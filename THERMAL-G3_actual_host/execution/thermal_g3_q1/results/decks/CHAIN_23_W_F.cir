* THERMAL-G3-Q1-R CHAIN_23_W_F
.include <MODEL_LIB>
vsrc vsrc 0 PWL(0 0 0.02 3.0)
rint vsrc vdd 10
cdec vdd 0 1e-05
rvrestt vdd vrest 2000
rvrestb vrest 0 1000
cvrestc vrest 0 1e-05
rvthet vdd vthe 2000
rvtheb vthe 0 1800
cvthec vthe 0 1e-05
rvthrt vdd vthr 2400
rvthrb vthr 0 1500
cvthrc vthr 0 1e-05
rvmidt vdd vmid 2000
rvmidb vmid 0 2000
cvmidc vmid 0 1e-05
rporr vdd porc 2.2e+06
cporc porc 0 1e-06
rporra porc porx 1e+06
rporrf por_ok porx 4e+06
npori1p por_hold porx vdd vsrc pch W=2.4e-06 L=5e-07
npori1n por_hold porx 0 0 nch W=1.2e-06 L=5e-07
npori2p por_ok por_hold vdd vsrc pch W=2.4e-06 L=5e-07
npori2n por_ok por_hold 0 0 nch W=1.2e-06 L=5e-07
riref vdd iref_n 2.2e+06
nirefd iref_n iref_n 0 0 nch W=4e-06 L=4e-06
ristep vdd istep_n 5.6e+07
nistepd istep_n istep_n 0 0 nch W=4e-06 L=4e-06
nirefm irefp_n iref_n 0 0 nch W=4e-06 L=4e-06
nirefpd irefp_n irefp_n vdd vsrc pch W=4e-06 L=4e-06
rilim vdd ilim_n 1.85e+06
nilimd ilim_n ilim_n 0 0 nch W=4e-06 L=4e-06
nilimm ilimp_n ilim_n 0 0 nch W=4e-06 L=4e-06
nilimpd ilimp_n ilimp_n vdd vsrc pch W=4e-06 L=4e-06
bs1_te s1_te 0 V=18.5
vqes1 s1_te s1_tea DC 0
rs1_ge s1_tea s1_tp 500
cs1_cp s1_tp 0 0.01
rs1_gm s1_tp s1_tn 1000
cs1_cn s1_tn 0 0.0001
bs1_ntc vdd s1_s I=V(vdd,s1_s)/(100000*exp(4250*(1/(298.15+V(s1_tn))-1/298.15)))
bs1_heat 0 s1_th I=V(vdd,s1_s)*V(vdd,s1_s)/(100000*exp(4250*(1/(298.15+V(s1_tn))-1/298.15)))
vqhs1 s1_th s1_tn DC 0
rs1_rs s1_s 0 100000
rs1_ravg s1_s s1_m 2e+06
cs1_cavg s1_m 0 1e-06
ns1_mpor s1_m por_ok s1_s vsrc pch W=4e-06 L=1e-06
rs1_ab vdd s1_anb 750000
ns1_amb s1_anb s1_anb 0 0 nch W=4e-06 L=4e-06
ns1_amt s1_atl s1_anb 0 0 nch W=4e-06 L=4e-06
ns1_am1 s1_da s1_s s1_atl 0 nch W=1e-06 L=4e-06
ns1_am2 s1_db s1_m s1_atl 0 nch W=1e-06 L=4e-06
rs1_ara vdd s1_da 680000
rs1_arb vdd s1_db 680000
ns1_tt s1_tl ilim_n 0 0 nch W=4e-06 L=4e-06
ns1_ta s1_ya s1_db s1_tl 0 nch W=1e-05 L=2e-06
ns1_tb s1_yb s1_da s1_tl 0 nch W=1e-05 L=2e-06
ns1_la s1_ya s1_ya vdd vsrc pch W=4e-06 L=4e-06
ns1_lb s1_yb s1_yb vdd vsrc pch W=4e-06 L=4e-06
ns1_ca s1_za s1_ya vdd vsrc pch W=4e-06 L=4e-06
ns1_na s1_za s1_za 0 0 nch W=4e-06 L=4e-06
ns1_cb s1_zb s1_yb vdd vsrc pch W=4e-06 L=4e-06
ns1_nb s1_zb s1_zb 0 0 nch W=4e-06 L=4e-06
bs2_te s2_te 0 V=(18.5+3*(1/(1+exp(-(time-10.6)/0.05))-1/(1+exp(-(time-17.6)/0.05))))
vqes2 s2_te s2_tea DC 0
rs2_ge s2_tea s2_tp 500
cs2_cp s2_tp 0 0.01
rs2_gm s2_tp s2_tn 1000
cs2_cn s2_tn 0 0.0001
bs2_ntc vdd s2_s I=V(vdd,s2_s)/(100000*exp(4250*(1/(298.15+V(s2_tn))-1/298.15)))
bs2_heat 0 s2_th I=V(vdd,s2_s)*V(vdd,s2_s)/(100000*exp(4250*(1/(298.15+V(s2_tn))-1/298.15)))
vqhs2 s2_th s2_tn DC 0
rs2_rs s2_s 0 100000
rs2_ravg s2_s s2_m 2e+06
cs2_cavg s2_m 0 1e-06
ns2_mpor s2_m por_ok s2_s vsrc pch W=4e-06 L=1e-06
rs2_ab vdd s2_anb 750000
ns2_amb s2_anb s2_anb 0 0 nch W=4e-06 L=4e-06
ns2_amt s2_atl s2_anb 0 0 nch W=4e-06 L=4e-06
ns2_am1 s2_da s2_s s2_atl 0 nch W=1e-06 L=4e-06
ns2_am2 s2_db s2_m s2_atl 0 nch W=1e-06 L=4e-06
rs2_ara vdd s2_da 680000
rs2_arb vdd s2_db 680000
ns2_tt s2_tl ilim_n 0 0 nch W=4e-06 L=4e-06
ns2_ta s2_ya s2_db s2_tl 0 nch W=1e-05 L=2e-06
ns2_tb s2_yb s2_da s2_tl 0 nch W=1e-05 L=2e-06
ns2_la s2_ya s2_ya vdd vsrc pch W=4e-06 L=4e-06
ns2_lb s2_yb s2_yb vdd vsrc pch W=4e-06 L=4e-06
ns2_ca s2_za s2_ya vdd vsrc pch W=4e-06 L=4e-06
ns2_na s2_za s2_za 0 0 nch W=4e-06 L=4e-06
ns2_cb s2_zb s2_yb vdd vsrc pch W=4e-06 L=4e-06
ns2_nb s2_zb s2_zb 0 0 nch W=4e-06 L=4e-06
bs3_te s3_te 0 V=(18.5+3*(1/(1+exp(-(time-12.1)/0.05))-1/(1+exp(-(time-19.1)/0.05))))
vqes3 s3_te s3_tea DC 0
rs3_ge s3_tea s3_tp 500
cs3_cp s3_tp 0 0.01
rs3_gm s3_tp s3_tn 1000
cs3_cn s3_tn 0 0.0001
bs3_ntc vdd s3_s I=V(vdd,s3_s)/(100000*exp(4250*(1/(298.15+V(s3_tn))-1/298.15)))
bs3_heat 0 s3_th I=V(vdd,s3_s)*V(vdd,s3_s)/(100000*exp(4250*(1/(298.15+V(s3_tn))-1/298.15)))
vqhs3 s3_th s3_tn DC 0
rs3_rs s3_s 0 100000
rs3_ravg s3_s s3_m 2e+06
cs3_cavg s3_m 0 1e-06
ns3_mpor s3_m por_ok s3_s vsrc pch W=4e-06 L=1e-06
rs3_ab vdd s3_anb 750000
ns3_amb s3_anb s3_anb 0 0 nch W=4e-06 L=4e-06
ns3_amt s3_atl s3_anb 0 0 nch W=4e-06 L=4e-06
ns3_am1 s3_da s3_s s3_atl 0 nch W=1e-06 L=4e-06
ns3_am2 s3_db s3_m s3_atl 0 nch W=1e-06 L=4e-06
rs3_ara vdd s3_da 680000
rs3_arb vdd s3_db 680000
ns3_tt s3_tl ilim_n 0 0 nch W=4e-06 L=4e-06
ns3_ta s3_ya s3_db s3_tl 0 nch W=1e-05 L=2e-06
ns3_tb s3_yb s3_da s3_tl 0 nch W=1e-05 L=2e-06
ns3_la s3_ya s3_ya vdd vsrc pch W=4e-06 L=4e-06
ns3_lb s3_yb s3_yb vdd vsrc pch W=4e-06 L=4e-06
ns3_ca s3_za s3_ya vdd vsrc pch W=4e-06 L=4e-06
ns3_na s3_za s3_za 0 0 nch W=4e-06 L=4e-06
ns3_cb s3_zb s3_yb vdd vsrc pch W=4e-06 L=4e-06
ns3_nb s3_zb s3_zb 0 0 nch W=4e-06 L=4e-06
bs4_te s4_te 0 V=18.5
vqes4 s4_te s4_tea DC 0
rs4_ge s4_tea s4_tp 500
cs4_cp s4_tp 0 0.01
rs4_gm s4_tp s4_tn 1000
cs4_cn s4_tn 0 0.0001
bs4_ntc vdd s4_s I=V(vdd,s4_s)/(100000*exp(4250*(1/(298.15+V(s4_tn))-1/298.15)))
bs4_heat 0 s4_th I=V(vdd,s4_s)*V(vdd,s4_s)/(100000*exp(4250*(1/(298.15+V(s4_tn))-1/298.15)))
vqhs4 s4_th s4_tn DC 0
rs4_rs s4_s 0 100000
rs4_ravg s4_s s4_m 2e+06
cs4_cavg s4_m 0 1e-06
ns4_mpor s4_m por_ok s4_s vsrc pch W=4e-06 L=1e-06
rs4_ab vdd s4_anb 750000
ns4_amb s4_anb s4_anb 0 0 nch W=4e-06 L=4e-06
ns4_amt s4_atl s4_anb 0 0 nch W=4e-06 L=4e-06
ns4_am1 s4_da s4_s s4_atl 0 nch W=1e-06 L=4e-06
ns4_am2 s4_db s4_m s4_atl 0 nch W=1e-06 L=4e-06
rs4_ara vdd s4_da 680000
rs4_arb vdd s4_db 680000
ns4_tt s4_tl ilim_n 0 0 nch W=4e-06 L=4e-06
ns4_ta s4_ya s4_db s4_tl 0 nch W=1e-05 L=2e-06
ns4_tb s4_yb s4_da s4_tl 0 nch W=1e-05 L=2e-06
ns4_la s4_ya s4_ya vdd vsrc pch W=4e-06 L=4e-06
ns4_lb s4_yb s4_yb vdd vsrc pch W=4e-06 L=4e-06
ns4_ca s4_za s4_ya vdd vsrc pch W=4e-06 L=4e-06
ns4_na s4_za s4_za 0 0 nch W=4e-06 L=4e-06
ns4_cb s4_zb s4_yb vdd vsrc pch W=4e-06 L=4e-06
ns4_nb s4_zb s4_zb 0 0 nch W=4e-06 L=4e-06
cgw2_e1_cm gw2_e1_vm 0 1e-07
rgw2_e1_rm gw2_e1_vm vrest 1e+06
ngw2_e1_bias0 gw2_e1_vm istep_n 0 0 nch W=4e-06 L=4e-06
rgw2_e1_kb vdd gw2_e1_knb 1e+06
ngw2_e1_kmb gw2_e1_knb gw2_e1_knb 0 0 nch W=4e-06 L=4e-06
ngw2_e1_kmt gw2_e1_ktail gw2_e1_knb 0 0 nch W=4e-06 L=4e-06
ngw2_e1_km1 gw2_e1_kd1 gw2_e1_vm gw2_e1_ktail 0 nch W=4e-06 L=4e-06
ngw2_e1_km2 gw2_e1_ko1 gw2_e1_h gw2_e1_ktail 0 nch W=4e-06 L=4e-06
ngw2_e1_km3 gw2_e1_kd1 gw2_e1_kd1 vdd vsrc pch W=4e-06 L=4e-06
ngw2_e1_km4 gw2_e1_ko1 gw2_e1_kd1 vdd vsrc pch W=4e-06 L=4e-06
ngw2_e1_ki1p gw2_e1_qb gw2_e1_ko1 vdd vsrc pch W=2.4e-06 L=5e-07
ngw2_e1_ki1n gw2_e1_qb gw2_e1_ko1 0 0 nch W=1.2e-06 L=5e-07
ngw2_e1_ki2p gw2_e1_q gw2_e1_qb vdd vsrc pch W=2.4e-06 L=5e-07
ngw2_e1_ki2n gw2_e1_q gw2_e1_qb 0 0 nch W=1.2e-06 L=5e-07
rgw2_e1_hra gw2_e1_h vthe 1e+06
rgw2_e1_hrf gw2_e1_h gw2_e1_qb 1.9e+07
cgw2_e1_hc gw2_e1_h 0 2.1e-09
ngw2_e1_dis gw2_e1_vm gw2_e1_q gw2_e1_vmd 0 nch W=4e-06 L=1e-06
rgw2_e1_rdis gw2_e1_vmd vrest 220000
ngw2_e1_rp gw2_e1_rt gw2_e1_qb vdd vsrc pch W=2e-06 L=1e-06
rgw2_e1_rrc gw2_e1_rt gw2_e1_rec 10000
cgw2_e1_rc gw2_e1_rec 0 1e-07
rgw2_e1_rr gw2_e1_rec 0 8.2e+06
ngw2_e1_sh1 gw2_e1_vm gw2_e1_rec gw2_e1_vms 0 nch W=2e-06 L=1e-06
ngw2_e1_sh2 gw2_e1_vms gw2_e1_qb vrest 0 nch W=2e-06 L=1e-06
ngw2_e1_porh gw2_e1_h por_hold vthe 0 nch W=2e-06 L=1e-06
ngw2_e1_porm gw2_e1_vm por_hold vrest 0 nch W=2e-06 L=1e-06
ngw2_e1_ip gw2_e1_vm s2_ya vdd vsrc pch W=4e-06 L=4e-06
ngw2_e1_in gw2_e1_vm s2_zb 0 0 nch W=4e-06 L=4e-06
ngw2_b1_sw gw2_b1_t gw2_e1_qb vdd vsrc pch W=2e-06 L=1e-06
rgw2_b1_rc gw2_b1_t gw2_b1 10000
cgw2_b1_c gw2_b1 0 1e-07
rgw2_b1_rl gw2_b1 0 2.2e+07
ngw2_b1_sh1p gw2_b1_n gw2_b1 vdd vsrc pch W=2.4e-06 L=5e-07
ngw2_b1_sh1n gw2_b1_n gw2_b1 0 0 nch W=1.2e-06 L=5e-07
ngw2_b1_sh2p gw2_b1_q gw2_b1_n vdd vsrc pch W=2.4e-06 L=5e-07
ngw2_b1_sh2n gw2_b1_q gw2_b1_n 0 0 nch W=1.2e-06 L=5e-07
cgw2_e2_cm gw2_e2_vm 0 1e-07
rgw2_e2_rm gw2_e2_vm vrest 1e+06
ngw2_e2_bias0 gw2_e2_vm istep_n 0 0 nch W=4e-06 L=4e-06
ngw2_e2_bias1 gw2_e2_vm istep_n 0 0 nch W=4e-06 L=4e-06
rgw2_e2_kb vdd gw2_e2_knb 1e+06
ngw2_e2_kmb gw2_e2_knb gw2_e2_knb 0 0 nch W=4e-06 L=4e-06
ngw2_e2_kmt gw2_e2_ktail gw2_e2_knb 0 0 nch W=4e-06 L=4e-06
ngw2_e2_km1 gw2_e2_kd1 gw2_e2_vm gw2_e2_ktail 0 nch W=4e-06 L=4e-06
ngw2_e2_km2 gw2_e2_ko1 gw2_e2_h gw2_e2_ktail 0 nch W=4e-06 L=4e-06
ngw2_e2_km3 gw2_e2_kd1 gw2_e2_kd1 vdd vsrc pch W=4e-06 L=4e-06
ngw2_e2_km4 gw2_e2_ko1 gw2_e2_kd1 vdd vsrc pch W=4e-06 L=4e-06
ngw2_e2_ki1p gw2_e2_qb gw2_e2_ko1 vdd vsrc pch W=2.4e-06 L=5e-07
ngw2_e2_ki1n gw2_e2_qb gw2_e2_ko1 0 0 nch W=1.2e-06 L=5e-07
ngw2_e2_ki2p gw2_e2_q gw2_e2_qb vdd vsrc pch W=2.4e-06 L=5e-07
ngw2_e2_ki2n gw2_e2_q gw2_e2_qb 0 0 nch W=1.2e-06 L=5e-07
rgw2_e2_hra gw2_e2_h vthe 1e+06
rgw2_e2_hrf gw2_e2_h gw2_e2_qb 1.9e+07
cgw2_e2_hc gw2_e2_h 0 2.1e-09
ngw2_e2_dis gw2_e2_vm gw2_e2_q gw2_e2_vmd 0 nch W=4e-06 L=1e-06
rgw2_e2_rdis gw2_e2_vmd vrest 220000
ngw2_e2_rp gw2_e2_rt gw2_e2_qb vdd vsrc pch W=2e-06 L=1e-06
rgw2_e2_rrc gw2_e2_rt gw2_e2_rec 10000
cgw2_e2_rc gw2_e2_rec 0 1e-07
rgw2_e2_rr gw2_e2_rec 0 8.2e+06
ngw2_e2_sh1 gw2_e2_vm gw2_e2_rec gw2_e2_vms 0 nch W=2e-06 L=1e-06
ngw2_e2_sh2 gw2_e2_vms gw2_e2_qb vrest 0 nch W=2e-06 L=1e-06
ngw2_e2_porh gw2_e2_h por_hold vthe 0 nch W=2e-06 L=1e-06
ngw2_e2_porm gw2_e2_vm por_hold vrest 0 nch W=2e-06 L=1e-06
ngw2_e2_ip gw2_e2_vm s2_ya vdd vsrc pch W=4e-06 L=4e-06
ngw2_e2_in gw2_e2_vm s2_zb 0 0 nch W=4e-06 L=4e-06
ngw2_b2_sw gw2_b2_t gw2_e2_qb vdd vsrc pch W=2e-06 L=1e-06
rgw2_b2_rc gw2_b2_t gw2_b2 10000
cgw2_b2_c gw2_b2 0 1e-07
rgw2_b2_rl gw2_b2 0 2.2e+07
ngw2_b2_sh1p gw2_b2_n gw2_b2 vdd vsrc pch W=2.4e-06 L=5e-07
ngw2_b2_sh1n gw2_b2_n gw2_b2 0 0 nch W=1.2e-06 L=5e-07
ngw2_b2_sh2p gw2_b2_q gw2_b2_n vdd vsrc pch W=2.4e-06 L=5e-07
ngw2_b2_sh2n gw2_b2_q gw2_b2_n 0 0 nch W=1.2e-06 L=5e-07
cgw2_e3_cm gw2_e3_vm 0 1e-07
rgw2_e3_rm gw2_e3_vm vrest 1e+06
ngw2_e3_bias0 gw2_e3_vm istep_n 0 0 nch W=4e-06 L=4e-06
ngw2_e3_bias1 gw2_e3_vm istep_n 0 0 nch W=4e-06 L=4e-06
ngw2_e3_bias2 gw2_e3_vm istep_n 0 0 nch W=4e-06 L=4e-06
rgw2_e3_kb vdd gw2_e3_knb 1e+06
ngw2_e3_kmb gw2_e3_knb gw2_e3_knb 0 0 nch W=4e-06 L=4e-06
ngw2_e3_kmt gw2_e3_ktail gw2_e3_knb 0 0 nch W=4e-06 L=4e-06
ngw2_e3_km1 gw2_e3_kd1 gw2_e3_vm gw2_e3_ktail 0 nch W=4e-06 L=4e-06
ngw2_e3_km2 gw2_e3_ko1 gw2_e3_h gw2_e3_ktail 0 nch W=4e-06 L=4e-06
ngw2_e3_km3 gw2_e3_kd1 gw2_e3_kd1 vdd vsrc pch W=4e-06 L=4e-06
ngw2_e3_km4 gw2_e3_ko1 gw2_e3_kd1 vdd vsrc pch W=4e-06 L=4e-06
ngw2_e3_ki1p gw2_e3_qb gw2_e3_ko1 vdd vsrc pch W=2.4e-06 L=5e-07
ngw2_e3_ki1n gw2_e3_qb gw2_e3_ko1 0 0 nch W=1.2e-06 L=5e-07
ngw2_e3_ki2p gw2_e3_q gw2_e3_qb vdd vsrc pch W=2.4e-06 L=5e-07
ngw2_e3_ki2n gw2_e3_q gw2_e3_qb 0 0 nch W=1.2e-06 L=5e-07
rgw2_e3_hra gw2_e3_h vthe 1e+06
rgw2_e3_hrf gw2_e3_h gw2_e3_qb 1.9e+07
cgw2_e3_hc gw2_e3_h 0 2.1e-09
ngw2_e3_dis gw2_e3_vm gw2_e3_q gw2_e3_vmd 0 nch W=4e-06 L=1e-06
rgw2_e3_rdis gw2_e3_vmd vrest 220000
ngw2_e3_rp gw2_e3_rt gw2_e3_qb vdd vsrc pch W=2e-06 L=1e-06
rgw2_e3_rrc gw2_e3_rt gw2_e3_rec 10000
cgw2_e3_rc gw2_e3_rec 0 1e-07
rgw2_e3_rr gw2_e3_rec 0 8.2e+06
ngw2_e3_sh1 gw2_e3_vm gw2_e3_rec gw2_e3_vms 0 nch W=2e-06 L=1e-06
ngw2_e3_sh2 gw2_e3_vms gw2_e3_qb vrest 0 nch W=2e-06 L=1e-06
ngw2_e3_porh gw2_e3_h por_hold vthe 0 nch W=2e-06 L=1e-06
ngw2_e3_porm gw2_e3_vm por_hold vrest 0 nch W=2e-06 L=1e-06
ngw2_e3_ip gw2_e3_vm s2_ya vdd vsrc pch W=4e-06 L=4e-06
ngw2_e3_in gw2_e3_vm s2_zb 0 0 nch W=4e-06 L=4e-06
ngw2_b3_sw gw2_b3_t gw2_e3_qb vdd vsrc pch W=2e-06 L=1e-06
rgw2_b3_rc gw2_b3_t gw2_b3 10000
cgw2_b3_c gw2_b3 0 1e-07
rgw2_b3_rl gw2_b3 0 2.2e+07
ngw2_b3_sh1p gw2_b3_n gw2_b3 vdd vsrc pch W=2.4e-06 L=5e-07
ngw2_b3_sh1n gw2_b3_n gw2_b3 0 0 nch W=1.2e-06 L=5e-07
ngw2_b3_sh2p gw2_b3_q gw2_b3_n vdd vsrc pch W=2.4e-06 L=5e-07
ngw2_b3_sh2n gw2_b3_q gw2_b3_n 0 0 nch W=1.2e-06 L=5e-07
cgw2_e4_cm gw2_e4_vm 0 1e-07
rgw2_e4_rm gw2_e4_vm vrest 1e+06
ngw2_e4_bias0 gw2_e4_vm istep_n 0 0 nch W=4e-06 L=4e-06
ngw2_e4_bias1 gw2_e4_vm istep_n 0 0 nch W=4e-06 L=4e-06
ngw2_e4_bias2 gw2_e4_vm istep_n 0 0 nch W=4e-06 L=4e-06
ngw2_e4_bias3 gw2_e4_vm istep_n 0 0 nch W=4e-06 L=4e-06
rgw2_e4_kb vdd gw2_e4_knb 1e+06
ngw2_e4_kmb gw2_e4_knb gw2_e4_knb 0 0 nch W=4e-06 L=4e-06
ngw2_e4_kmt gw2_e4_ktail gw2_e4_knb 0 0 nch W=4e-06 L=4e-06
ngw2_e4_km1 gw2_e4_kd1 gw2_e4_vm gw2_e4_ktail 0 nch W=4e-06 L=4e-06
ngw2_e4_km2 gw2_e4_ko1 gw2_e4_h gw2_e4_ktail 0 nch W=4e-06 L=4e-06
ngw2_e4_km3 gw2_e4_kd1 gw2_e4_kd1 vdd vsrc pch W=4e-06 L=4e-06
ngw2_e4_km4 gw2_e4_ko1 gw2_e4_kd1 vdd vsrc pch W=4e-06 L=4e-06
ngw2_e4_ki1p gw2_e4_qb gw2_e4_ko1 vdd vsrc pch W=2.4e-06 L=5e-07
ngw2_e4_ki1n gw2_e4_qb gw2_e4_ko1 0 0 nch W=1.2e-06 L=5e-07
ngw2_e4_ki2p gw2_e4_q gw2_e4_qb vdd vsrc pch W=2.4e-06 L=5e-07
ngw2_e4_ki2n gw2_e4_q gw2_e4_qb 0 0 nch W=1.2e-06 L=5e-07
rgw2_e4_hra gw2_e4_h vthe 1e+06
rgw2_e4_hrf gw2_e4_h gw2_e4_qb 1.9e+07
cgw2_e4_hc gw2_e4_h 0 2.1e-09
ngw2_e4_dis gw2_e4_vm gw2_e4_q gw2_e4_vmd 0 nch W=4e-06 L=1e-06
rgw2_e4_rdis gw2_e4_vmd vrest 220000
ngw2_e4_rp gw2_e4_rt gw2_e4_qb vdd vsrc pch W=2e-06 L=1e-06
rgw2_e4_rrc gw2_e4_rt gw2_e4_rec 10000
cgw2_e4_rc gw2_e4_rec 0 1e-07
rgw2_e4_rr gw2_e4_rec 0 8.2e+06
ngw2_e4_sh1 gw2_e4_vm gw2_e4_rec gw2_e4_vms 0 nch W=2e-06 L=1e-06
ngw2_e4_sh2 gw2_e4_vms gw2_e4_qb vrest 0 nch W=2e-06 L=1e-06
ngw2_e4_porh gw2_e4_h por_hold vthe 0 nch W=2e-06 L=1e-06
ngw2_e4_porm gw2_e4_vm por_hold vrest 0 nch W=2e-06 L=1e-06
ngw2_e4_ip gw2_e4_vm s2_ya vdd vsrc pch W=4e-06 L=4e-06
ngw2_e4_in gw2_e4_vm s2_zb 0 0 nch W=4e-06 L=4e-06
ngw2_b4_sw gw2_b4_t gw2_e4_qb vdd vsrc pch W=2e-06 L=1e-06
rgw2_b4_rc gw2_b4_t gw2_b4 10000
cgw2_b4_c gw2_b4 0 1e-07
rgw2_b4_rl gw2_b4 0 2.2e+07
ngw2_b4_sh1p gw2_b4_n gw2_b4 vdd vsrc pch W=2.4e-06 L=5e-07
ngw2_b4_sh1n gw2_b4_n gw2_b4 0 0 nch W=1.2e-06 L=5e-07
ngw2_b4_sh2p gw2_b4_q gw2_b4_n vdd vsrc pch W=2.4e-06 L=5e-07
ngw2_b4_sh2n gw2_b4_q gw2_b4_n 0 0 nch W=1.2e-06 L=5e-07
cgw2_e5_cm gw2_e5_vm 0 1e-07
rgw2_e5_rm gw2_e5_vm vrest 1e+06
ngw2_e5_bias0 gw2_e5_vm istep_n 0 0 nch W=4e-06 L=4e-06
ngw2_e5_bias1 gw2_e5_vm istep_n 0 0 nch W=4e-06 L=4e-06
ngw2_e5_bias2 gw2_e5_vm istep_n 0 0 nch W=4e-06 L=4e-06
ngw2_e5_bias3 gw2_e5_vm istep_n 0 0 nch W=4e-06 L=4e-06
ngw2_e5_bias4 gw2_e5_vm istep_n 0 0 nch W=4e-06 L=4e-06
rgw2_e5_kb vdd gw2_e5_knb 1e+06
ngw2_e5_kmb gw2_e5_knb gw2_e5_knb 0 0 nch W=4e-06 L=4e-06
ngw2_e5_kmt gw2_e5_ktail gw2_e5_knb 0 0 nch W=4e-06 L=4e-06
ngw2_e5_km1 gw2_e5_kd1 gw2_e5_vm gw2_e5_ktail 0 nch W=4e-06 L=4e-06
ngw2_e5_km2 gw2_e5_ko1 gw2_e5_h gw2_e5_ktail 0 nch W=4e-06 L=4e-06
ngw2_e5_km3 gw2_e5_kd1 gw2_e5_kd1 vdd vsrc pch W=4e-06 L=4e-06
ngw2_e5_km4 gw2_e5_ko1 gw2_e5_kd1 vdd vsrc pch W=4e-06 L=4e-06
ngw2_e5_ki1p gw2_e5_qb gw2_e5_ko1 vdd vsrc pch W=2.4e-06 L=5e-07
ngw2_e5_ki1n gw2_e5_qb gw2_e5_ko1 0 0 nch W=1.2e-06 L=5e-07
ngw2_e5_ki2p gw2_e5_q gw2_e5_qb vdd vsrc pch W=2.4e-06 L=5e-07
ngw2_e5_ki2n gw2_e5_q gw2_e5_qb 0 0 nch W=1.2e-06 L=5e-07
rgw2_e5_hra gw2_e5_h vthe 1e+06
rgw2_e5_hrf gw2_e5_h gw2_e5_qb 1.9e+07
cgw2_e5_hc gw2_e5_h 0 2.1e-09
ngw2_e5_dis gw2_e5_vm gw2_e5_q gw2_e5_vmd 0 nch W=4e-06 L=1e-06
rgw2_e5_rdis gw2_e5_vmd vrest 220000
ngw2_e5_rp gw2_e5_rt gw2_e5_qb vdd vsrc pch W=2e-06 L=1e-06
rgw2_e5_rrc gw2_e5_rt gw2_e5_rec 10000
cgw2_e5_rc gw2_e5_rec 0 1e-07
rgw2_e5_rr gw2_e5_rec 0 8.2e+06
ngw2_e5_sh1 gw2_e5_vm gw2_e5_rec gw2_e5_vms 0 nch W=2e-06 L=1e-06
ngw2_e5_sh2 gw2_e5_vms gw2_e5_qb vrest 0 nch W=2e-06 L=1e-06
ngw2_e5_porh gw2_e5_h por_hold vthe 0 nch W=2e-06 L=1e-06
ngw2_e5_porm gw2_e5_vm por_hold vrest 0 nch W=2e-06 L=1e-06
ngw2_e5_ip gw2_e5_vm s2_ya vdd vsrc pch W=4e-06 L=4e-06
ngw2_e5_in gw2_e5_vm s2_zb 0 0 nch W=4e-06 L=4e-06
ngw2_b5_sw gw2_b5_t gw2_e5_qb vdd vsrc pch W=2e-06 L=1e-06
rgw2_b5_rc gw2_b5_t gw2_b5 10000
cgw2_b5_c gw2_b5 0 1e-07
rgw2_b5_rl gw2_b5 0 2.2e+07
ngw2_b5_sh1p gw2_b5_n gw2_b5 vdd vsrc pch W=2.4e-06 L=5e-07
ngw2_b5_sh1n gw2_b5_n gw2_b5 0 0 nch W=1.2e-06 L=5e-07
ngw2_b5_sh2p gw2_b5_q gw2_b5_n vdd vsrc pch W=2.4e-06 L=5e-07
ngw2_b5_sh2n gw2_b5_q gw2_b5_n 0 0 nch W=1.2e-06 L=5e-07
cgw2_e6_cm gw2_e6_vm 0 1e-07
rgw2_e6_rm gw2_e6_vm vrest 1e+06
ngw2_e6_bias0 gw2_e6_vm istep_n 0 0 nch W=4e-06 L=4e-06
ngw2_e6_bias1 gw2_e6_vm istep_n 0 0 nch W=4e-06 L=4e-06
ngw2_e6_bias2 gw2_e6_vm istep_n 0 0 nch W=4e-06 L=4e-06
ngw2_e6_bias3 gw2_e6_vm istep_n 0 0 nch W=4e-06 L=4e-06
ngw2_e6_bias4 gw2_e6_vm istep_n 0 0 nch W=4e-06 L=4e-06
ngw2_e6_bias5 gw2_e6_vm istep_n 0 0 nch W=4e-06 L=4e-06
rgw2_e6_kb vdd gw2_e6_knb 1e+06
ngw2_e6_kmb gw2_e6_knb gw2_e6_knb 0 0 nch W=4e-06 L=4e-06
ngw2_e6_kmt gw2_e6_ktail gw2_e6_knb 0 0 nch W=4e-06 L=4e-06
ngw2_e6_km1 gw2_e6_kd1 gw2_e6_vm gw2_e6_ktail 0 nch W=4e-06 L=4e-06
ngw2_e6_km2 gw2_e6_ko1 gw2_e6_h gw2_e6_ktail 0 nch W=4e-06 L=4e-06
ngw2_e6_km3 gw2_e6_kd1 gw2_e6_kd1 vdd vsrc pch W=4e-06 L=4e-06
ngw2_e6_km4 gw2_e6_ko1 gw2_e6_kd1 vdd vsrc pch W=4e-06 L=4e-06
ngw2_e6_ki1p gw2_e6_qb gw2_e6_ko1 vdd vsrc pch W=2.4e-06 L=5e-07
ngw2_e6_ki1n gw2_e6_qb gw2_e6_ko1 0 0 nch W=1.2e-06 L=5e-07
ngw2_e6_ki2p gw2_e6_q gw2_e6_qb vdd vsrc pch W=2.4e-06 L=5e-07
ngw2_e6_ki2n gw2_e6_q gw2_e6_qb 0 0 nch W=1.2e-06 L=5e-07
rgw2_e6_hra gw2_e6_h vthe 1e+06
rgw2_e6_hrf gw2_e6_h gw2_e6_qb 1.9e+07
cgw2_e6_hc gw2_e6_h 0 2.1e-09
ngw2_e6_dis gw2_e6_vm gw2_e6_q gw2_e6_vmd 0 nch W=4e-06 L=1e-06
rgw2_e6_rdis gw2_e6_vmd vrest 220000
ngw2_e6_rp gw2_e6_rt gw2_e6_qb vdd vsrc pch W=2e-06 L=1e-06
rgw2_e6_rrc gw2_e6_rt gw2_e6_rec 10000
cgw2_e6_rc gw2_e6_rec 0 1e-07
rgw2_e6_rr gw2_e6_rec 0 8.2e+06
ngw2_e6_sh1 gw2_e6_vm gw2_e6_rec gw2_e6_vms 0 nch W=2e-06 L=1e-06
ngw2_e6_sh2 gw2_e6_vms gw2_e6_qb vrest 0 nch W=2e-06 L=1e-06
ngw2_e6_porh gw2_e6_h por_hold vthe 0 nch W=2e-06 L=1e-06
ngw2_e6_porm gw2_e6_vm por_hold vrest 0 nch W=2e-06 L=1e-06
ngw2_e6_ip gw2_e6_vm s2_ya vdd vsrc pch W=4e-06 L=4e-06
ngw2_e6_in gw2_e6_vm s2_zb 0 0 nch W=4e-06 L=4e-06
ngw2_b6_sw gw2_b6_t gw2_e6_qb vdd vsrc pch W=2e-06 L=1e-06
rgw2_b6_rc gw2_b6_t gw2_b6 10000
cgw2_b6_c gw2_b6 0 1e-07
rgw2_b6_rl gw2_b6 0 2.2e+07
ngw2_b6_sh1p gw2_b6_n gw2_b6 vdd vsrc pch W=2.4e-06 L=5e-07
ngw2_b6_sh1n gw2_b6_n gw2_b6 0 0 nch W=1.2e-06 L=5e-07
ngw2_b6_sh2p gw2_b6_q gw2_b6_n vdd vsrc pch W=2.4e-06 L=5e-07
ngw2_b6_sh2n gw2_b6_q gw2_b6_n 0 0 nch W=1.2e-06 L=5e-07
cgw2_e7_cm gw2_e7_vm 0 1e-07
rgw2_e7_rm gw2_e7_vm vrest 1e+06
ngw2_e7_bias0 gw2_e7_vm istep_n 0 0 nch W=4e-06 L=4e-06
ngw2_e7_bias1 gw2_e7_vm istep_n 0 0 nch W=4e-06 L=4e-06
ngw2_e7_bias2 gw2_e7_vm istep_n 0 0 nch W=4e-06 L=4e-06
ngw2_e7_bias3 gw2_e7_vm istep_n 0 0 nch W=4e-06 L=4e-06
ngw2_e7_bias4 gw2_e7_vm istep_n 0 0 nch W=4e-06 L=4e-06
ngw2_e7_bias5 gw2_e7_vm istep_n 0 0 nch W=4e-06 L=4e-06
ngw2_e7_bias6 gw2_e7_vm istep_n 0 0 nch W=4e-06 L=4e-06
rgw2_e7_kb vdd gw2_e7_knb 1e+06
ngw2_e7_kmb gw2_e7_knb gw2_e7_knb 0 0 nch W=4e-06 L=4e-06
ngw2_e7_kmt gw2_e7_ktail gw2_e7_knb 0 0 nch W=4e-06 L=4e-06
ngw2_e7_km1 gw2_e7_kd1 gw2_e7_vm gw2_e7_ktail 0 nch W=4e-06 L=4e-06
ngw2_e7_km2 gw2_e7_ko1 gw2_e7_h gw2_e7_ktail 0 nch W=4e-06 L=4e-06
ngw2_e7_km3 gw2_e7_kd1 gw2_e7_kd1 vdd vsrc pch W=4e-06 L=4e-06
ngw2_e7_km4 gw2_e7_ko1 gw2_e7_kd1 vdd vsrc pch W=4e-06 L=4e-06
ngw2_e7_ki1p gw2_e7_qb gw2_e7_ko1 vdd vsrc pch W=2.4e-06 L=5e-07
ngw2_e7_ki1n gw2_e7_qb gw2_e7_ko1 0 0 nch W=1.2e-06 L=5e-07
ngw2_e7_ki2p gw2_e7_q gw2_e7_qb vdd vsrc pch W=2.4e-06 L=5e-07
ngw2_e7_ki2n gw2_e7_q gw2_e7_qb 0 0 nch W=1.2e-06 L=5e-07
rgw2_e7_hra gw2_e7_h vthe 1e+06
rgw2_e7_hrf gw2_e7_h gw2_e7_qb 1.9e+07
cgw2_e7_hc gw2_e7_h 0 2.1e-09
ngw2_e7_dis gw2_e7_vm gw2_e7_q gw2_e7_vmd 0 nch W=4e-06 L=1e-06
rgw2_e7_rdis gw2_e7_vmd vrest 220000
ngw2_e7_rp gw2_e7_rt gw2_e7_qb vdd vsrc pch W=2e-06 L=1e-06
rgw2_e7_rrc gw2_e7_rt gw2_e7_rec 10000
cgw2_e7_rc gw2_e7_rec 0 1e-07
rgw2_e7_rr gw2_e7_rec 0 8.2e+06
ngw2_e7_sh1 gw2_e7_vm gw2_e7_rec gw2_e7_vms 0 nch W=2e-06 L=1e-06
ngw2_e7_sh2 gw2_e7_vms gw2_e7_qb vrest 0 nch W=2e-06 L=1e-06
ngw2_e7_porh gw2_e7_h por_hold vthe 0 nch W=2e-06 L=1e-06
ngw2_e7_porm gw2_e7_vm por_hold vrest 0 nch W=2e-06 L=1e-06
ngw2_e7_ip gw2_e7_vm s2_ya vdd vsrc pch W=4e-06 L=4e-06
ngw2_e7_in gw2_e7_vm s2_zb 0 0 nch W=4e-06 L=4e-06
ngw2_b7_sw gw2_b7_t gw2_e7_qb vdd vsrc pch W=2e-06 L=1e-06
rgw2_b7_rc gw2_b7_t gw2_b7 10000
cgw2_b7_c gw2_b7 0 1e-07
rgw2_b7_rl gw2_b7 0 2.2e+07
ngw2_b7_sh1p gw2_b7_n gw2_b7 vdd vsrc pch W=2.4e-06 L=5e-07
ngw2_b7_sh1n gw2_b7_n gw2_b7 0 0 nch W=1.2e-06 L=5e-07
ngw2_b7_sh2p gw2_b7_q gw2_b7_n vdd vsrc pch W=2.4e-06 L=5e-07
ngw2_b7_sh2n gw2_b7_q gw2_b7_n 0 0 nch W=1.2e-06 L=5e-07
cgw2_e8_cm gw2_e8_vm 0 1e-07
rgw2_e8_rm gw2_e8_vm vrest 1e+06
ngw2_e8_bias0 gw2_e8_vm istep_n 0 0 nch W=4e-06 L=4e-06
ngw2_e8_bias1 gw2_e8_vm istep_n 0 0 nch W=4e-06 L=4e-06
ngw2_e8_bias2 gw2_e8_vm istep_n 0 0 nch W=4e-06 L=4e-06
ngw2_e8_bias3 gw2_e8_vm istep_n 0 0 nch W=4e-06 L=4e-06
ngw2_e8_bias4 gw2_e8_vm istep_n 0 0 nch W=4e-06 L=4e-06
ngw2_e8_bias5 gw2_e8_vm istep_n 0 0 nch W=4e-06 L=4e-06
ngw2_e8_bias6 gw2_e8_vm istep_n 0 0 nch W=4e-06 L=4e-06
ngw2_e8_bias7 gw2_e8_vm istep_n 0 0 nch W=4e-06 L=4e-06
rgw2_e8_kb vdd gw2_e8_knb 1e+06
ngw2_e8_kmb gw2_e8_knb gw2_e8_knb 0 0 nch W=4e-06 L=4e-06
ngw2_e8_kmt gw2_e8_ktail gw2_e8_knb 0 0 nch W=4e-06 L=4e-06
ngw2_e8_km1 gw2_e8_kd1 gw2_e8_vm gw2_e8_ktail 0 nch W=4e-06 L=4e-06
ngw2_e8_km2 gw2_e8_ko1 gw2_e8_h gw2_e8_ktail 0 nch W=4e-06 L=4e-06
ngw2_e8_km3 gw2_e8_kd1 gw2_e8_kd1 vdd vsrc pch W=4e-06 L=4e-06
ngw2_e8_km4 gw2_e8_ko1 gw2_e8_kd1 vdd vsrc pch W=4e-06 L=4e-06
ngw2_e8_ki1p gw2_e8_qb gw2_e8_ko1 vdd vsrc pch W=2.4e-06 L=5e-07
ngw2_e8_ki1n gw2_e8_qb gw2_e8_ko1 0 0 nch W=1.2e-06 L=5e-07
ngw2_e8_ki2p gw2_e8_q gw2_e8_qb vdd vsrc pch W=2.4e-06 L=5e-07
ngw2_e8_ki2n gw2_e8_q gw2_e8_qb 0 0 nch W=1.2e-06 L=5e-07
rgw2_e8_hra gw2_e8_h vthe 1e+06
rgw2_e8_hrf gw2_e8_h gw2_e8_qb 1.9e+07
cgw2_e8_hc gw2_e8_h 0 2.1e-09
ngw2_e8_dis gw2_e8_vm gw2_e8_q gw2_e8_vmd 0 nch W=4e-06 L=1e-06
rgw2_e8_rdis gw2_e8_vmd vrest 220000
ngw2_e8_rp gw2_e8_rt gw2_e8_qb vdd vsrc pch W=2e-06 L=1e-06
rgw2_e8_rrc gw2_e8_rt gw2_e8_rec 10000
cgw2_e8_rc gw2_e8_rec 0 1e-07
rgw2_e8_rr gw2_e8_rec 0 8.2e+06
ngw2_e8_sh1 gw2_e8_vm gw2_e8_rec gw2_e8_vms 0 nch W=2e-06 L=1e-06
ngw2_e8_sh2 gw2_e8_vms gw2_e8_qb vrest 0 nch W=2e-06 L=1e-06
ngw2_e8_porh gw2_e8_h por_hold vthe 0 nch W=2e-06 L=1e-06
ngw2_e8_porm gw2_e8_vm por_hold vrest 0 nch W=2e-06 L=1e-06
ngw2_e8_ip gw2_e8_vm s2_ya vdd vsrc pch W=4e-06 L=4e-06
ngw2_e8_in gw2_e8_vm s2_zb 0 0 nch W=4e-06 L=4e-06
ngw2_b8_sw gw2_b8_t gw2_e8_qb vdd vsrc pch W=2e-06 L=1e-06
rgw2_b8_rc gw2_b8_t gw2_b8 10000
cgw2_b8_c gw2_b8 0 1e-07
rgw2_b8_rl gw2_b8 0 2.2e+07
ngw2_b8_sh1p gw2_b8_n gw2_b8 vdd vsrc pch W=2.4e-06 L=5e-07
ngw2_b8_sh1n gw2_b8_n gw2_b8 0 0 nch W=1.2e-06 L=5e-07
ngw2_b8_sh2p gw2_b8_q gw2_b8_n vdd vsrc pch W=2.4e-06 L=5e-07
ngw2_b8_sh2n gw2_b8_q gw2_b8_n 0 0 nch W=1.2e-06 L=5e-07
cgw2_e9_cm gw2_e9_vm 0 1e-07
rgw2_e9_rm gw2_e9_vm vrest 1e+06
ngw2_e9_bias0 gw2_e9_vm istep_n 0 0 nch W=4e-06 L=4e-06
ngw2_e9_bias1 gw2_e9_vm istep_n 0 0 nch W=4e-06 L=4e-06
ngw2_e9_bias2 gw2_e9_vm istep_n 0 0 nch W=4e-06 L=4e-06
ngw2_e9_bias3 gw2_e9_vm istep_n 0 0 nch W=4e-06 L=4e-06
ngw2_e9_bias4 gw2_e9_vm istep_n 0 0 nch W=4e-06 L=4e-06
ngw2_e9_bias5 gw2_e9_vm istep_n 0 0 nch W=4e-06 L=4e-06
ngw2_e9_bias6 gw2_e9_vm istep_n 0 0 nch W=4e-06 L=4e-06
ngw2_e9_bias7 gw2_e9_vm istep_n 0 0 nch W=4e-06 L=4e-06
ngw2_e9_bias8 gw2_e9_vm istep_n 0 0 nch W=4e-06 L=4e-06
rgw2_e9_kb vdd gw2_e9_knb 1e+06
ngw2_e9_kmb gw2_e9_knb gw2_e9_knb 0 0 nch W=4e-06 L=4e-06
ngw2_e9_kmt gw2_e9_ktail gw2_e9_knb 0 0 nch W=4e-06 L=4e-06
ngw2_e9_km1 gw2_e9_kd1 gw2_e9_vm gw2_e9_ktail 0 nch W=4e-06 L=4e-06
ngw2_e9_km2 gw2_e9_ko1 gw2_e9_h gw2_e9_ktail 0 nch W=4e-06 L=4e-06
ngw2_e9_km3 gw2_e9_kd1 gw2_e9_kd1 vdd vsrc pch W=4e-06 L=4e-06
ngw2_e9_km4 gw2_e9_ko1 gw2_e9_kd1 vdd vsrc pch W=4e-06 L=4e-06
ngw2_e9_ki1p gw2_e9_qb gw2_e9_ko1 vdd vsrc pch W=2.4e-06 L=5e-07
ngw2_e9_ki1n gw2_e9_qb gw2_e9_ko1 0 0 nch W=1.2e-06 L=5e-07
ngw2_e9_ki2p gw2_e9_q gw2_e9_qb vdd vsrc pch W=2.4e-06 L=5e-07
ngw2_e9_ki2n gw2_e9_q gw2_e9_qb 0 0 nch W=1.2e-06 L=5e-07
rgw2_e9_hra gw2_e9_h vthe 1e+06
rgw2_e9_hrf gw2_e9_h gw2_e9_qb 1.9e+07
cgw2_e9_hc gw2_e9_h 0 2.1e-09
ngw2_e9_dis gw2_e9_vm gw2_e9_q gw2_e9_vmd 0 nch W=4e-06 L=1e-06
rgw2_e9_rdis gw2_e9_vmd vrest 220000
ngw2_e9_rp gw2_e9_rt gw2_e9_qb vdd vsrc pch W=2e-06 L=1e-06
rgw2_e9_rrc gw2_e9_rt gw2_e9_rec 10000
cgw2_e9_rc gw2_e9_rec 0 1e-07
rgw2_e9_rr gw2_e9_rec 0 8.2e+06
ngw2_e9_sh1 gw2_e9_vm gw2_e9_rec gw2_e9_vms 0 nch W=2e-06 L=1e-06
ngw2_e9_sh2 gw2_e9_vms gw2_e9_qb vrest 0 nch W=2e-06 L=1e-06
ngw2_e9_porh gw2_e9_h por_hold vthe 0 nch W=2e-06 L=1e-06
ngw2_e9_porm gw2_e9_vm por_hold vrest 0 nch W=2e-06 L=1e-06
ngw2_e9_ip gw2_e9_vm s2_ya vdd vsrc pch W=4e-06 L=4e-06
ngw2_e9_in gw2_e9_vm s2_zb 0 0 nch W=4e-06 L=4e-06
ngw2_b9_sw gw2_b9_t gw2_e9_qb vdd vsrc pch W=2e-06 L=1e-06
rgw2_b9_rc gw2_b9_t gw2_b9 10000
cgw2_b9_c gw2_b9 0 1e-07
rgw2_b9_rl gw2_b9 0 2.2e+07
ngw2_b9_sh1p gw2_b9_n gw2_b9 vdd vsrc pch W=2.4e-06 L=5e-07
ngw2_b9_sh1n gw2_b9_n gw2_b9 0 0 nch W=1.2e-06 L=5e-07
ngw2_b9_sh2p gw2_b9_q gw2_b9_n vdd vsrc pch W=2.4e-06 L=5e-07
ngw2_b9_sh2n gw2_b9_q gw2_b9_n 0 0 nch W=1.2e-06 L=5e-07
cgw2_e10_cm gw2_e10_vm 0 1e-07
rgw2_e10_rm gw2_e10_vm vrest 1e+06
ngw2_e10_bias0 gw2_e10_vm istep_n 0 0 nch W=4e-06 L=4e-06
ngw2_e10_bias1 gw2_e10_vm istep_n 0 0 nch W=4e-06 L=4e-06
ngw2_e10_bias2 gw2_e10_vm istep_n 0 0 nch W=4e-06 L=4e-06
ngw2_e10_bias3 gw2_e10_vm istep_n 0 0 nch W=4e-06 L=4e-06
ngw2_e10_bias4 gw2_e10_vm istep_n 0 0 nch W=4e-06 L=4e-06
ngw2_e10_bias5 gw2_e10_vm istep_n 0 0 nch W=4e-06 L=4e-06
ngw2_e10_bias6 gw2_e10_vm istep_n 0 0 nch W=4e-06 L=4e-06
ngw2_e10_bias7 gw2_e10_vm istep_n 0 0 nch W=4e-06 L=4e-06
ngw2_e10_bias8 gw2_e10_vm istep_n 0 0 nch W=4e-06 L=4e-06
ngw2_e10_bias9 gw2_e10_vm istep_n 0 0 nch W=4e-06 L=4e-06
rgw2_e10_kb vdd gw2_e10_knb 1e+06
ngw2_e10_kmb gw2_e10_knb gw2_e10_knb 0 0 nch W=4e-06 L=4e-06
ngw2_e10_kmt gw2_e10_ktail gw2_e10_knb 0 0 nch W=4e-06 L=4e-06
ngw2_e10_km1 gw2_e10_kd1 gw2_e10_vm gw2_e10_ktail 0 nch W=4e-06 L=4e-06
ngw2_e10_km2 gw2_e10_ko1 gw2_e10_h gw2_e10_ktail 0 nch W=4e-06 L=4e-06
ngw2_e10_km3 gw2_e10_kd1 gw2_e10_kd1 vdd vsrc pch W=4e-06 L=4e-06
ngw2_e10_km4 gw2_e10_ko1 gw2_e10_kd1 vdd vsrc pch W=4e-06 L=4e-06
ngw2_e10_ki1p gw2_e10_qb gw2_e10_ko1 vdd vsrc pch W=2.4e-06 L=5e-07
ngw2_e10_ki1n gw2_e10_qb gw2_e10_ko1 0 0 nch W=1.2e-06 L=5e-07
ngw2_e10_ki2p gw2_e10_q gw2_e10_qb vdd vsrc pch W=2.4e-06 L=5e-07
ngw2_e10_ki2n gw2_e10_q gw2_e10_qb 0 0 nch W=1.2e-06 L=5e-07
rgw2_e10_hra gw2_e10_h vthe 1e+06
rgw2_e10_hrf gw2_e10_h gw2_e10_qb 1.9e+07
cgw2_e10_hc gw2_e10_h 0 2.1e-09
ngw2_e10_dis gw2_e10_vm gw2_e10_q gw2_e10_vmd 0 nch W=4e-06 L=1e-06
rgw2_e10_rdis gw2_e10_vmd vrest 220000
ngw2_e10_rp gw2_e10_rt gw2_e10_qb vdd vsrc pch W=2e-06 L=1e-06
rgw2_e10_rrc gw2_e10_rt gw2_e10_rec 10000
cgw2_e10_rc gw2_e10_rec 0 1e-07
rgw2_e10_rr gw2_e10_rec 0 8.2e+06
ngw2_e10_sh1 gw2_e10_vm gw2_e10_rec gw2_e10_vms 0 nch W=2e-06 L=1e-06
ngw2_e10_sh2 gw2_e10_vms gw2_e10_qb vrest 0 nch W=2e-06 L=1e-06
ngw2_e10_porh gw2_e10_h por_hold vthe 0 nch W=2e-06 L=1e-06
ngw2_e10_porm gw2_e10_vm por_hold vrest 0 nch W=2e-06 L=1e-06
ngw2_e10_ip gw2_e10_vm s2_ya vdd vsrc pch W=4e-06 L=4e-06
ngw2_e10_in gw2_e10_vm s2_zb 0 0 nch W=4e-06 L=4e-06
ngw2_b10_sw gw2_b10_t gw2_e10_qb vdd vsrc pch W=2e-06 L=1e-06
rgw2_b10_rc gw2_b10_t gw2_b10 10000
cgw2_b10_c gw2_b10 0 1e-07
rgw2_b10_rl gw2_b10 0 2.2e+07
ngw2_b10_sh1p gw2_b10_n gw2_b10 vdd vsrc pch W=2.4e-06 L=5e-07
ngw2_b10_sh1n gw2_b10_n gw2_b10 0 0 nch W=1.2e-06 L=5e-07
ngw2_b10_sh2p gw2_b10_q gw2_b10_n vdd vsrc pch W=2.4e-06 L=5e-07
ngw2_b10_sh2n gw2_b10_q gw2_b10_n 0 0 nch W=1.2e-06 L=5e-07
ngw2_and_a0_npa gw2_and_a0_nb gw2_b1_q vdd vsrc pch W=2.4e-06 L=5e-07
ngw2_and_a0_npb gw2_and_a0_nb gw2_b2_q vdd vsrc pch W=2.4e-06 L=5e-07
ngw2_and_a0_nna gw2_and_a0_nb gw2_b1_q gw2_and_a0_nx 0 nch W=2.4e-06 L=5e-07
ngw2_and_a0_nnb gw2_and_a0_nx gw2_b2_q 0 0 nch W=2.4e-06 L=5e-07
ngw2_and_a0_ip gw2_and_g0 gw2_and_a0_nb vdd vsrc pch W=2.4e-06 L=5e-07
ngw2_and_a0_in gw2_and_g0 gw2_and_a0_nb 0 0 nch W=1.2e-06 L=5e-07
ngw2_and_a1_npa gw2_and_a1_nb gw2_b3_q vdd vsrc pch W=2.4e-06 L=5e-07
ngw2_and_a1_npb gw2_and_a1_nb gw2_b4_q vdd vsrc pch W=2.4e-06 L=5e-07
ngw2_and_a1_nna gw2_and_a1_nb gw2_b3_q gw2_and_a1_nx 0 nch W=2.4e-06 L=5e-07
ngw2_and_a1_nnb gw2_and_a1_nx gw2_b4_q 0 0 nch W=2.4e-06 L=5e-07
ngw2_and_a1_ip gw2_and_g1 gw2_and_a1_nb vdd vsrc pch W=2.4e-06 L=5e-07
ngw2_and_a1_in gw2_and_g1 gw2_and_a1_nb 0 0 nch W=1.2e-06 L=5e-07
ngw2_and_a2_npa gw2_and_a2_nb gw2_b5_q vdd vsrc pch W=2.4e-06 L=5e-07
ngw2_and_a2_npb gw2_and_a2_nb gw2_b6_q vdd vsrc pch W=2.4e-06 L=5e-07
ngw2_and_a2_nna gw2_and_a2_nb gw2_b5_q gw2_and_a2_nx 0 nch W=2.4e-06 L=5e-07
ngw2_and_a2_nnb gw2_and_a2_nx gw2_b6_q 0 0 nch W=2.4e-06 L=5e-07
ngw2_and_a2_ip gw2_and_g2 gw2_and_a2_nb vdd vsrc pch W=2.4e-06 L=5e-07
ngw2_and_a2_in gw2_and_g2 gw2_and_a2_nb 0 0 nch W=1.2e-06 L=5e-07
ngw2_and_a3_npa gw2_and_a3_nb gw2_b7_q vdd vsrc pch W=2.4e-06 L=5e-07
ngw2_and_a3_npb gw2_and_a3_nb gw2_b8_q vdd vsrc pch W=2.4e-06 L=5e-07
ngw2_and_a3_nna gw2_and_a3_nb gw2_b7_q gw2_and_a3_nx 0 nch W=2.4e-06 L=5e-07
ngw2_and_a3_nnb gw2_and_a3_nx gw2_b8_q 0 0 nch W=2.4e-06 L=5e-07
ngw2_and_a3_ip gw2_and_g3 gw2_and_a3_nb vdd vsrc pch W=2.4e-06 L=5e-07
ngw2_and_a3_in gw2_and_g3 gw2_and_a3_nb 0 0 nch W=1.2e-06 L=5e-07
ngw2_and_a4_npa gw2_and_a4_nb gw2_b9_q vdd vsrc pch W=2.4e-06 L=5e-07
ngw2_and_a4_npb gw2_and_a4_nb gw2_b10_q vdd vsrc pch W=2.4e-06 L=5e-07
ngw2_and_a4_nna gw2_and_a4_nb gw2_b9_q gw2_and_a4_nx 0 nch W=2.4e-06 L=5e-07
ngw2_and_a4_nnb gw2_and_a4_nx gw2_b10_q 0 0 nch W=2.4e-06 L=5e-07
ngw2_and_a4_ip gw2_and_g4 gw2_and_a4_nb vdd vsrc pch W=2.4e-06 L=5e-07
ngw2_and_a4_in gw2_and_g4 gw2_and_a4_nb 0 0 nch W=1.2e-06 L=5e-07
ngw2_and_a5_npa gw2_and_a5_nb gw2_and_g0 vdd vsrc pch W=2.4e-06 L=5e-07
ngw2_and_a5_npb gw2_and_a5_nb gw2_and_g1 vdd vsrc pch W=2.4e-06 L=5e-07
ngw2_and_a5_nna gw2_and_a5_nb gw2_and_g0 gw2_and_a5_nx 0 nch W=2.4e-06 L=5e-07
ngw2_and_a5_nnb gw2_and_a5_nx gw2_and_g1 0 0 nch W=2.4e-06 L=5e-07
ngw2_and_a5_ip gw2_and_g5 gw2_and_a5_nb vdd vsrc pch W=2.4e-06 L=5e-07
ngw2_and_a5_in gw2_and_g5 gw2_and_a5_nb 0 0 nch W=1.2e-06 L=5e-07
ngw2_and_a6_npa gw2_and_a6_nb gw2_and_g2 vdd vsrc pch W=2.4e-06 L=5e-07
ngw2_and_a6_npb gw2_and_a6_nb gw2_and_g3 vdd vsrc pch W=2.4e-06 L=5e-07
ngw2_and_a6_nna gw2_and_a6_nb gw2_and_g2 gw2_and_a6_nx 0 nch W=2.4e-06 L=5e-07
ngw2_and_a6_nnb gw2_and_a6_nx gw2_and_g3 0 0 nch W=2.4e-06 L=5e-07
ngw2_and_a6_ip gw2_and_g6 gw2_and_a6_nb vdd vsrc pch W=2.4e-06 L=5e-07
ngw2_and_a6_in gw2_and_g6 gw2_and_a6_nb 0 0 nch W=1.2e-06 L=5e-07
ngw2_and_a7_npa gw2_and_a7_nb gw2_and_g5 vdd vsrc pch W=2.4e-06 L=5e-07
ngw2_and_a7_npb gw2_and_a7_nb gw2_and_g6 vdd vsrc pch W=2.4e-06 L=5e-07
ngw2_and_a7_nna gw2_and_a7_nb gw2_and_g5 gw2_and_a7_nx 0 nch W=2.4e-06 L=5e-07
ngw2_and_a7_nnb gw2_and_a7_nx gw2_and_g6 0 0 nch W=2.4e-06 L=5e-07
ngw2_and_a7_ip gw2_and_g7 gw2_and_a7_nb vdd vsrc pch W=2.4e-06 L=5e-07
ngw2_and_a7_in gw2_and_g7 gw2_and_a7_nb 0 0 nch W=1.2e-06 L=5e-07
ngw2_and_a8_npa gw2_and_a8_nb gw2_and_g7 vdd vsrc pch W=2.4e-06 L=5e-07
ngw2_and_a8_npb gw2_and_a8_nb gw2_and_g4 vdd vsrc pch W=2.4e-06 L=5e-07
ngw2_and_a8_nna gw2_and_a8_nb gw2_and_g7 gw2_and_a8_nx 0 nch W=2.4e-06 L=5e-07
ngw2_and_a8_nnb gw2_and_a8_nx gw2_and_g4 0 0 nch W=2.4e-06 L=5e-07
ngw2_and_a8_ip gw2_and_g8 gw2_and_a8_nb vdd vsrc pch W=2.4e-06 L=5e-07
ngw2_and_a8_in gw2_and_g8 gw2_and_a8_nb 0 0 nch W=1.2e-06 L=5e-07
ngw2_gip gw2_gb gw2_and_g8 vdd vsrc pch W=2.4e-06 L=5e-07
ngw2_gin gw2_gb gw2_and_g8 0 0 nch W=1.2e-06 L=5e-07
cgw2_col_cm gw2_col_vm 0 1e-07
rgw2_col_rm gw2_col_vm vrest 1e+06
rgw2_col_kb vdd gw2_col_knb 1e+06
ngw2_col_kmb gw2_col_knb gw2_col_knb 0 0 nch W=4e-06 L=4e-06
ngw2_col_kmt gw2_col_ktail gw2_col_knb 0 0 nch W=4e-06 L=4e-06
ngw2_col_km1 gw2_col_kd1 gw2_col_vm gw2_col_ktail 0 nch W=4e-06 L=4e-06
ngw2_col_km2 gw2_col_ko1 gw2_col_h gw2_col_ktail 0 nch W=4e-06 L=4e-06
ngw2_col_km3 gw2_col_kd1 gw2_col_kd1 vdd vsrc pch W=4e-06 L=4e-06
ngw2_col_km4 gw2_col_ko1 gw2_col_kd1 vdd vsrc pch W=4e-06 L=4e-06
ngw2_col_ki1p gw2_col_qb gw2_col_ko1 vdd vsrc pch W=2.4e-06 L=5e-07
ngw2_col_ki1n gw2_col_qb gw2_col_ko1 0 0 nch W=1.2e-06 L=5e-07
ngw2_col_ki2p gw2_col_q gw2_col_qb vdd vsrc pch W=2.4e-06 L=5e-07
ngw2_col_ki2n gw2_col_q gw2_col_qb 0 0 nch W=1.2e-06 L=5e-07
rgw2_col_hra gw2_col_h vthe 1e+06
rgw2_col_hrf gw2_col_h gw2_col_qb 1.9e+07
cgw2_col_hc gw2_col_h 0 2.1e-09
ngw2_col_dis gw2_col_vm gw2_col_q gw2_col_vmd 0 nch W=4e-06 L=1e-06
rgw2_col_rdis gw2_col_vmd vrest 220000
ngw2_col_rp gw2_col_rt gw2_col_qb vdd vsrc pch W=2e-06 L=1e-06
rgw2_col_rrc gw2_col_rt gw2_col_rec 10000
cgw2_col_rc gw2_col_rec 0 1e-07
rgw2_col_rr gw2_col_rec 0 8.2e+06
ngw2_col_sh1 gw2_col_vm gw2_col_rec gw2_col_vms 0 nch W=2e-06 L=1e-06
ngw2_col_sh2 gw2_col_vms gw2_col_qb vrest 0 nch W=2e-06 L=1e-06
ngw2_col_porh gw2_col_h por_hold vthe 0 nch W=2e-06 L=1e-06
ngw2_col_porm gw2_col_vm por_hold vrest 0 nch W=2e-06 L=1e-06
ngw2_cin_sw gw2_cin_x gw2_gb vdd vsrc pch W=4e-06 L=1e-06
ngw2_cin_cp gw2_col_vm ilimp_n gw2_cin_x vsrc pch W=4e-06 L=4e-06
ngw2_op_tsw gw2_op_tt gw2_col_qb vdd vsrc pch W=2e-06 L=1e-06
rgw2_op_trc gw2_op_tt gw2_op_at 10000
cgw2_op_tc gw2_op_at 0 1e-07
rgw2_op_trl gw2_op_at 0 2.2e+07
ngw2_op_sh1p gw2_op_an gw2_op_at vdd vsrc pch W=2.4e-06 L=5e-07
ngw2_op_sh1n gw2_op_an gw2_op_at 0 0 nch W=1.2e-06 L=5e-07
ngw2_op_sh2p gw2_op_aq gw2_op_an vdd vsrc pch W=2.4e-06 L=5e-07
ngw2_op_sh2n gw2_op_aq gw2_op_an 0 0 nch W=1.2e-06 L=5e-07
ngw2_op_abp gw2_op_aqb gw2_op_aq vdd vsrc pch W=2.4e-06 L=5e-07
ngw2_op_abn gw2_op_aqb gw2_op_aq 0 0 nch W=1.2e-06 L=5e-07
rgw2_op_dr gw2_op_aq gw2_op_ad 1e+06
cgw2_op_dc gw2_op_ad 0 3.3e-07
ngw2_op_d2p gw2_op_adn gw2_op_ad vdd vsrc pch W=2.4e-06 L=5e-07
ngw2_op_d2n gw2_op_adn gw2_op_ad 0 0 nch W=1.2e-06 L=5e-07
ngw2_op_gpa gw2_op_pb gw2_op_aq vdd vsrc pch W=2.4e-06 L=5e-07
ngw2_op_gpb gw2_op_pb gw2_op_adn vdd vsrc pch W=2.4e-06 L=5e-07
ngw2_op_gna gw2_op_pb gw2_op_aq gw2_op_gx 0 nch W=2.4e-06 L=5e-07
ngw2_op_gnb gw2_op_gx gw2_op_adn 0 0 nch W=2.4e-06 L=5e-07
ngw2_op_op gw2_op_p gw2_op_pb vdd vsrc pch W=2.4e-06 L=5e-07
ngw2_op_on gw2_op_p gw2_op_pb 0 0 nch W=1.2e-06 L=5e-07
cgw3_e1_cm gw3_e1_vm 0 1e-07
rgw3_e1_rm gw3_e1_vm vrest 1e+06
ngw3_e1_bias0 gw3_e1_vm istep_n 0 0 nch W=4e-06 L=4e-06
rgw3_e1_kb vdd gw3_e1_knb 1e+06
ngw3_e1_kmb gw3_e1_knb gw3_e1_knb 0 0 nch W=4e-06 L=4e-06
ngw3_e1_kmt gw3_e1_ktail gw3_e1_knb 0 0 nch W=4e-06 L=4e-06
ngw3_e1_km1 gw3_e1_kd1 gw3_e1_vm gw3_e1_ktail 0 nch W=4e-06 L=4e-06
ngw3_e1_km2 gw3_e1_ko1 gw3_e1_h gw3_e1_ktail 0 nch W=4e-06 L=4e-06
ngw3_e1_km3 gw3_e1_kd1 gw3_e1_kd1 vdd vsrc pch W=4e-06 L=4e-06
ngw3_e1_km4 gw3_e1_ko1 gw3_e1_kd1 vdd vsrc pch W=4e-06 L=4e-06
ngw3_e1_ki1p gw3_e1_qb gw3_e1_ko1 vdd vsrc pch W=2.4e-06 L=5e-07
ngw3_e1_ki1n gw3_e1_qb gw3_e1_ko1 0 0 nch W=1.2e-06 L=5e-07
ngw3_e1_ki2p gw3_e1_q gw3_e1_qb vdd vsrc pch W=2.4e-06 L=5e-07
ngw3_e1_ki2n gw3_e1_q gw3_e1_qb 0 0 nch W=1.2e-06 L=5e-07
rgw3_e1_hra gw3_e1_h vthe 1e+06
rgw3_e1_hrf gw3_e1_h gw3_e1_qb 1.9e+07
cgw3_e1_hc gw3_e1_h 0 2.1e-09
ngw3_e1_dis gw3_e1_vm gw3_e1_q gw3_e1_vmd 0 nch W=4e-06 L=1e-06
rgw3_e1_rdis gw3_e1_vmd vrest 220000
ngw3_e1_rp gw3_e1_rt gw3_e1_qb vdd vsrc pch W=2e-06 L=1e-06
rgw3_e1_rrc gw3_e1_rt gw3_e1_rec 10000
cgw3_e1_rc gw3_e1_rec 0 1e-07
rgw3_e1_rr gw3_e1_rec 0 8.2e+06
ngw3_e1_sh1 gw3_e1_vm gw3_e1_rec gw3_e1_vms 0 nch W=2e-06 L=1e-06
ngw3_e1_sh2 gw3_e1_vms gw3_e1_qb vrest 0 nch W=2e-06 L=1e-06
ngw3_e1_porh gw3_e1_h por_hold vthe 0 nch W=2e-06 L=1e-06
ngw3_e1_porm gw3_e1_vm por_hold vrest 0 nch W=2e-06 L=1e-06
ngw3_e1_ip gw3_e1_vm s3_ya vdd vsrc pch W=4e-06 L=4e-06
ngw3_e1_in gw3_e1_vm s3_zb 0 0 nch W=4e-06 L=4e-06
ngw3_b1_sw gw3_b1_t gw3_e1_qb vdd vsrc pch W=2e-06 L=1e-06
rgw3_b1_rc gw3_b1_t gw3_b1 10000
cgw3_b1_c gw3_b1 0 1e-07
rgw3_b1_rl gw3_b1 0 2.2e+07
ngw3_b1_sh1p gw3_b1_n gw3_b1 vdd vsrc pch W=2.4e-06 L=5e-07
ngw3_b1_sh1n gw3_b1_n gw3_b1 0 0 nch W=1.2e-06 L=5e-07
ngw3_b1_sh2p gw3_b1_q gw3_b1_n vdd vsrc pch W=2.4e-06 L=5e-07
ngw3_b1_sh2n gw3_b1_q gw3_b1_n 0 0 nch W=1.2e-06 L=5e-07
cgw3_e2_cm gw3_e2_vm 0 1e-07
rgw3_e2_rm gw3_e2_vm vrest 1e+06
ngw3_e2_bias0 gw3_e2_vm istep_n 0 0 nch W=4e-06 L=4e-06
ngw3_e2_bias1 gw3_e2_vm istep_n 0 0 nch W=4e-06 L=4e-06
rgw3_e2_kb vdd gw3_e2_knb 1e+06
ngw3_e2_kmb gw3_e2_knb gw3_e2_knb 0 0 nch W=4e-06 L=4e-06
ngw3_e2_kmt gw3_e2_ktail gw3_e2_knb 0 0 nch W=4e-06 L=4e-06
ngw3_e2_km1 gw3_e2_kd1 gw3_e2_vm gw3_e2_ktail 0 nch W=4e-06 L=4e-06
ngw3_e2_km2 gw3_e2_ko1 gw3_e2_h gw3_e2_ktail 0 nch W=4e-06 L=4e-06
ngw3_e2_km3 gw3_e2_kd1 gw3_e2_kd1 vdd vsrc pch W=4e-06 L=4e-06
ngw3_e2_km4 gw3_e2_ko1 gw3_e2_kd1 vdd vsrc pch W=4e-06 L=4e-06
ngw3_e2_ki1p gw3_e2_qb gw3_e2_ko1 vdd vsrc pch W=2.4e-06 L=5e-07
ngw3_e2_ki1n gw3_e2_qb gw3_e2_ko1 0 0 nch W=1.2e-06 L=5e-07
ngw3_e2_ki2p gw3_e2_q gw3_e2_qb vdd vsrc pch W=2.4e-06 L=5e-07
ngw3_e2_ki2n gw3_e2_q gw3_e2_qb 0 0 nch W=1.2e-06 L=5e-07
rgw3_e2_hra gw3_e2_h vthe 1e+06
rgw3_e2_hrf gw3_e2_h gw3_e2_qb 1.9e+07
cgw3_e2_hc gw3_e2_h 0 2.1e-09
ngw3_e2_dis gw3_e2_vm gw3_e2_q gw3_e2_vmd 0 nch W=4e-06 L=1e-06
rgw3_e2_rdis gw3_e2_vmd vrest 220000
ngw3_e2_rp gw3_e2_rt gw3_e2_qb vdd vsrc pch W=2e-06 L=1e-06
rgw3_e2_rrc gw3_e2_rt gw3_e2_rec 10000
cgw3_e2_rc gw3_e2_rec 0 1e-07
rgw3_e2_rr gw3_e2_rec 0 8.2e+06
ngw3_e2_sh1 gw3_e2_vm gw3_e2_rec gw3_e2_vms 0 nch W=2e-06 L=1e-06
ngw3_e2_sh2 gw3_e2_vms gw3_e2_qb vrest 0 nch W=2e-06 L=1e-06
ngw3_e2_porh gw3_e2_h por_hold vthe 0 nch W=2e-06 L=1e-06
ngw3_e2_porm gw3_e2_vm por_hold vrest 0 nch W=2e-06 L=1e-06
ngw3_e2_ip gw3_e2_vm s3_ya vdd vsrc pch W=4e-06 L=4e-06
ngw3_e2_in gw3_e2_vm s3_zb 0 0 nch W=4e-06 L=4e-06
ngw3_b2_sw gw3_b2_t gw3_e2_qb vdd vsrc pch W=2e-06 L=1e-06
rgw3_b2_rc gw3_b2_t gw3_b2 10000
cgw3_b2_c gw3_b2 0 1e-07
rgw3_b2_rl gw3_b2 0 2.2e+07
ngw3_b2_sh1p gw3_b2_n gw3_b2 vdd vsrc pch W=2.4e-06 L=5e-07
ngw3_b2_sh1n gw3_b2_n gw3_b2 0 0 nch W=1.2e-06 L=5e-07
ngw3_b2_sh2p gw3_b2_q gw3_b2_n vdd vsrc pch W=2.4e-06 L=5e-07
ngw3_b2_sh2n gw3_b2_q gw3_b2_n 0 0 nch W=1.2e-06 L=5e-07
cgw3_e3_cm gw3_e3_vm 0 1e-07
rgw3_e3_rm gw3_e3_vm vrest 1e+06
ngw3_e3_bias0 gw3_e3_vm istep_n 0 0 nch W=4e-06 L=4e-06
ngw3_e3_bias1 gw3_e3_vm istep_n 0 0 nch W=4e-06 L=4e-06
ngw3_e3_bias2 gw3_e3_vm istep_n 0 0 nch W=4e-06 L=4e-06
rgw3_e3_kb vdd gw3_e3_knb 1e+06
ngw3_e3_kmb gw3_e3_knb gw3_e3_knb 0 0 nch W=4e-06 L=4e-06
ngw3_e3_kmt gw3_e3_ktail gw3_e3_knb 0 0 nch W=4e-06 L=4e-06
ngw3_e3_km1 gw3_e3_kd1 gw3_e3_vm gw3_e3_ktail 0 nch W=4e-06 L=4e-06
ngw3_e3_km2 gw3_e3_ko1 gw3_e3_h gw3_e3_ktail 0 nch W=4e-06 L=4e-06
ngw3_e3_km3 gw3_e3_kd1 gw3_e3_kd1 vdd vsrc pch W=4e-06 L=4e-06
ngw3_e3_km4 gw3_e3_ko1 gw3_e3_kd1 vdd vsrc pch W=4e-06 L=4e-06
ngw3_e3_ki1p gw3_e3_qb gw3_e3_ko1 vdd vsrc pch W=2.4e-06 L=5e-07
ngw3_e3_ki1n gw3_e3_qb gw3_e3_ko1 0 0 nch W=1.2e-06 L=5e-07
ngw3_e3_ki2p gw3_e3_q gw3_e3_qb vdd vsrc pch W=2.4e-06 L=5e-07
ngw3_e3_ki2n gw3_e3_q gw3_e3_qb 0 0 nch W=1.2e-06 L=5e-07
rgw3_e3_hra gw3_e3_h vthe 1e+06
rgw3_e3_hrf gw3_e3_h gw3_e3_qb 1.9e+07
cgw3_e3_hc gw3_e3_h 0 2.1e-09
ngw3_e3_dis gw3_e3_vm gw3_e3_q gw3_e3_vmd 0 nch W=4e-06 L=1e-06
rgw3_e3_rdis gw3_e3_vmd vrest 220000
ngw3_e3_rp gw3_e3_rt gw3_e3_qb vdd vsrc pch W=2e-06 L=1e-06
rgw3_e3_rrc gw3_e3_rt gw3_e3_rec 10000
cgw3_e3_rc gw3_e3_rec 0 1e-07
rgw3_e3_rr gw3_e3_rec 0 8.2e+06
ngw3_e3_sh1 gw3_e3_vm gw3_e3_rec gw3_e3_vms 0 nch W=2e-06 L=1e-06
ngw3_e3_sh2 gw3_e3_vms gw3_e3_qb vrest 0 nch W=2e-06 L=1e-06
ngw3_e3_porh gw3_e3_h por_hold vthe 0 nch W=2e-06 L=1e-06
ngw3_e3_porm gw3_e3_vm por_hold vrest 0 nch W=2e-06 L=1e-06
ngw3_e3_ip gw3_e3_vm s3_ya vdd vsrc pch W=4e-06 L=4e-06
ngw3_e3_in gw3_e3_vm s3_zb 0 0 nch W=4e-06 L=4e-06
ngw3_b3_sw gw3_b3_t gw3_e3_qb vdd vsrc pch W=2e-06 L=1e-06
rgw3_b3_rc gw3_b3_t gw3_b3 10000
cgw3_b3_c gw3_b3 0 1e-07
rgw3_b3_rl gw3_b3 0 2.2e+07
ngw3_b3_sh1p gw3_b3_n gw3_b3 vdd vsrc pch W=2.4e-06 L=5e-07
ngw3_b3_sh1n gw3_b3_n gw3_b3 0 0 nch W=1.2e-06 L=5e-07
ngw3_b3_sh2p gw3_b3_q gw3_b3_n vdd vsrc pch W=2.4e-06 L=5e-07
ngw3_b3_sh2n gw3_b3_q gw3_b3_n 0 0 nch W=1.2e-06 L=5e-07
cgw3_e4_cm gw3_e4_vm 0 1e-07
rgw3_e4_rm gw3_e4_vm vrest 1e+06
ngw3_e4_bias0 gw3_e4_vm istep_n 0 0 nch W=4e-06 L=4e-06
ngw3_e4_bias1 gw3_e4_vm istep_n 0 0 nch W=4e-06 L=4e-06
ngw3_e4_bias2 gw3_e4_vm istep_n 0 0 nch W=4e-06 L=4e-06
ngw3_e4_bias3 gw3_e4_vm istep_n 0 0 nch W=4e-06 L=4e-06
rgw3_e4_kb vdd gw3_e4_knb 1e+06
ngw3_e4_kmb gw3_e4_knb gw3_e4_knb 0 0 nch W=4e-06 L=4e-06
ngw3_e4_kmt gw3_e4_ktail gw3_e4_knb 0 0 nch W=4e-06 L=4e-06
ngw3_e4_km1 gw3_e4_kd1 gw3_e4_vm gw3_e4_ktail 0 nch W=4e-06 L=4e-06
ngw3_e4_km2 gw3_e4_ko1 gw3_e4_h gw3_e4_ktail 0 nch W=4e-06 L=4e-06
ngw3_e4_km3 gw3_e4_kd1 gw3_e4_kd1 vdd vsrc pch W=4e-06 L=4e-06
ngw3_e4_km4 gw3_e4_ko1 gw3_e4_kd1 vdd vsrc pch W=4e-06 L=4e-06
ngw3_e4_ki1p gw3_e4_qb gw3_e4_ko1 vdd vsrc pch W=2.4e-06 L=5e-07
ngw3_e4_ki1n gw3_e4_qb gw3_e4_ko1 0 0 nch W=1.2e-06 L=5e-07
ngw3_e4_ki2p gw3_e4_q gw3_e4_qb vdd vsrc pch W=2.4e-06 L=5e-07
ngw3_e4_ki2n gw3_e4_q gw3_e4_qb 0 0 nch W=1.2e-06 L=5e-07
rgw3_e4_hra gw3_e4_h vthe 1e+06
rgw3_e4_hrf gw3_e4_h gw3_e4_qb 1.9e+07
cgw3_e4_hc gw3_e4_h 0 2.1e-09
ngw3_e4_dis gw3_e4_vm gw3_e4_q gw3_e4_vmd 0 nch W=4e-06 L=1e-06
rgw3_e4_rdis gw3_e4_vmd vrest 220000
ngw3_e4_rp gw3_e4_rt gw3_e4_qb vdd vsrc pch W=2e-06 L=1e-06
rgw3_e4_rrc gw3_e4_rt gw3_e4_rec 10000
cgw3_e4_rc gw3_e4_rec 0 1e-07
rgw3_e4_rr gw3_e4_rec 0 8.2e+06
ngw3_e4_sh1 gw3_e4_vm gw3_e4_rec gw3_e4_vms 0 nch W=2e-06 L=1e-06
ngw3_e4_sh2 gw3_e4_vms gw3_e4_qb vrest 0 nch W=2e-06 L=1e-06
ngw3_e4_porh gw3_e4_h por_hold vthe 0 nch W=2e-06 L=1e-06
ngw3_e4_porm gw3_e4_vm por_hold vrest 0 nch W=2e-06 L=1e-06
ngw3_e4_ip gw3_e4_vm s3_ya vdd vsrc pch W=4e-06 L=4e-06
ngw3_e4_in gw3_e4_vm s3_zb 0 0 nch W=4e-06 L=4e-06
ngw3_b4_sw gw3_b4_t gw3_e4_qb vdd vsrc pch W=2e-06 L=1e-06
rgw3_b4_rc gw3_b4_t gw3_b4 10000
cgw3_b4_c gw3_b4 0 1e-07
rgw3_b4_rl gw3_b4 0 2.2e+07
ngw3_b4_sh1p gw3_b4_n gw3_b4 vdd vsrc pch W=2.4e-06 L=5e-07
ngw3_b4_sh1n gw3_b4_n gw3_b4 0 0 nch W=1.2e-06 L=5e-07
ngw3_b4_sh2p gw3_b4_q gw3_b4_n vdd vsrc pch W=2.4e-06 L=5e-07
ngw3_b4_sh2n gw3_b4_q gw3_b4_n 0 0 nch W=1.2e-06 L=5e-07
cgw3_e5_cm gw3_e5_vm 0 1e-07
rgw3_e5_rm gw3_e5_vm vrest 1e+06
ngw3_e5_bias0 gw3_e5_vm istep_n 0 0 nch W=4e-06 L=4e-06
ngw3_e5_bias1 gw3_e5_vm istep_n 0 0 nch W=4e-06 L=4e-06
ngw3_e5_bias2 gw3_e5_vm istep_n 0 0 nch W=4e-06 L=4e-06
ngw3_e5_bias3 gw3_e5_vm istep_n 0 0 nch W=4e-06 L=4e-06
ngw3_e5_bias4 gw3_e5_vm istep_n 0 0 nch W=4e-06 L=4e-06
rgw3_e5_kb vdd gw3_e5_knb 1e+06
ngw3_e5_kmb gw3_e5_knb gw3_e5_knb 0 0 nch W=4e-06 L=4e-06
ngw3_e5_kmt gw3_e5_ktail gw3_e5_knb 0 0 nch W=4e-06 L=4e-06
ngw3_e5_km1 gw3_e5_kd1 gw3_e5_vm gw3_e5_ktail 0 nch W=4e-06 L=4e-06
ngw3_e5_km2 gw3_e5_ko1 gw3_e5_h gw3_e5_ktail 0 nch W=4e-06 L=4e-06
ngw3_e5_km3 gw3_e5_kd1 gw3_e5_kd1 vdd vsrc pch W=4e-06 L=4e-06
ngw3_e5_km4 gw3_e5_ko1 gw3_e5_kd1 vdd vsrc pch W=4e-06 L=4e-06
ngw3_e5_ki1p gw3_e5_qb gw3_e5_ko1 vdd vsrc pch W=2.4e-06 L=5e-07
ngw3_e5_ki1n gw3_e5_qb gw3_e5_ko1 0 0 nch W=1.2e-06 L=5e-07
ngw3_e5_ki2p gw3_e5_q gw3_e5_qb vdd vsrc pch W=2.4e-06 L=5e-07
ngw3_e5_ki2n gw3_e5_q gw3_e5_qb 0 0 nch W=1.2e-06 L=5e-07
rgw3_e5_hra gw3_e5_h vthe 1e+06
rgw3_e5_hrf gw3_e5_h gw3_e5_qb 1.9e+07
cgw3_e5_hc gw3_e5_h 0 2.1e-09
ngw3_e5_dis gw3_e5_vm gw3_e5_q gw3_e5_vmd 0 nch W=4e-06 L=1e-06
rgw3_e5_rdis gw3_e5_vmd vrest 220000
ngw3_e5_rp gw3_e5_rt gw3_e5_qb vdd vsrc pch W=2e-06 L=1e-06
rgw3_e5_rrc gw3_e5_rt gw3_e5_rec 10000
cgw3_e5_rc gw3_e5_rec 0 1e-07
rgw3_e5_rr gw3_e5_rec 0 8.2e+06
ngw3_e5_sh1 gw3_e5_vm gw3_e5_rec gw3_e5_vms 0 nch W=2e-06 L=1e-06
ngw3_e5_sh2 gw3_e5_vms gw3_e5_qb vrest 0 nch W=2e-06 L=1e-06
ngw3_e5_porh gw3_e5_h por_hold vthe 0 nch W=2e-06 L=1e-06
ngw3_e5_porm gw3_e5_vm por_hold vrest 0 nch W=2e-06 L=1e-06
ngw3_e5_ip gw3_e5_vm s3_ya vdd vsrc pch W=4e-06 L=4e-06
ngw3_e5_in gw3_e5_vm s3_zb 0 0 nch W=4e-06 L=4e-06
ngw3_b5_sw gw3_b5_t gw3_e5_qb vdd vsrc pch W=2e-06 L=1e-06
rgw3_b5_rc gw3_b5_t gw3_b5 10000
cgw3_b5_c gw3_b5 0 1e-07
rgw3_b5_rl gw3_b5 0 2.2e+07
ngw3_b5_sh1p gw3_b5_n gw3_b5 vdd vsrc pch W=2.4e-06 L=5e-07
ngw3_b5_sh1n gw3_b5_n gw3_b5 0 0 nch W=1.2e-06 L=5e-07
ngw3_b5_sh2p gw3_b5_q gw3_b5_n vdd vsrc pch W=2.4e-06 L=5e-07
ngw3_b5_sh2n gw3_b5_q gw3_b5_n 0 0 nch W=1.2e-06 L=5e-07
cgw3_e6_cm gw3_e6_vm 0 1e-07
rgw3_e6_rm gw3_e6_vm vrest 1e+06
ngw3_e6_bias0 gw3_e6_vm istep_n 0 0 nch W=4e-06 L=4e-06
ngw3_e6_bias1 gw3_e6_vm istep_n 0 0 nch W=4e-06 L=4e-06
ngw3_e6_bias2 gw3_e6_vm istep_n 0 0 nch W=4e-06 L=4e-06
ngw3_e6_bias3 gw3_e6_vm istep_n 0 0 nch W=4e-06 L=4e-06
ngw3_e6_bias4 gw3_e6_vm istep_n 0 0 nch W=4e-06 L=4e-06
ngw3_e6_bias5 gw3_e6_vm istep_n 0 0 nch W=4e-06 L=4e-06
rgw3_e6_kb vdd gw3_e6_knb 1e+06
ngw3_e6_kmb gw3_e6_knb gw3_e6_knb 0 0 nch W=4e-06 L=4e-06
ngw3_e6_kmt gw3_e6_ktail gw3_e6_knb 0 0 nch W=4e-06 L=4e-06
ngw3_e6_km1 gw3_e6_kd1 gw3_e6_vm gw3_e6_ktail 0 nch W=4e-06 L=4e-06
ngw3_e6_km2 gw3_e6_ko1 gw3_e6_h gw3_e6_ktail 0 nch W=4e-06 L=4e-06
ngw3_e6_km3 gw3_e6_kd1 gw3_e6_kd1 vdd vsrc pch W=4e-06 L=4e-06
ngw3_e6_km4 gw3_e6_ko1 gw3_e6_kd1 vdd vsrc pch W=4e-06 L=4e-06
ngw3_e6_ki1p gw3_e6_qb gw3_e6_ko1 vdd vsrc pch W=2.4e-06 L=5e-07
ngw3_e6_ki1n gw3_e6_qb gw3_e6_ko1 0 0 nch W=1.2e-06 L=5e-07
ngw3_e6_ki2p gw3_e6_q gw3_e6_qb vdd vsrc pch W=2.4e-06 L=5e-07
ngw3_e6_ki2n gw3_e6_q gw3_e6_qb 0 0 nch W=1.2e-06 L=5e-07
rgw3_e6_hra gw3_e6_h vthe 1e+06
rgw3_e6_hrf gw3_e6_h gw3_e6_qb 1.9e+07
cgw3_e6_hc gw3_e6_h 0 2.1e-09
ngw3_e6_dis gw3_e6_vm gw3_e6_q gw3_e6_vmd 0 nch W=4e-06 L=1e-06
rgw3_e6_rdis gw3_e6_vmd vrest 220000
ngw3_e6_rp gw3_e6_rt gw3_e6_qb vdd vsrc pch W=2e-06 L=1e-06
rgw3_e6_rrc gw3_e6_rt gw3_e6_rec 10000
cgw3_e6_rc gw3_e6_rec 0 1e-07
rgw3_e6_rr gw3_e6_rec 0 8.2e+06
ngw3_e6_sh1 gw3_e6_vm gw3_e6_rec gw3_e6_vms 0 nch W=2e-06 L=1e-06
ngw3_e6_sh2 gw3_e6_vms gw3_e6_qb vrest 0 nch W=2e-06 L=1e-06
ngw3_e6_porh gw3_e6_h por_hold vthe 0 nch W=2e-06 L=1e-06
ngw3_e6_porm gw3_e6_vm por_hold vrest 0 nch W=2e-06 L=1e-06
ngw3_e6_ip gw3_e6_vm s3_ya vdd vsrc pch W=4e-06 L=4e-06
ngw3_e6_in gw3_e6_vm s3_zb 0 0 nch W=4e-06 L=4e-06
ngw3_b6_sw gw3_b6_t gw3_e6_qb vdd vsrc pch W=2e-06 L=1e-06
rgw3_b6_rc gw3_b6_t gw3_b6 10000
cgw3_b6_c gw3_b6 0 1e-07
rgw3_b6_rl gw3_b6 0 2.2e+07
ngw3_b6_sh1p gw3_b6_n gw3_b6 vdd vsrc pch W=2.4e-06 L=5e-07
ngw3_b6_sh1n gw3_b6_n gw3_b6 0 0 nch W=1.2e-06 L=5e-07
ngw3_b6_sh2p gw3_b6_q gw3_b6_n vdd vsrc pch W=2.4e-06 L=5e-07
ngw3_b6_sh2n gw3_b6_q gw3_b6_n 0 0 nch W=1.2e-06 L=5e-07
cgw3_e7_cm gw3_e7_vm 0 1e-07
rgw3_e7_rm gw3_e7_vm vrest 1e+06
ngw3_e7_bias0 gw3_e7_vm istep_n 0 0 nch W=4e-06 L=4e-06
ngw3_e7_bias1 gw3_e7_vm istep_n 0 0 nch W=4e-06 L=4e-06
ngw3_e7_bias2 gw3_e7_vm istep_n 0 0 nch W=4e-06 L=4e-06
ngw3_e7_bias3 gw3_e7_vm istep_n 0 0 nch W=4e-06 L=4e-06
ngw3_e7_bias4 gw3_e7_vm istep_n 0 0 nch W=4e-06 L=4e-06
ngw3_e7_bias5 gw3_e7_vm istep_n 0 0 nch W=4e-06 L=4e-06
ngw3_e7_bias6 gw3_e7_vm istep_n 0 0 nch W=4e-06 L=4e-06
rgw3_e7_kb vdd gw3_e7_knb 1e+06
ngw3_e7_kmb gw3_e7_knb gw3_e7_knb 0 0 nch W=4e-06 L=4e-06
ngw3_e7_kmt gw3_e7_ktail gw3_e7_knb 0 0 nch W=4e-06 L=4e-06
ngw3_e7_km1 gw3_e7_kd1 gw3_e7_vm gw3_e7_ktail 0 nch W=4e-06 L=4e-06
ngw3_e7_km2 gw3_e7_ko1 gw3_e7_h gw3_e7_ktail 0 nch W=4e-06 L=4e-06
ngw3_e7_km3 gw3_e7_kd1 gw3_e7_kd1 vdd vsrc pch W=4e-06 L=4e-06
ngw3_e7_km4 gw3_e7_ko1 gw3_e7_kd1 vdd vsrc pch W=4e-06 L=4e-06
ngw3_e7_ki1p gw3_e7_qb gw3_e7_ko1 vdd vsrc pch W=2.4e-06 L=5e-07
ngw3_e7_ki1n gw3_e7_qb gw3_e7_ko1 0 0 nch W=1.2e-06 L=5e-07
ngw3_e7_ki2p gw3_e7_q gw3_e7_qb vdd vsrc pch W=2.4e-06 L=5e-07
ngw3_e7_ki2n gw3_e7_q gw3_e7_qb 0 0 nch W=1.2e-06 L=5e-07
rgw3_e7_hra gw3_e7_h vthe 1e+06
rgw3_e7_hrf gw3_e7_h gw3_e7_qb 1.9e+07
cgw3_e7_hc gw3_e7_h 0 2.1e-09
ngw3_e7_dis gw3_e7_vm gw3_e7_q gw3_e7_vmd 0 nch W=4e-06 L=1e-06
rgw3_e7_rdis gw3_e7_vmd vrest 220000
ngw3_e7_rp gw3_e7_rt gw3_e7_qb vdd vsrc pch W=2e-06 L=1e-06
rgw3_e7_rrc gw3_e7_rt gw3_e7_rec 10000
cgw3_e7_rc gw3_e7_rec 0 1e-07
rgw3_e7_rr gw3_e7_rec 0 8.2e+06
ngw3_e7_sh1 gw3_e7_vm gw3_e7_rec gw3_e7_vms 0 nch W=2e-06 L=1e-06
ngw3_e7_sh2 gw3_e7_vms gw3_e7_qb vrest 0 nch W=2e-06 L=1e-06
ngw3_e7_porh gw3_e7_h por_hold vthe 0 nch W=2e-06 L=1e-06
ngw3_e7_porm gw3_e7_vm por_hold vrest 0 nch W=2e-06 L=1e-06
ngw3_e7_ip gw3_e7_vm s3_ya vdd vsrc pch W=4e-06 L=4e-06
ngw3_e7_in gw3_e7_vm s3_zb 0 0 nch W=4e-06 L=4e-06
ngw3_b7_sw gw3_b7_t gw3_e7_qb vdd vsrc pch W=2e-06 L=1e-06
rgw3_b7_rc gw3_b7_t gw3_b7 10000
cgw3_b7_c gw3_b7 0 1e-07
rgw3_b7_rl gw3_b7 0 2.2e+07
ngw3_b7_sh1p gw3_b7_n gw3_b7 vdd vsrc pch W=2.4e-06 L=5e-07
ngw3_b7_sh1n gw3_b7_n gw3_b7 0 0 nch W=1.2e-06 L=5e-07
ngw3_b7_sh2p gw3_b7_q gw3_b7_n vdd vsrc pch W=2.4e-06 L=5e-07
ngw3_b7_sh2n gw3_b7_q gw3_b7_n 0 0 nch W=1.2e-06 L=5e-07
cgw3_e8_cm gw3_e8_vm 0 1e-07
rgw3_e8_rm gw3_e8_vm vrest 1e+06
ngw3_e8_bias0 gw3_e8_vm istep_n 0 0 nch W=4e-06 L=4e-06
ngw3_e8_bias1 gw3_e8_vm istep_n 0 0 nch W=4e-06 L=4e-06
ngw3_e8_bias2 gw3_e8_vm istep_n 0 0 nch W=4e-06 L=4e-06
ngw3_e8_bias3 gw3_e8_vm istep_n 0 0 nch W=4e-06 L=4e-06
ngw3_e8_bias4 gw3_e8_vm istep_n 0 0 nch W=4e-06 L=4e-06
ngw3_e8_bias5 gw3_e8_vm istep_n 0 0 nch W=4e-06 L=4e-06
ngw3_e8_bias6 gw3_e8_vm istep_n 0 0 nch W=4e-06 L=4e-06
ngw3_e8_bias7 gw3_e8_vm istep_n 0 0 nch W=4e-06 L=4e-06
rgw3_e8_kb vdd gw3_e8_knb 1e+06
ngw3_e8_kmb gw3_e8_knb gw3_e8_knb 0 0 nch W=4e-06 L=4e-06
ngw3_e8_kmt gw3_e8_ktail gw3_e8_knb 0 0 nch W=4e-06 L=4e-06
ngw3_e8_km1 gw3_e8_kd1 gw3_e8_vm gw3_e8_ktail 0 nch W=4e-06 L=4e-06
ngw3_e8_km2 gw3_e8_ko1 gw3_e8_h gw3_e8_ktail 0 nch W=4e-06 L=4e-06
ngw3_e8_km3 gw3_e8_kd1 gw3_e8_kd1 vdd vsrc pch W=4e-06 L=4e-06
ngw3_e8_km4 gw3_e8_ko1 gw3_e8_kd1 vdd vsrc pch W=4e-06 L=4e-06
ngw3_e8_ki1p gw3_e8_qb gw3_e8_ko1 vdd vsrc pch W=2.4e-06 L=5e-07
ngw3_e8_ki1n gw3_e8_qb gw3_e8_ko1 0 0 nch W=1.2e-06 L=5e-07
ngw3_e8_ki2p gw3_e8_q gw3_e8_qb vdd vsrc pch W=2.4e-06 L=5e-07
ngw3_e8_ki2n gw3_e8_q gw3_e8_qb 0 0 nch W=1.2e-06 L=5e-07
rgw3_e8_hra gw3_e8_h vthe 1e+06
rgw3_e8_hrf gw3_e8_h gw3_e8_qb 1.9e+07
cgw3_e8_hc gw3_e8_h 0 2.1e-09
ngw3_e8_dis gw3_e8_vm gw3_e8_q gw3_e8_vmd 0 nch W=4e-06 L=1e-06
rgw3_e8_rdis gw3_e8_vmd vrest 220000
ngw3_e8_rp gw3_e8_rt gw3_e8_qb vdd vsrc pch W=2e-06 L=1e-06
rgw3_e8_rrc gw3_e8_rt gw3_e8_rec 10000
cgw3_e8_rc gw3_e8_rec 0 1e-07
rgw3_e8_rr gw3_e8_rec 0 8.2e+06
ngw3_e8_sh1 gw3_e8_vm gw3_e8_rec gw3_e8_vms 0 nch W=2e-06 L=1e-06
ngw3_e8_sh2 gw3_e8_vms gw3_e8_qb vrest 0 nch W=2e-06 L=1e-06
ngw3_e8_porh gw3_e8_h por_hold vthe 0 nch W=2e-06 L=1e-06
ngw3_e8_porm gw3_e8_vm por_hold vrest 0 nch W=2e-06 L=1e-06
ngw3_e8_ip gw3_e8_vm s3_ya vdd vsrc pch W=4e-06 L=4e-06
ngw3_e8_in gw3_e8_vm s3_zb 0 0 nch W=4e-06 L=4e-06
ngw3_b8_sw gw3_b8_t gw3_e8_qb vdd vsrc pch W=2e-06 L=1e-06
rgw3_b8_rc gw3_b8_t gw3_b8 10000
cgw3_b8_c gw3_b8 0 1e-07
rgw3_b8_rl gw3_b8 0 2.2e+07
ngw3_b8_sh1p gw3_b8_n gw3_b8 vdd vsrc pch W=2.4e-06 L=5e-07
ngw3_b8_sh1n gw3_b8_n gw3_b8 0 0 nch W=1.2e-06 L=5e-07
ngw3_b8_sh2p gw3_b8_q gw3_b8_n vdd vsrc pch W=2.4e-06 L=5e-07
ngw3_b8_sh2n gw3_b8_q gw3_b8_n 0 0 nch W=1.2e-06 L=5e-07
cgw3_e9_cm gw3_e9_vm 0 1e-07
rgw3_e9_rm gw3_e9_vm vrest 1e+06
ngw3_e9_bias0 gw3_e9_vm istep_n 0 0 nch W=4e-06 L=4e-06
ngw3_e9_bias1 gw3_e9_vm istep_n 0 0 nch W=4e-06 L=4e-06
ngw3_e9_bias2 gw3_e9_vm istep_n 0 0 nch W=4e-06 L=4e-06
ngw3_e9_bias3 gw3_e9_vm istep_n 0 0 nch W=4e-06 L=4e-06
ngw3_e9_bias4 gw3_e9_vm istep_n 0 0 nch W=4e-06 L=4e-06
ngw3_e9_bias5 gw3_e9_vm istep_n 0 0 nch W=4e-06 L=4e-06
ngw3_e9_bias6 gw3_e9_vm istep_n 0 0 nch W=4e-06 L=4e-06
ngw3_e9_bias7 gw3_e9_vm istep_n 0 0 nch W=4e-06 L=4e-06
ngw3_e9_bias8 gw3_e9_vm istep_n 0 0 nch W=4e-06 L=4e-06
rgw3_e9_kb vdd gw3_e9_knb 1e+06
ngw3_e9_kmb gw3_e9_knb gw3_e9_knb 0 0 nch W=4e-06 L=4e-06
ngw3_e9_kmt gw3_e9_ktail gw3_e9_knb 0 0 nch W=4e-06 L=4e-06
ngw3_e9_km1 gw3_e9_kd1 gw3_e9_vm gw3_e9_ktail 0 nch W=4e-06 L=4e-06
ngw3_e9_km2 gw3_e9_ko1 gw3_e9_h gw3_e9_ktail 0 nch W=4e-06 L=4e-06
ngw3_e9_km3 gw3_e9_kd1 gw3_e9_kd1 vdd vsrc pch W=4e-06 L=4e-06
ngw3_e9_km4 gw3_e9_ko1 gw3_e9_kd1 vdd vsrc pch W=4e-06 L=4e-06
ngw3_e9_ki1p gw3_e9_qb gw3_e9_ko1 vdd vsrc pch W=2.4e-06 L=5e-07
ngw3_e9_ki1n gw3_e9_qb gw3_e9_ko1 0 0 nch W=1.2e-06 L=5e-07
ngw3_e9_ki2p gw3_e9_q gw3_e9_qb vdd vsrc pch W=2.4e-06 L=5e-07
ngw3_e9_ki2n gw3_e9_q gw3_e9_qb 0 0 nch W=1.2e-06 L=5e-07
rgw3_e9_hra gw3_e9_h vthe 1e+06
rgw3_e9_hrf gw3_e9_h gw3_e9_qb 1.9e+07
cgw3_e9_hc gw3_e9_h 0 2.1e-09
ngw3_e9_dis gw3_e9_vm gw3_e9_q gw3_e9_vmd 0 nch W=4e-06 L=1e-06
rgw3_e9_rdis gw3_e9_vmd vrest 220000
ngw3_e9_rp gw3_e9_rt gw3_e9_qb vdd vsrc pch W=2e-06 L=1e-06
rgw3_e9_rrc gw3_e9_rt gw3_e9_rec 10000
cgw3_e9_rc gw3_e9_rec 0 1e-07
rgw3_e9_rr gw3_e9_rec 0 8.2e+06
ngw3_e9_sh1 gw3_e9_vm gw3_e9_rec gw3_e9_vms 0 nch W=2e-06 L=1e-06
ngw3_e9_sh2 gw3_e9_vms gw3_e9_qb vrest 0 nch W=2e-06 L=1e-06
ngw3_e9_porh gw3_e9_h por_hold vthe 0 nch W=2e-06 L=1e-06
ngw3_e9_porm gw3_e9_vm por_hold vrest 0 nch W=2e-06 L=1e-06
ngw3_e9_ip gw3_e9_vm s3_ya vdd vsrc pch W=4e-06 L=4e-06
ngw3_e9_in gw3_e9_vm s3_zb 0 0 nch W=4e-06 L=4e-06
ngw3_b9_sw gw3_b9_t gw3_e9_qb vdd vsrc pch W=2e-06 L=1e-06
rgw3_b9_rc gw3_b9_t gw3_b9 10000
cgw3_b9_c gw3_b9 0 1e-07
rgw3_b9_rl gw3_b9 0 2.2e+07
ngw3_b9_sh1p gw3_b9_n gw3_b9 vdd vsrc pch W=2.4e-06 L=5e-07
ngw3_b9_sh1n gw3_b9_n gw3_b9 0 0 nch W=1.2e-06 L=5e-07
ngw3_b9_sh2p gw3_b9_q gw3_b9_n vdd vsrc pch W=2.4e-06 L=5e-07
ngw3_b9_sh2n gw3_b9_q gw3_b9_n 0 0 nch W=1.2e-06 L=5e-07
cgw3_e10_cm gw3_e10_vm 0 1e-07
rgw3_e10_rm gw3_e10_vm vrest 1e+06
ngw3_e10_bias0 gw3_e10_vm istep_n 0 0 nch W=4e-06 L=4e-06
ngw3_e10_bias1 gw3_e10_vm istep_n 0 0 nch W=4e-06 L=4e-06
ngw3_e10_bias2 gw3_e10_vm istep_n 0 0 nch W=4e-06 L=4e-06
ngw3_e10_bias3 gw3_e10_vm istep_n 0 0 nch W=4e-06 L=4e-06
ngw3_e10_bias4 gw3_e10_vm istep_n 0 0 nch W=4e-06 L=4e-06
ngw3_e10_bias5 gw3_e10_vm istep_n 0 0 nch W=4e-06 L=4e-06
ngw3_e10_bias6 gw3_e10_vm istep_n 0 0 nch W=4e-06 L=4e-06
ngw3_e10_bias7 gw3_e10_vm istep_n 0 0 nch W=4e-06 L=4e-06
ngw3_e10_bias8 gw3_e10_vm istep_n 0 0 nch W=4e-06 L=4e-06
ngw3_e10_bias9 gw3_e10_vm istep_n 0 0 nch W=4e-06 L=4e-06
rgw3_e10_kb vdd gw3_e10_knb 1e+06
ngw3_e10_kmb gw3_e10_knb gw3_e10_knb 0 0 nch W=4e-06 L=4e-06
ngw3_e10_kmt gw3_e10_ktail gw3_e10_knb 0 0 nch W=4e-06 L=4e-06
ngw3_e10_km1 gw3_e10_kd1 gw3_e10_vm gw3_e10_ktail 0 nch W=4e-06 L=4e-06
ngw3_e10_km2 gw3_e10_ko1 gw3_e10_h gw3_e10_ktail 0 nch W=4e-06 L=4e-06
ngw3_e10_km3 gw3_e10_kd1 gw3_e10_kd1 vdd vsrc pch W=4e-06 L=4e-06
ngw3_e10_km4 gw3_e10_ko1 gw3_e10_kd1 vdd vsrc pch W=4e-06 L=4e-06
ngw3_e10_ki1p gw3_e10_qb gw3_e10_ko1 vdd vsrc pch W=2.4e-06 L=5e-07
ngw3_e10_ki1n gw3_e10_qb gw3_e10_ko1 0 0 nch W=1.2e-06 L=5e-07
ngw3_e10_ki2p gw3_e10_q gw3_e10_qb vdd vsrc pch W=2.4e-06 L=5e-07
ngw3_e10_ki2n gw3_e10_q gw3_e10_qb 0 0 nch W=1.2e-06 L=5e-07
rgw3_e10_hra gw3_e10_h vthe 1e+06
rgw3_e10_hrf gw3_e10_h gw3_e10_qb 1.9e+07
cgw3_e10_hc gw3_e10_h 0 2.1e-09
ngw3_e10_dis gw3_e10_vm gw3_e10_q gw3_e10_vmd 0 nch W=4e-06 L=1e-06
rgw3_e10_rdis gw3_e10_vmd vrest 220000
ngw3_e10_rp gw3_e10_rt gw3_e10_qb vdd vsrc pch W=2e-06 L=1e-06
rgw3_e10_rrc gw3_e10_rt gw3_e10_rec 10000
cgw3_e10_rc gw3_e10_rec 0 1e-07
rgw3_e10_rr gw3_e10_rec 0 8.2e+06
ngw3_e10_sh1 gw3_e10_vm gw3_e10_rec gw3_e10_vms 0 nch W=2e-06 L=1e-06
ngw3_e10_sh2 gw3_e10_vms gw3_e10_qb vrest 0 nch W=2e-06 L=1e-06
ngw3_e10_porh gw3_e10_h por_hold vthe 0 nch W=2e-06 L=1e-06
ngw3_e10_porm gw3_e10_vm por_hold vrest 0 nch W=2e-06 L=1e-06
ngw3_e10_ip gw3_e10_vm s3_ya vdd vsrc pch W=4e-06 L=4e-06
ngw3_e10_in gw3_e10_vm s3_zb 0 0 nch W=4e-06 L=4e-06
ngw3_b10_sw gw3_b10_t gw3_e10_qb vdd vsrc pch W=2e-06 L=1e-06
rgw3_b10_rc gw3_b10_t gw3_b10 10000
cgw3_b10_c gw3_b10 0 1e-07
rgw3_b10_rl gw3_b10 0 2.2e+07
ngw3_b10_sh1p gw3_b10_n gw3_b10 vdd vsrc pch W=2.4e-06 L=5e-07
ngw3_b10_sh1n gw3_b10_n gw3_b10 0 0 nch W=1.2e-06 L=5e-07
ngw3_b10_sh2p gw3_b10_q gw3_b10_n vdd vsrc pch W=2.4e-06 L=5e-07
ngw3_b10_sh2n gw3_b10_q gw3_b10_n 0 0 nch W=1.2e-06 L=5e-07
ngw3_and_a0_npa gw3_and_a0_nb gw3_b1_q vdd vsrc pch W=2.4e-06 L=5e-07
ngw3_and_a0_npb gw3_and_a0_nb gw3_b2_q vdd vsrc pch W=2.4e-06 L=5e-07
ngw3_and_a0_nna gw3_and_a0_nb gw3_b1_q gw3_and_a0_nx 0 nch W=2.4e-06 L=5e-07
ngw3_and_a0_nnb gw3_and_a0_nx gw3_b2_q 0 0 nch W=2.4e-06 L=5e-07
ngw3_and_a0_ip gw3_and_g0 gw3_and_a0_nb vdd vsrc pch W=2.4e-06 L=5e-07
ngw3_and_a0_in gw3_and_g0 gw3_and_a0_nb 0 0 nch W=1.2e-06 L=5e-07
ngw3_and_a1_npa gw3_and_a1_nb gw3_b3_q vdd vsrc pch W=2.4e-06 L=5e-07
ngw3_and_a1_npb gw3_and_a1_nb gw3_b4_q vdd vsrc pch W=2.4e-06 L=5e-07
ngw3_and_a1_nna gw3_and_a1_nb gw3_b3_q gw3_and_a1_nx 0 nch W=2.4e-06 L=5e-07
ngw3_and_a1_nnb gw3_and_a1_nx gw3_b4_q 0 0 nch W=2.4e-06 L=5e-07
ngw3_and_a1_ip gw3_and_g1 gw3_and_a1_nb vdd vsrc pch W=2.4e-06 L=5e-07
ngw3_and_a1_in gw3_and_g1 gw3_and_a1_nb 0 0 nch W=1.2e-06 L=5e-07
ngw3_and_a2_npa gw3_and_a2_nb gw3_b5_q vdd vsrc pch W=2.4e-06 L=5e-07
ngw3_and_a2_npb gw3_and_a2_nb gw3_b6_q vdd vsrc pch W=2.4e-06 L=5e-07
ngw3_and_a2_nna gw3_and_a2_nb gw3_b5_q gw3_and_a2_nx 0 nch W=2.4e-06 L=5e-07
ngw3_and_a2_nnb gw3_and_a2_nx gw3_b6_q 0 0 nch W=2.4e-06 L=5e-07
ngw3_and_a2_ip gw3_and_g2 gw3_and_a2_nb vdd vsrc pch W=2.4e-06 L=5e-07
ngw3_and_a2_in gw3_and_g2 gw3_and_a2_nb 0 0 nch W=1.2e-06 L=5e-07
ngw3_and_a3_npa gw3_and_a3_nb gw3_b7_q vdd vsrc pch W=2.4e-06 L=5e-07
ngw3_and_a3_npb gw3_and_a3_nb gw3_b8_q vdd vsrc pch W=2.4e-06 L=5e-07
ngw3_and_a3_nna gw3_and_a3_nb gw3_b7_q gw3_and_a3_nx 0 nch W=2.4e-06 L=5e-07
ngw3_and_a3_nnb gw3_and_a3_nx gw3_b8_q 0 0 nch W=2.4e-06 L=5e-07
ngw3_and_a3_ip gw3_and_g3 gw3_and_a3_nb vdd vsrc pch W=2.4e-06 L=5e-07
ngw3_and_a3_in gw3_and_g3 gw3_and_a3_nb 0 0 nch W=1.2e-06 L=5e-07
ngw3_and_a4_npa gw3_and_a4_nb gw3_b9_q vdd vsrc pch W=2.4e-06 L=5e-07
ngw3_and_a4_npb gw3_and_a4_nb gw3_b10_q vdd vsrc pch W=2.4e-06 L=5e-07
ngw3_and_a4_nna gw3_and_a4_nb gw3_b9_q gw3_and_a4_nx 0 nch W=2.4e-06 L=5e-07
ngw3_and_a4_nnb gw3_and_a4_nx gw3_b10_q 0 0 nch W=2.4e-06 L=5e-07
ngw3_and_a4_ip gw3_and_g4 gw3_and_a4_nb vdd vsrc pch W=2.4e-06 L=5e-07
ngw3_and_a4_in gw3_and_g4 gw3_and_a4_nb 0 0 nch W=1.2e-06 L=5e-07
ngw3_and_a5_npa gw3_and_a5_nb gw3_and_g0 vdd vsrc pch W=2.4e-06 L=5e-07
ngw3_and_a5_npb gw3_and_a5_nb gw3_and_g1 vdd vsrc pch W=2.4e-06 L=5e-07
ngw3_and_a5_nna gw3_and_a5_nb gw3_and_g0 gw3_and_a5_nx 0 nch W=2.4e-06 L=5e-07
ngw3_and_a5_nnb gw3_and_a5_nx gw3_and_g1 0 0 nch W=2.4e-06 L=5e-07
ngw3_and_a5_ip gw3_and_g5 gw3_and_a5_nb vdd vsrc pch W=2.4e-06 L=5e-07
ngw3_and_a5_in gw3_and_g5 gw3_and_a5_nb 0 0 nch W=1.2e-06 L=5e-07
ngw3_and_a6_npa gw3_and_a6_nb gw3_and_g2 vdd vsrc pch W=2.4e-06 L=5e-07
ngw3_and_a6_npb gw3_and_a6_nb gw3_and_g3 vdd vsrc pch W=2.4e-06 L=5e-07
ngw3_and_a6_nna gw3_and_a6_nb gw3_and_g2 gw3_and_a6_nx 0 nch W=2.4e-06 L=5e-07
ngw3_and_a6_nnb gw3_and_a6_nx gw3_and_g3 0 0 nch W=2.4e-06 L=5e-07
ngw3_and_a6_ip gw3_and_g6 gw3_and_a6_nb vdd vsrc pch W=2.4e-06 L=5e-07
ngw3_and_a6_in gw3_and_g6 gw3_and_a6_nb 0 0 nch W=1.2e-06 L=5e-07
ngw3_and_a7_npa gw3_and_a7_nb gw3_and_g5 vdd vsrc pch W=2.4e-06 L=5e-07
ngw3_and_a7_npb gw3_and_a7_nb gw3_and_g6 vdd vsrc pch W=2.4e-06 L=5e-07
ngw3_and_a7_nna gw3_and_a7_nb gw3_and_g5 gw3_and_a7_nx 0 nch W=2.4e-06 L=5e-07
ngw3_and_a7_nnb gw3_and_a7_nx gw3_and_g6 0 0 nch W=2.4e-06 L=5e-07
ngw3_and_a7_ip gw3_and_g7 gw3_and_a7_nb vdd vsrc pch W=2.4e-06 L=5e-07
ngw3_and_a7_in gw3_and_g7 gw3_and_a7_nb 0 0 nch W=1.2e-06 L=5e-07
ngw3_and_a8_npa gw3_and_a8_nb gw3_and_g7 vdd vsrc pch W=2.4e-06 L=5e-07
ngw3_and_a8_npb gw3_and_a8_nb gw3_and_g4 vdd vsrc pch W=2.4e-06 L=5e-07
ngw3_and_a8_nna gw3_and_a8_nb gw3_and_g7 gw3_and_a8_nx 0 nch W=2.4e-06 L=5e-07
ngw3_and_a8_nnb gw3_and_a8_nx gw3_and_g4 0 0 nch W=2.4e-06 L=5e-07
ngw3_and_a8_ip gw3_and_g8 gw3_and_a8_nb vdd vsrc pch W=2.4e-06 L=5e-07
ngw3_and_a8_in gw3_and_g8 gw3_and_a8_nb 0 0 nch W=1.2e-06 L=5e-07
ngw3_gip gw3_gb gw3_and_g8 vdd vsrc pch W=2.4e-06 L=5e-07
ngw3_gin gw3_gb gw3_and_g8 0 0 nch W=1.2e-06 L=5e-07
cgw3_col_cm gw3_col_vm 0 1e-07
rgw3_col_rm gw3_col_vm vrest 1e+06
rgw3_col_kb vdd gw3_col_knb 1e+06
ngw3_col_kmb gw3_col_knb gw3_col_knb 0 0 nch W=4e-06 L=4e-06
ngw3_col_kmt gw3_col_ktail gw3_col_knb 0 0 nch W=4e-06 L=4e-06
ngw3_col_km1 gw3_col_kd1 gw3_col_vm gw3_col_ktail 0 nch W=4e-06 L=4e-06
ngw3_col_km2 gw3_col_ko1 gw3_col_h gw3_col_ktail 0 nch W=4e-06 L=4e-06
ngw3_col_km3 gw3_col_kd1 gw3_col_kd1 vdd vsrc pch W=4e-06 L=4e-06
ngw3_col_km4 gw3_col_ko1 gw3_col_kd1 vdd vsrc pch W=4e-06 L=4e-06
ngw3_col_ki1p gw3_col_qb gw3_col_ko1 vdd vsrc pch W=2.4e-06 L=5e-07
ngw3_col_ki1n gw3_col_qb gw3_col_ko1 0 0 nch W=1.2e-06 L=5e-07
ngw3_col_ki2p gw3_col_q gw3_col_qb vdd vsrc pch W=2.4e-06 L=5e-07
ngw3_col_ki2n gw3_col_q gw3_col_qb 0 0 nch W=1.2e-06 L=5e-07
rgw3_col_hra gw3_col_h vthe 1e+06
rgw3_col_hrf gw3_col_h gw3_col_qb 1.9e+07
cgw3_col_hc gw3_col_h 0 2.1e-09
ngw3_col_dis gw3_col_vm gw3_col_q gw3_col_vmd 0 nch W=4e-06 L=1e-06
rgw3_col_rdis gw3_col_vmd vrest 220000
ngw3_col_rp gw3_col_rt gw3_col_qb vdd vsrc pch W=2e-06 L=1e-06
rgw3_col_rrc gw3_col_rt gw3_col_rec 10000
cgw3_col_rc gw3_col_rec 0 1e-07
rgw3_col_rr gw3_col_rec 0 8.2e+06
ngw3_col_sh1 gw3_col_vm gw3_col_rec gw3_col_vms 0 nch W=2e-06 L=1e-06
ngw3_col_sh2 gw3_col_vms gw3_col_qb vrest 0 nch W=2e-06 L=1e-06
ngw3_col_porh gw3_col_h por_hold vthe 0 nch W=2e-06 L=1e-06
ngw3_col_porm gw3_col_vm por_hold vrest 0 nch W=2e-06 L=1e-06
ngw3_cin_sw gw3_cin_x gw3_gb vdd vsrc pch W=4e-06 L=1e-06
ngw3_cin_cp gw3_col_vm ilimp_n gw3_cin_x vsrc pch W=4e-06 L=4e-06
ngw3_op_tsw gw3_op_tt gw3_col_qb vdd vsrc pch W=2e-06 L=1e-06
rgw3_op_trc gw3_op_tt gw3_op_at 10000
cgw3_op_tc gw3_op_at 0 1e-07
rgw3_op_trl gw3_op_at 0 2.2e+07
ngw3_op_sh1p gw3_op_an gw3_op_at vdd vsrc pch W=2.4e-06 L=5e-07
ngw3_op_sh1n gw3_op_an gw3_op_at 0 0 nch W=1.2e-06 L=5e-07
ngw3_op_sh2p gw3_op_aq gw3_op_an vdd vsrc pch W=2.4e-06 L=5e-07
ngw3_op_sh2n gw3_op_aq gw3_op_an 0 0 nch W=1.2e-06 L=5e-07
ngw3_op_abp gw3_op_aqb gw3_op_aq vdd vsrc pch W=2.4e-06 L=5e-07
ngw3_op_abn gw3_op_aqb gw3_op_aq 0 0 nch W=1.2e-06 L=5e-07
rgw3_op_dr gw3_op_aq gw3_op_ad 1e+06
cgw3_op_dc gw3_op_ad 0 3.3e-07
ngw3_op_d2p gw3_op_adn gw3_op_ad vdd vsrc pch W=2.4e-06 L=5e-07
ngw3_op_d2n gw3_op_adn gw3_op_ad 0 0 nch W=1.2e-06 L=5e-07
ngw3_op_gpa gw3_op_pb gw3_op_aq vdd vsrc pch W=2.4e-06 L=5e-07
ngw3_op_gpb gw3_op_pb gw3_op_adn vdd vsrc pch W=2.4e-06 L=5e-07
ngw3_op_gna gw3_op_pb gw3_op_aq gw3_op_gx 0 nch W=2.4e-06 L=5e-07
ngw3_op_gnb gw3_op_gx gw3_op_adn 0 0 nch W=2.4e-06 L=5e-07
ngw3_op_op gw3_op_p gw3_op_pb vdd vsrc pch W=2.4e-06 L=5e-07
ngw3_op_on gw3_op_p gw3_op_pb 0 0 nch W=1.2e-06 L=5e-07
nhsw2_sw hsw2_sd gw2_col_qb vdd vsrc pch W=4e-06 L=5e-07
rhsw2_rr hsw2_sd hsw2_h1 100000
chsw2_c1 hsw2_h1 0 1e-06
rhsw2_r2 hsw2_h1 hw2 1e+06
chsw2_c2 hw2 0 4.7e-07
rhsw2_rl hw2 0 4.7e+06
nhsw3_sw hsw3_sd gw3_col_qb vdd vsrc pch W=4e-06 L=5e-07
rhsw3_rr hsw3_sd hsw3_h1 100000
chsw3_c1 hsw3_h1 0 1e-06
rhsw3_r2 hsw3_h1 hw3 1e+06
chsw3_c2 hw3 0 4.7e-07
rhsw3_rl hw3 0 4.7e+06
nthw23f_st_mh thw23f_mi hw2 thw23f_st_x 0 nch W=2e-06 L=4e-06
nthw23f_st_mp thw23f_st_x gw3_op_aq 0 0 nch W=4e-06 L=1e-06
va_cthw23f_cm_p thw23f_vm cthw23f_cm_p 0
cthw23f_cm cthw23f_cm_p 0 1.5e-06
va_rthw23f_rm_p thw23f_vm rthw23f_rm_p 0
rthw23f_rm rthw23f_rm_p vrest 1e+06
rthw23f_kb vdd thw23f_knb 1e+06
nthw23f_kmb thw23f_knb thw23f_knb 0 0 nch W=4e-06 L=4e-06
nthw23f_kmt thw23f_ktail thw23f_knb 0 0 nch W=4e-06 L=4e-06
va_nthw23f_km1_g thw23f_vm nthw23f_km1_g 0
nthw23f_km1 thw23f_kd1 nthw23f_km1_g thw23f_ktail 0 nch W=4e-06 L=4e-06
nthw23f_km2 thw23f_ko1 thw23f_h thw23f_ktail 0 nch W=4e-06 L=4e-06
nthw23f_km3 thw23f_kd1 thw23f_kd1 vdd vsrc pch W=4e-06 L=4e-06
nthw23f_km4 thw23f_ko1 thw23f_kd1 vdd vsrc pch W=4e-06 L=4e-06
nthw23f_ki1p thw23f_qb thw23f_ko1 vdd vsrc pch W=2.4e-06 L=5e-07
nthw23f_ki1n thw23f_qb thw23f_ko1 0 0 nch W=1.2e-06 L=5e-07
nthw23f_ki2p thw23f_q thw23f_qb vdd vsrc pch W=2.4e-06 L=5e-07
nthw23f_ki2n thw23f_q thw23f_qb 0 0 nch W=1.2e-06 L=5e-07
rthw23f_hra thw23f_h vthr 1e+06
rthw23f_hrf thw23f_h thw23f_qb 1.9e+07
cthw23f_hc thw23f_h 0 2.1e-09
va_nthw23f_dis_d thw23f_vm nthw23f_dis_d 0
va_nthw23f_dis_s thw23f_vmd nthw23f_dis_s 0
nthw23f_dis nthw23f_dis_d thw23f_q nthw23f_dis_s 0 nch W=4e-06 L=1e-06
va_rthw23f_rdis_p thw23f_vmd rthw23f_rdis_p 0
rthw23f_rdis rthw23f_rdis_p vrest 12000
nthw23f_rp thw23f_rt thw23f_qb vdd vsrc pch W=2e-06 L=1e-06
rthw23f_rrc thw23f_rt thw23f_rec 10000
cthw23f_rc thw23f_rec 0 1e-07
rthw23f_rr thw23f_rec 0 8.2e+06
va_nthw23f_sh1_d thw23f_vm nthw23f_sh1_d 0
va_nthw23f_sh1_s thw23f_vms nthw23f_sh1_s 0
nthw23f_sh1 nthw23f_sh1_d thw23f_rec nthw23f_sh1_s 0 nch W=2e-06 L=1e-06
va_nthw23f_sh2_d thw23f_vms nthw23f_sh2_d 0
nthw23f_sh2 nthw23f_sh2_d thw23f_qb vrest 0 nch W=2e-06 L=1e-06
nthw23f_porh thw23f_h por_hold vthr 0 nch W=2e-06 L=1e-06
va_nthw23f_porm_d thw23f_vm nthw23f_porm_d 0
nthw23f_porm nthw23f_porm_d por_hold vrest 0 nch W=2e-06 L=1e-06
nthw23f_op_tsw thw23f_op_tt thw23f_qb vdd vsrc pch W=2e-06 L=1e-06
rthw23f_op_trc thw23f_op_tt thw23f_op_at 10000
cthw23f_op_tc thw23f_op_at 0 1e-07
rthw23f_op_trl thw23f_op_at 0 2.2e+07
nthw23f_op_sh1p thw23f_op_an thw23f_op_at vdd vsrc pch W=2.4e-06 L=5e-07
nthw23f_op_sh1n thw23f_op_an thw23f_op_at 0 0 nch W=1.2e-06 L=5e-07
nthw23f_op_sh2p thw23f_op_aq thw23f_op_an vdd vsrc pch W=2.4e-06 L=5e-07
nthw23f_op_sh2n thw23f_op_aq thw23f_op_an 0 0 nch W=1.2e-06 L=5e-07
nthw23f_op_abp thw23f_op_aqb thw23f_op_aq vdd vsrc pch W=2.4e-06 L=5e-07
nthw23f_op_abn thw23f_op_aqb thw23f_op_aq 0 0 nch W=1.2e-06 L=5e-07
rthw23f_op_dr thw23f_op_aq thw23f_op_ad 1e+06
cthw23f_op_dc thw23f_op_ad 0 3.3e-07
nthw23f_op_d2p thw23f_op_adn thw23f_op_ad vdd vsrc pch W=2.4e-06 L=5e-07
nthw23f_op_d2n thw23f_op_adn thw23f_op_ad 0 0 nch W=1.2e-06 L=5e-07
nthw23f_op_gpa thw23f_op_pb thw23f_op_aq vdd vsrc pch W=2.4e-06 L=5e-07
nthw23f_op_gpb thw23f_op_pb thw23f_op_adn vdd vsrc pch W=2.4e-06 L=5e-07
nthw23f_op_gna thw23f_op_pb thw23f_op_aq thw23f_op_gx 0 nch W=2.4e-06 L=5e-07
nthw23f_op_gnb thw23f_op_gx thw23f_op_adn 0 0 nch W=2.4e-06 L=5e-07
nthw23f_op_op thw23f_op_p thw23f_op_pb vdd vsrc pch W=2.4e-06 L=5e-07
nthw23f_op_on thw23f_op_p thw23f_op_pb 0 0 nch W=1.2e-06 L=5e-07
nthw23f_rm_md thw23f_mi thw23f_mi vdd vsrc pch W=4e-06 L=2e-06
va_nthw23f_rm_mo_d thw23f_vm nthw23f_rm_mo_d 0
nthw23f_rm_mo nthw23f_rm_mo_d thw23f_mi vdd vsrc pch W=1e-06 L=8e-06
nthw23r_st_mh thw23r_mi hw3 thw23r_st_x 0 nch W=2e-06 L=4e-06
nthw23r_st_mp thw23r_st_x gw2_op_aq 0 0 nch W=4e-06 L=1e-06
va_cthw23r_cm_p thw23r_vm cthw23r_cm_p 0
cthw23r_cm cthw23r_cm_p 0 1.5e-06
va_rthw23r_rm_p thw23r_vm rthw23r_rm_p 0
rthw23r_rm rthw23r_rm_p vrest 1e+06
rthw23r_kb vdd thw23r_knb 1e+06
nthw23r_kmb thw23r_knb thw23r_knb 0 0 nch W=4e-06 L=4e-06
nthw23r_kmt thw23r_ktail thw23r_knb 0 0 nch W=4e-06 L=4e-06
va_nthw23r_km1_g thw23r_vm nthw23r_km1_g 0
nthw23r_km1 thw23r_kd1 nthw23r_km1_g thw23r_ktail 0 nch W=4e-06 L=4e-06
nthw23r_km2 thw23r_ko1 thw23r_h thw23r_ktail 0 nch W=4e-06 L=4e-06
nthw23r_km3 thw23r_kd1 thw23r_kd1 vdd vsrc pch W=4e-06 L=4e-06
nthw23r_km4 thw23r_ko1 thw23r_kd1 vdd vsrc pch W=4e-06 L=4e-06
nthw23r_ki1p thw23r_qb thw23r_ko1 vdd vsrc pch W=2.4e-06 L=5e-07
nthw23r_ki1n thw23r_qb thw23r_ko1 0 0 nch W=1.2e-06 L=5e-07
nthw23r_ki2p thw23r_q thw23r_qb vdd vsrc pch W=2.4e-06 L=5e-07
nthw23r_ki2n thw23r_q thw23r_qb 0 0 nch W=1.2e-06 L=5e-07
rthw23r_hra thw23r_h vthr 1e+06
rthw23r_hrf thw23r_h thw23r_qb 1.9e+07
cthw23r_hc thw23r_h 0 2.1e-09
va_nthw23r_dis_d thw23r_vm nthw23r_dis_d 0
va_nthw23r_dis_s thw23r_vmd nthw23r_dis_s 0
nthw23r_dis nthw23r_dis_d thw23r_q nthw23r_dis_s 0 nch W=4e-06 L=1e-06
va_rthw23r_rdis_p thw23r_vmd rthw23r_rdis_p 0
rthw23r_rdis rthw23r_rdis_p vrest 12000
nthw23r_rp thw23r_rt thw23r_qb vdd vsrc pch W=2e-06 L=1e-06
rthw23r_rrc thw23r_rt thw23r_rec 10000
cthw23r_rc thw23r_rec 0 1e-07
rthw23r_rr thw23r_rec 0 8.2e+06
va_nthw23r_sh1_d thw23r_vm nthw23r_sh1_d 0
va_nthw23r_sh1_s thw23r_vms nthw23r_sh1_s 0
nthw23r_sh1 nthw23r_sh1_d thw23r_rec nthw23r_sh1_s 0 nch W=2e-06 L=1e-06
va_nthw23r_sh2_d thw23r_vms nthw23r_sh2_d 0
nthw23r_sh2 nthw23r_sh2_d thw23r_qb vrest 0 nch W=2e-06 L=1e-06
nthw23r_porh thw23r_h por_hold vthr 0 nch W=2e-06 L=1e-06
va_nthw23r_porm_d thw23r_vm nthw23r_porm_d 0
nthw23r_porm nthw23r_porm_d por_hold vrest 0 nch W=2e-06 L=1e-06
nthw23r_op_tsw thw23r_op_tt thw23r_qb vdd vsrc pch W=2e-06 L=1e-06
rthw23r_op_trc thw23r_op_tt thw23r_op_at 10000
cthw23r_op_tc thw23r_op_at 0 1e-07
rthw23r_op_trl thw23r_op_at 0 2.2e+07
nthw23r_op_sh1p thw23r_op_an thw23r_op_at vdd vsrc pch W=2.4e-06 L=5e-07
nthw23r_op_sh1n thw23r_op_an thw23r_op_at 0 0 nch W=1.2e-06 L=5e-07
nthw23r_op_sh2p thw23r_op_aq thw23r_op_an vdd vsrc pch W=2.4e-06 L=5e-07
nthw23r_op_sh2n thw23r_op_aq thw23r_op_an 0 0 nch W=1.2e-06 L=5e-07
nthw23r_op_abp thw23r_op_aqb thw23r_op_aq vdd vsrc pch W=2.4e-06 L=5e-07
nthw23r_op_abn thw23r_op_aqb thw23r_op_aq 0 0 nch W=1.2e-06 L=5e-07
rthw23r_op_dr thw23r_op_aq thw23r_op_ad 1e+06
cthw23r_op_dc thw23r_op_ad 0 3.3e-07
nthw23r_op_d2p thw23r_op_adn thw23r_op_ad vdd vsrc pch W=2.4e-06 L=5e-07
nthw23r_op_d2n thw23r_op_adn thw23r_op_ad 0 0 nch W=1.2e-06 L=5e-07
nthw23r_op_gpa thw23r_op_pb thw23r_op_aq vdd vsrc pch W=2.4e-06 L=5e-07
nthw23r_op_gpb thw23r_op_pb thw23r_op_adn vdd vsrc pch W=2.4e-06 L=5e-07
nthw23r_op_gna thw23r_op_pb thw23r_op_aq thw23r_op_gx 0 nch W=2.4e-06 L=5e-07
nthw23r_op_gnb thw23r_op_gx thw23r_op_adn 0 0 nch W=2.4e-06 L=5e-07
nthw23r_op_op thw23r_op_p thw23r_op_pb vdd vsrc pch W=2.4e-06 L=5e-07
nthw23r_op_on thw23r_op_p thw23r_op_pb 0 0 nch W=1.2e-06 L=5e-07
nthw23r_rm_md thw23r_mi thw23r_mi vdd vsrc pch W=4e-06 L=2e-06
va_nthw23r_rm_mo_d thw23r_vm nthw23r_rm_mo_d 0
nthw23r_rm_mo nthw23r_rm_mo_d thw23r_mi vdd vsrc pch W=1e-06 L=8e-06
cspwc1 spw1 0 1e-07
rspwl1 spw1 vmid 1e+06
nspwi1_sw spwi1_x vdd vdd vsrc pch W=4e-06 L=1e-06
nspwi1_cp spw1 irefp_n spwi1_x vsrc pch W=2e-06 L=4e-06
cspwc2 spw2 0 1e-07
rspwl2 spw2 vmid 1e+06
nspwi2_sw spwi2_x gw2_op_aqb vdd vsrc pch W=4e-06 L=1e-06
nspwi2_cp spw2 irefp_n spwi2_x vsrc pch W=2e-06 L=4e-06
cspwc3 spw3 0 1e-07
rspwl3 spw3 vmid 1e+06
nspwi3_sw spwi3_x gw3_op_aqb vdd vsrc pch W=4e-06 L=1e-06
nspwi3_cp spw3 irefp_n spwi3_x vsrc pch W=2e-06 L=4e-06
cspwc4 spw4 0 1e-07
rspwl4 spw4 vmid 1e+06
nspwi4_sw spwi4_x vdd vdd vsrc pch W=4e-06 L=1e-06
nspwi4_cp spw4 irefp_n spwi4_x vsrc pch W=2e-06 L=4e-06
rspwrs12 spw1 spws12 200000
cspwcs12 spws12 0 1e-12
rspwrt12 spws12 spw2 800000
rspwrs23 spw2 spws23 200000
cspwcs23 spws23 0 1e-12
rspwrt23 spws23 spw3 800000
rspwrs34 spw3 spws34 200000
cspwcs34 spws34 0 1e-12
rspwrt34 spws34 spw4 800000
va_csgw23f_cm_p sgw23f_vm csgw23f_cm_p 0
csgw23f_cm csgw23f_cm_p 0 1e-07
va_rsgw23f_rm_p sgw23f_vm rsgw23f_rm_p 0
rsgw23f_rm rsgw23f_rm_p vrest 1e+06
rsgw23f_kb vdd sgw23f_knb 1e+06
nsgw23f_kmb sgw23f_knb sgw23f_knb 0 0 nch W=4e-06 L=4e-06
nsgw23f_kmt sgw23f_ktail sgw23f_knb 0 0 nch W=4e-06 L=4e-06
va_nsgw23f_km1_g sgw23f_vm nsgw23f_km1_g 0
nsgw23f_km1 sgw23f_kd1 nsgw23f_km1_g sgw23f_ktail 0 nch W=4e-06 L=4e-06
nsgw23f_km2 sgw23f_ko1 sgw23f_h sgw23f_ktail 0 nch W=4e-06 L=4e-06
nsgw23f_km3 sgw23f_kd1 sgw23f_kd1 vdd vsrc pch W=4e-06 L=4e-06
nsgw23f_km4 sgw23f_ko1 sgw23f_kd1 vdd vsrc pch W=4e-06 L=4e-06
nsgw23f_ki1p sgw23f_qb sgw23f_ko1 vdd vsrc pch W=2.4e-06 L=5e-07
nsgw23f_ki1n sgw23f_qb sgw23f_ko1 0 0 nch W=1.2e-06 L=5e-07
nsgw23f_ki2p sgw23f_q sgw23f_qb vdd vsrc pch W=2.4e-06 L=5e-07
nsgw23f_ki2n sgw23f_q sgw23f_qb 0 0 nch W=1.2e-06 L=5e-07
rsgw23f_hra sgw23f_h vthr 1e+06
rsgw23f_hrf sgw23f_h sgw23f_qb 1.9e+07
csgw23f_hc sgw23f_h 0 2.1e-09
va_nsgw23f_dis_d sgw23f_vm nsgw23f_dis_d 0
va_nsgw23f_dis_s sgw23f_vmd nsgw23f_dis_s 0
nsgw23f_dis nsgw23f_dis_d sgw23f_q nsgw23f_dis_s 0 nch W=4e-06 L=1e-06
va_rsgw23f_rdis_p sgw23f_vmd rsgw23f_rdis_p 0
rsgw23f_rdis rsgw23f_rdis_p vrest 75000
nsgw23f_rp sgw23f_rt sgw23f_qb vdd vsrc pch W=2e-06 L=1e-06
rsgw23f_rrc sgw23f_rt sgw23f_rec 10000
csgw23f_rc sgw23f_rec 0 1e-07
rsgw23f_rr sgw23f_rec 0 8.2e+06
va_nsgw23f_sh1_d sgw23f_vm nsgw23f_sh1_d 0
va_nsgw23f_sh1_s sgw23f_vms nsgw23f_sh1_s 0
nsgw23f_sh1 nsgw23f_sh1_d sgw23f_rec nsgw23f_sh1_s 0 nch W=2e-06 L=1e-06
va_nsgw23f_sh2_d sgw23f_vms nsgw23f_sh2_d 0
nsgw23f_sh2 nsgw23f_sh2_d sgw23f_qb vrest 0 nch W=2e-06 L=1e-06
nsgw23f_porh sgw23f_h por_hold vthr 0 nch W=2e-06 L=1e-06
va_nsgw23f_porm_d sgw23f_vm nsgw23f_porm_d 0
nsgw23f_porm nsgw23f_porm_d por_hold vrest 0 nch W=2e-06 L=1e-06
nsgw23f_op_tsw sgw23f_op_tt sgw23f_qb vdd vsrc pch W=2e-06 L=1e-06
rsgw23f_op_trc sgw23f_op_tt sgw23f_op_at 10000
csgw23f_op_tc sgw23f_op_at 0 1e-07
rsgw23f_op_trl sgw23f_op_at 0 2.2e+07
nsgw23f_op_sh1p sgw23f_op_an sgw23f_op_at vdd vsrc pch W=2.4e-06 L=5e-07
nsgw23f_op_sh1n sgw23f_op_an sgw23f_op_at 0 0 nch W=1.2e-06 L=5e-07
nsgw23f_op_sh2p sgw23f_op_aq sgw23f_op_an vdd vsrc pch W=2.4e-06 L=5e-07
nsgw23f_op_sh2n sgw23f_op_aq sgw23f_op_an 0 0 nch W=1.2e-06 L=5e-07
nsgw23f_op_abp sgw23f_op_aqb sgw23f_op_aq vdd vsrc pch W=2.4e-06 L=5e-07
nsgw23f_op_abn sgw23f_op_aqb sgw23f_op_aq 0 0 nch W=1.2e-06 L=5e-07
rsgw23f_op_dr sgw23f_op_aq sgw23f_op_ad 1e+06
csgw23f_op_dc sgw23f_op_ad 0 3.3e-07
nsgw23f_op_d2p sgw23f_op_adn sgw23f_op_ad vdd vsrc pch W=2.4e-06 L=5e-07
nsgw23f_op_d2n sgw23f_op_adn sgw23f_op_ad 0 0 nch W=1.2e-06 L=5e-07
nsgw23f_op_gpa sgw23f_op_pb sgw23f_op_aq vdd vsrc pch W=2.4e-06 L=5e-07
nsgw23f_op_gpb sgw23f_op_pb sgw23f_op_adn vdd vsrc pch W=2.4e-06 L=5e-07
nsgw23f_op_gna sgw23f_op_pb sgw23f_op_aq sgw23f_op_gx 0 nch W=2.4e-06 L=5e-07
nsgw23f_op_gnb sgw23f_op_gx sgw23f_op_adn 0 0 nch W=2.4e-06 L=5e-07
nsgw23f_op_op sgw23f_op_p sgw23f_op_pb vdd vsrc pch W=2.4e-06 L=5e-07
nsgw23f_op_on sgw23f_op_p sgw23f_op_pb 0 0 nch W=1.2e-06 L=5e-07
rsgw23f_ota_b vdd sgw23f_ota_nb 3.3e+06
nsgw23f_ota_mb sgw23f_ota_nb sgw23f_ota_nb 0 0 nch W=4e-06 L=4e-06
nsgw23f_ota_mt sgw23f_ota_tail sgw23f_ota_nb 0 0 nch W=4e-06 L=4e-06
nsgw23f_ota_m1 sgw23f_ota_d1 spw2 sgw23f_ota_tail 0 nch W=1e-05 L=2e-06
va_nsgw23f_ota_m2_d sgw23f_vm nsgw23f_ota_m2_d 0
nsgw23f_ota_m2 nsgw23f_ota_m2_d spws23 sgw23f_ota_tail 0 nch W=1e-05 L=2e-06
nsgw23f_ota_m3 sgw23f_ota_d1 sgw23f_ota_d1 vdd vsrc pch W=1e-05 L=2e-06
va_nsgw23f_ota_m4_d sgw23f_vm nsgw23f_ota_m4_d 0
nsgw23f_ota_m4 nsgw23f_ota_m4_d sgw23f_ota_d1 vdd vsrc pch W=1e-05 L=2e-06
va_csgw23r_cm_p sgw23r_vm csgw23r_cm_p 0
csgw23r_cm csgw23r_cm_p 0 1e-07
va_rsgw23r_rm_p sgw23r_vm rsgw23r_rm_p 0
rsgw23r_rm rsgw23r_rm_p vrest 1e+06
rsgw23r_kb vdd sgw23r_knb 1e+06
nsgw23r_kmb sgw23r_knb sgw23r_knb 0 0 nch W=4e-06 L=4e-06
nsgw23r_kmt sgw23r_ktail sgw23r_knb 0 0 nch W=4e-06 L=4e-06
va_nsgw23r_km1_g sgw23r_vm nsgw23r_km1_g 0
nsgw23r_km1 sgw23r_kd1 nsgw23r_km1_g sgw23r_ktail 0 nch W=4e-06 L=4e-06
nsgw23r_km2 sgw23r_ko1 sgw23r_h sgw23r_ktail 0 nch W=4e-06 L=4e-06
nsgw23r_km3 sgw23r_kd1 sgw23r_kd1 vdd vsrc pch W=4e-06 L=4e-06
nsgw23r_km4 sgw23r_ko1 sgw23r_kd1 vdd vsrc pch W=4e-06 L=4e-06
nsgw23r_ki1p sgw23r_qb sgw23r_ko1 vdd vsrc pch W=2.4e-06 L=5e-07
nsgw23r_ki1n sgw23r_qb sgw23r_ko1 0 0 nch W=1.2e-06 L=5e-07
nsgw23r_ki2p sgw23r_q sgw23r_qb vdd vsrc pch W=2.4e-06 L=5e-07
nsgw23r_ki2n sgw23r_q sgw23r_qb 0 0 nch W=1.2e-06 L=5e-07
rsgw23r_hra sgw23r_h vthr 1e+06
rsgw23r_hrf sgw23r_h sgw23r_qb 1.9e+07
csgw23r_hc sgw23r_h 0 2.1e-09
va_nsgw23r_dis_d sgw23r_vm nsgw23r_dis_d 0
va_nsgw23r_dis_s sgw23r_vmd nsgw23r_dis_s 0
nsgw23r_dis nsgw23r_dis_d sgw23r_q nsgw23r_dis_s 0 nch W=4e-06 L=1e-06
va_rsgw23r_rdis_p sgw23r_vmd rsgw23r_rdis_p 0
rsgw23r_rdis rsgw23r_rdis_p vrest 75000
nsgw23r_rp sgw23r_rt sgw23r_qb vdd vsrc pch W=2e-06 L=1e-06
rsgw23r_rrc sgw23r_rt sgw23r_rec 10000
csgw23r_rc sgw23r_rec 0 1e-07
rsgw23r_rr sgw23r_rec 0 8.2e+06
va_nsgw23r_sh1_d sgw23r_vm nsgw23r_sh1_d 0
va_nsgw23r_sh1_s sgw23r_vms nsgw23r_sh1_s 0
nsgw23r_sh1 nsgw23r_sh1_d sgw23r_rec nsgw23r_sh1_s 0 nch W=2e-06 L=1e-06
va_nsgw23r_sh2_d sgw23r_vms nsgw23r_sh2_d 0
nsgw23r_sh2 nsgw23r_sh2_d sgw23r_qb vrest 0 nch W=2e-06 L=1e-06
nsgw23r_porh sgw23r_h por_hold vthr 0 nch W=2e-06 L=1e-06
va_nsgw23r_porm_d sgw23r_vm nsgw23r_porm_d 0
nsgw23r_porm nsgw23r_porm_d por_hold vrest 0 nch W=2e-06 L=1e-06
nsgw23r_op_tsw sgw23r_op_tt sgw23r_qb vdd vsrc pch W=2e-06 L=1e-06
rsgw23r_op_trc sgw23r_op_tt sgw23r_op_at 10000
csgw23r_op_tc sgw23r_op_at 0 1e-07
rsgw23r_op_trl sgw23r_op_at 0 2.2e+07
nsgw23r_op_sh1p sgw23r_op_an sgw23r_op_at vdd vsrc pch W=2.4e-06 L=5e-07
nsgw23r_op_sh1n sgw23r_op_an sgw23r_op_at 0 0 nch W=1.2e-06 L=5e-07
nsgw23r_op_sh2p sgw23r_op_aq sgw23r_op_an vdd vsrc pch W=2.4e-06 L=5e-07
nsgw23r_op_sh2n sgw23r_op_aq sgw23r_op_an 0 0 nch W=1.2e-06 L=5e-07
nsgw23r_op_abp sgw23r_op_aqb sgw23r_op_aq vdd vsrc pch W=2.4e-06 L=5e-07
nsgw23r_op_abn sgw23r_op_aqb sgw23r_op_aq 0 0 nch W=1.2e-06 L=5e-07
rsgw23r_op_dr sgw23r_op_aq sgw23r_op_ad 1e+06
csgw23r_op_dc sgw23r_op_ad 0 3.3e-07
nsgw23r_op_d2p sgw23r_op_adn sgw23r_op_ad vdd vsrc pch W=2.4e-06 L=5e-07
nsgw23r_op_d2n sgw23r_op_adn sgw23r_op_ad 0 0 nch W=1.2e-06 L=5e-07
nsgw23r_op_gpa sgw23r_op_pb sgw23r_op_aq vdd vsrc pch W=2.4e-06 L=5e-07
nsgw23r_op_gpb sgw23r_op_pb sgw23r_op_adn vdd vsrc pch W=2.4e-06 L=5e-07
nsgw23r_op_gna sgw23r_op_pb sgw23r_op_aq sgw23r_op_gx 0 nch W=2.4e-06 L=5e-07
nsgw23r_op_gnb sgw23r_op_gx sgw23r_op_adn 0 0 nch W=2.4e-06 L=5e-07
nsgw23r_op_op sgw23r_op_p sgw23r_op_pb vdd vsrc pch W=2.4e-06 L=5e-07
nsgw23r_op_on sgw23r_op_p sgw23r_op_pb 0 0 nch W=1.2e-06 L=5e-07
rsgw23r_ota_b vdd sgw23r_ota_nb 3.3e+06
nsgw23r_ota_mb sgw23r_ota_nb sgw23r_ota_nb 0 0 nch W=4e-06 L=4e-06
nsgw23r_ota_mt sgw23r_ota_tail sgw23r_ota_nb 0 0 nch W=4e-06 L=4e-06
nsgw23r_ota_m1 sgw23r_ota_d1 spws23 sgw23r_ota_tail 0 nch W=1e-05 L=2e-06
va_nsgw23r_ota_m2_d sgw23r_vm nsgw23r_ota_m2_d 0
nsgw23r_ota_m2 nsgw23r_ota_m2_d spw2 sgw23r_ota_tail 0 nch W=1e-05 L=2e-06
nsgw23r_ota_m3 sgw23r_ota_d1 sgw23r_ota_d1 vdd vsrc pch W=1e-05 L=2e-06
va_nsgw23r_ota_m4_d sgw23r_vm nsgw23r_ota_m4_d 0
nsgw23r_ota_m4 nsgw23r_ota_m4_d sgw23r_ota_d1 vdd vsrc pch W=1e-05 L=2e-06
ncdw23f_hsf_sw cdw23f_hsf_sd sgw23f_op_aqb vdd vsrc pch W=4e-06 L=5e-07
rcdw23f_hsf_rr cdw23f_hsf_sd cdw23f_hsf_h1 100000
ccdw23f_hsf_c1 cdw23f_hsf_h1 0 1e-06
rcdw23f_hsf_r2 cdw23f_hsf_h1 cdw23f_hs 1e+06
ccdw23f_hsf_c2 cdw23f_hs 0 4.7e-07
rcdw23f_hsf_rl cdw23f_hs 0 4.7e+06
ncdw23f_hcf_sw cdw23f_hcf_sd sgw23r_op_aqb vdd vsrc pch W=4e-06 L=5e-07
rcdw23f_hcf_rr cdw23f_hcf_sd cdw23f_hcf_h1 100000
ccdw23f_hcf_c1 cdw23f_hcf_h1 0 1e-06
rcdw23f_hcf_r2 cdw23f_hcf_h1 cdw23f_hc 1e+06
ccdw23f_hcf_c2 cdw23f_hc 0 4.7e-07
rcdw23f_hcf_rl cdw23f_hc 0 4.7e+06
va_ccdw23f_cm_p cdw23f_vm ccdw23f_cm_p 0
ccdw23f_cm ccdw23f_cm_p 0 1.5e-06
va_rcdw23f_rm_p cdw23f_vm rcdw23f_rm_p 0
rcdw23f_rm rcdw23f_rm_p vrest 1e+06
rcdw23f_kb vdd cdw23f_knb 1e+06
ncdw23f_kmb cdw23f_knb cdw23f_knb 0 0 nch W=4e-06 L=4e-06
ncdw23f_kmt cdw23f_ktail cdw23f_knb 0 0 nch W=4e-06 L=4e-06
va_ncdw23f_km1_g cdw23f_vm ncdw23f_km1_g 0
ncdw23f_km1 cdw23f_kd1 ncdw23f_km1_g cdw23f_ktail 0 nch W=4e-06 L=4e-06
ncdw23f_km2 cdw23f_ko1 cdw23f_h cdw23f_ktail 0 nch W=4e-06 L=4e-06
ncdw23f_km3 cdw23f_kd1 cdw23f_kd1 vdd vsrc pch W=4e-06 L=4e-06
ncdw23f_km4 cdw23f_ko1 cdw23f_kd1 vdd vsrc pch W=4e-06 L=4e-06
ncdw23f_ki1p cdw23f_qb cdw23f_ko1 vdd vsrc pch W=2.4e-06 L=5e-07
ncdw23f_ki1n cdw23f_qb cdw23f_ko1 0 0 nch W=1.2e-06 L=5e-07
ncdw23f_ki2p cdw23f_q cdw23f_qb vdd vsrc pch W=2.4e-06 L=5e-07
ncdw23f_ki2n cdw23f_q cdw23f_qb 0 0 nch W=1.2e-06 L=5e-07
rcdw23f_hra cdw23f_h vthr 1e+06
rcdw23f_hrf cdw23f_h cdw23f_qb 1.9e+07
ccdw23f_hc cdw23f_h 0 2.1e-09
va_ncdw23f_dis_d cdw23f_vm ncdw23f_dis_d 0
va_ncdw23f_dis_s cdw23f_vmd ncdw23f_dis_s 0
ncdw23f_dis ncdw23f_dis_d cdw23f_q ncdw23f_dis_s 0 nch W=4e-06 L=1e-06
va_rcdw23f_rdis_p cdw23f_vmd rcdw23f_rdis_p 0
rcdw23f_rdis rcdw23f_rdis_p vrest 12000
ncdw23f_rp cdw23f_rt cdw23f_qb vdd vsrc pch W=2e-06 L=1e-06
rcdw23f_rrc cdw23f_rt cdw23f_rec 10000
ccdw23f_rc cdw23f_rec 0 1e-07
rcdw23f_rr cdw23f_rec 0 8.2e+06
va_ncdw23f_sh1_d cdw23f_vm ncdw23f_sh1_d 0
va_ncdw23f_sh1_s cdw23f_vms ncdw23f_sh1_s 0
ncdw23f_sh1 ncdw23f_sh1_d cdw23f_rec ncdw23f_sh1_s 0 nch W=2e-06 L=1e-06
va_ncdw23f_sh2_d cdw23f_vms ncdw23f_sh2_d 0
ncdw23f_sh2 ncdw23f_sh2_d cdw23f_qb vrest 0 nch W=2e-06 L=1e-06
ncdw23f_porh cdw23f_h por_hold vthr 0 nch W=2e-06 L=1e-06
va_ncdw23f_porm_d cdw23f_vm ncdw23f_porm_d 0
ncdw23f_porm ncdw23f_porm_d por_hold vrest 0 nch W=2e-06 L=1e-06
ncdw23f_op_tsw cdw23f_op_tt cdw23f_qb vdd vsrc pch W=2e-06 L=1e-06
rcdw23f_op_trc cdw23f_op_tt cdw23f_op_at 10000
ccdw23f_op_tc cdw23f_op_at 0 1e-07
rcdw23f_op_trl cdw23f_op_at 0 2.2e+07
ncdw23f_op_sh1p cdw23f_op_an cdw23f_op_at vdd vsrc pch W=2.4e-06 L=5e-07
ncdw23f_op_sh1n cdw23f_op_an cdw23f_op_at 0 0 nch W=1.2e-06 L=5e-07
ncdw23f_op_sh2p cdw23f_op_aq cdw23f_op_an vdd vsrc pch W=2.4e-06 L=5e-07
ncdw23f_op_sh2n cdw23f_op_aq cdw23f_op_an 0 0 nch W=1.2e-06 L=5e-07
ncdw23f_op_abp cdw23f_op_aqb cdw23f_op_aq vdd vsrc pch W=2.4e-06 L=5e-07
ncdw23f_op_abn cdw23f_op_aqb cdw23f_op_aq 0 0 nch W=1.2e-06 L=5e-07
rcdw23f_op_dr cdw23f_op_aq cdw23f_op_ad 1e+06
ccdw23f_op_dc cdw23f_op_ad 0 3.3e-07
ncdw23f_op_d2p cdw23f_op_adn cdw23f_op_ad vdd vsrc pch W=2.4e-06 L=5e-07
ncdw23f_op_d2n cdw23f_op_adn cdw23f_op_ad 0 0 nch W=1.2e-06 L=5e-07
ncdw23f_op_gpa cdw23f_op_pb cdw23f_op_aq vdd vsrc pch W=2.4e-06 L=5e-07
ncdw23f_op_gpb cdw23f_op_pb cdw23f_op_adn vdd vsrc pch W=2.4e-06 L=5e-07
ncdw23f_op_gna cdw23f_op_pb cdw23f_op_aq cdw23f_op_gx 0 nch W=2.4e-06 L=5e-07
ncdw23f_op_gnb cdw23f_op_gx cdw23f_op_adn 0 0 nch W=2.4e-06 L=5e-07
ncdw23f_op_op cdw23f_op_p cdw23f_op_pb vdd vsrc pch W=2.4e-06 L=5e-07
ncdw23f_op_on cdw23f_op_p cdw23f_op_pb 0 0 nch W=1.2e-06 L=5e-07
ncdw23f_st_mh cdw23f_mi cdw23f_hs cdw23f_st_x 0 nch W=2e-06 L=4e-06
ncdw23f_st_mp cdw23f_st_x thw23f_op_aq 0 0 nch W=4e-06 L=1e-06
ncdw23f_rm_md cdw23f_mi cdw23f_mi vdd vsrc pch W=4e-06 L=2e-06
va_ncdw23f_rm_mo_d cdw23f_vm ncdw23f_rm_mo_d 0
ncdw23f_rm_mo ncdw23f_rm_mo_d cdw23f_mi vdd vsrc pch W=1e-06 L=8e-06
va_ncdw23f_kh_d cdw23f_vm ncdw23f_kh_d 0
ncdw23f_kh ncdw23f_kh_d cdw23f_hc cdw23f_kx 0 nch W=2e-06 L=4e-06
ncdw23f_kp cdw23f_kx thw23f_op_aq vrest 0 nch W=4e-06 L=1e-06
ncdw23r_hsf_sw cdw23r_hsf_sd sgw23r_op_aqb vdd vsrc pch W=4e-06 L=5e-07
rcdw23r_hsf_rr cdw23r_hsf_sd cdw23r_hsf_h1 100000
ccdw23r_hsf_c1 cdw23r_hsf_h1 0 1e-06
rcdw23r_hsf_r2 cdw23r_hsf_h1 cdw23r_hs 1e+06
ccdw23r_hsf_c2 cdw23r_hs 0 4.7e-07
rcdw23r_hsf_rl cdw23r_hs 0 4.7e+06
ncdw23r_hcf_sw cdw23r_hcf_sd sgw23f_op_aqb vdd vsrc pch W=4e-06 L=5e-07
rcdw23r_hcf_rr cdw23r_hcf_sd cdw23r_hcf_h1 100000
ccdw23r_hcf_c1 cdw23r_hcf_h1 0 1e-06
rcdw23r_hcf_r2 cdw23r_hcf_h1 cdw23r_hc 1e+06
ccdw23r_hcf_c2 cdw23r_hc 0 4.7e-07
rcdw23r_hcf_rl cdw23r_hc 0 4.7e+06
va_ccdw23r_cm_p cdw23r_vm ccdw23r_cm_p 0
ccdw23r_cm ccdw23r_cm_p 0 1.5e-06
va_rcdw23r_rm_p cdw23r_vm rcdw23r_rm_p 0
rcdw23r_rm rcdw23r_rm_p vrest 1e+06
rcdw23r_kb vdd cdw23r_knb 1e+06
ncdw23r_kmb cdw23r_knb cdw23r_knb 0 0 nch W=4e-06 L=4e-06
ncdw23r_kmt cdw23r_ktail cdw23r_knb 0 0 nch W=4e-06 L=4e-06
va_ncdw23r_km1_g cdw23r_vm ncdw23r_km1_g 0
ncdw23r_km1 cdw23r_kd1 ncdw23r_km1_g cdw23r_ktail 0 nch W=4e-06 L=4e-06
ncdw23r_km2 cdw23r_ko1 cdw23r_h cdw23r_ktail 0 nch W=4e-06 L=4e-06
ncdw23r_km3 cdw23r_kd1 cdw23r_kd1 vdd vsrc pch W=4e-06 L=4e-06
ncdw23r_km4 cdw23r_ko1 cdw23r_kd1 vdd vsrc pch W=4e-06 L=4e-06
ncdw23r_ki1p cdw23r_qb cdw23r_ko1 vdd vsrc pch W=2.4e-06 L=5e-07
ncdw23r_ki1n cdw23r_qb cdw23r_ko1 0 0 nch W=1.2e-06 L=5e-07
ncdw23r_ki2p cdw23r_q cdw23r_qb vdd vsrc pch W=2.4e-06 L=5e-07
ncdw23r_ki2n cdw23r_q cdw23r_qb 0 0 nch W=1.2e-06 L=5e-07
rcdw23r_hra cdw23r_h vthr 1e+06
rcdw23r_hrf cdw23r_h cdw23r_qb 1.9e+07
ccdw23r_hc cdw23r_h 0 2.1e-09
va_ncdw23r_dis_d cdw23r_vm ncdw23r_dis_d 0
va_ncdw23r_dis_s cdw23r_vmd ncdw23r_dis_s 0
ncdw23r_dis ncdw23r_dis_d cdw23r_q ncdw23r_dis_s 0 nch W=4e-06 L=1e-06
va_rcdw23r_rdis_p cdw23r_vmd rcdw23r_rdis_p 0
rcdw23r_rdis rcdw23r_rdis_p vrest 12000
ncdw23r_rp cdw23r_rt cdw23r_qb vdd vsrc pch W=2e-06 L=1e-06
rcdw23r_rrc cdw23r_rt cdw23r_rec 10000
ccdw23r_rc cdw23r_rec 0 1e-07
rcdw23r_rr cdw23r_rec 0 8.2e+06
va_ncdw23r_sh1_d cdw23r_vm ncdw23r_sh1_d 0
va_ncdw23r_sh1_s cdw23r_vms ncdw23r_sh1_s 0
ncdw23r_sh1 ncdw23r_sh1_d cdw23r_rec ncdw23r_sh1_s 0 nch W=2e-06 L=1e-06
va_ncdw23r_sh2_d cdw23r_vms ncdw23r_sh2_d 0
ncdw23r_sh2 ncdw23r_sh2_d cdw23r_qb vrest 0 nch W=2e-06 L=1e-06
ncdw23r_porh cdw23r_h por_hold vthr 0 nch W=2e-06 L=1e-06
va_ncdw23r_porm_d cdw23r_vm ncdw23r_porm_d 0
ncdw23r_porm ncdw23r_porm_d por_hold vrest 0 nch W=2e-06 L=1e-06
ncdw23r_op_tsw cdw23r_op_tt cdw23r_qb vdd vsrc pch W=2e-06 L=1e-06
rcdw23r_op_trc cdw23r_op_tt cdw23r_op_at 10000
ccdw23r_op_tc cdw23r_op_at 0 1e-07
rcdw23r_op_trl cdw23r_op_at 0 2.2e+07
ncdw23r_op_sh1p cdw23r_op_an cdw23r_op_at vdd vsrc pch W=2.4e-06 L=5e-07
ncdw23r_op_sh1n cdw23r_op_an cdw23r_op_at 0 0 nch W=1.2e-06 L=5e-07
ncdw23r_op_sh2p cdw23r_op_aq cdw23r_op_an vdd vsrc pch W=2.4e-06 L=5e-07
ncdw23r_op_sh2n cdw23r_op_aq cdw23r_op_an 0 0 nch W=1.2e-06 L=5e-07
ncdw23r_op_abp cdw23r_op_aqb cdw23r_op_aq vdd vsrc pch W=2.4e-06 L=5e-07
ncdw23r_op_abn cdw23r_op_aqb cdw23r_op_aq 0 0 nch W=1.2e-06 L=5e-07
rcdw23r_op_dr cdw23r_op_aq cdw23r_op_ad 1e+06
ccdw23r_op_dc cdw23r_op_ad 0 3.3e-07
ncdw23r_op_d2p cdw23r_op_adn cdw23r_op_ad vdd vsrc pch W=2.4e-06 L=5e-07
ncdw23r_op_d2n cdw23r_op_adn cdw23r_op_ad 0 0 nch W=1.2e-06 L=5e-07
ncdw23r_op_gpa cdw23r_op_pb cdw23r_op_aq vdd vsrc pch W=2.4e-06 L=5e-07
ncdw23r_op_gpb cdw23r_op_pb cdw23r_op_adn vdd vsrc pch W=2.4e-06 L=5e-07
ncdw23r_op_gna cdw23r_op_pb cdw23r_op_aq cdw23r_op_gx 0 nch W=2.4e-06 L=5e-07
ncdw23r_op_gnb cdw23r_op_gx cdw23r_op_adn 0 0 nch W=2.4e-06 L=5e-07
ncdw23r_op_op cdw23r_op_p cdw23r_op_pb vdd vsrc pch W=2.4e-06 L=5e-07
ncdw23r_op_on cdw23r_op_p cdw23r_op_pb 0 0 nch W=1.2e-06 L=5e-07
ncdw23r_st_mh cdw23r_mi cdw23r_hs cdw23r_st_x 0 nch W=2e-06 L=4e-06
ncdw23r_st_mp cdw23r_st_x thw23r_op_aq 0 0 nch W=4e-06 L=1e-06
ncdw23r_rm_md cdw23r_mi cdw23r_mi vdd vsrc pch W=4e-06 L=2e-06
va_ncdw23r_rm_mo_d cdw23r_vm ncdw23r_rm_mo_d 0
ncdw23r_rm_mo ncdw23r_rm_mo_d cdw23r_mi vdd vsrc pch W=1e-06 L=8e-06
va_ncdw23r_kh_d cdw23r_vm ncdw23r_kh_d 0
ncdw23r_kh ncdw23r_kh_d cdw23r_hc cdw23r_kx 0 nch W=2e-06 L=4e-06
ncdw23r_kp cdw23r_kx thw23r_op_aq vrest 0 nch W=4e-06 L=1e-06
va_cldpos_p load_pos cldpos_p 0
cldpos cldpos_p vmid 1e-06
va_rldpos_p load_pos rldpos_p 0
rldpos rldpos_p vmid 100000
nagw23f_sw agw23f_x cdw23f_op_aqb vdd vsrc pch W=4e-06 L=1e-06
va_nagw23f_cp_d load_pos nagw23f_cp_d 0
nagw23f_cp nagw23f_cp_d irefp_n agw23f_x vsrc pch W=4e-06 L=4e-06
va_cldneg_p load_neg cldneg_p 0
cldneg cldneg_p vmid 1e-06
va_rldneg_p load_neg rldneg_p 0
rldneg rldneg_p vmid 100000
nagw23r_sw agw23r_x cdw23r_op_aqb vdd vsrc pch W=4e-06 L=1e-06
va_nagw23r_cp_d load_neg nagw23r_cp_d 0
nagw23r_cp nagw23r_cp_d irefp_n agw23r_x vsrc pch W=4e-06 L=4e-06
cpar_agw23f_x agw23f_x 0 5e-14
cpar_agw23r_x agw23r_x 0 5e-14
cpar_cdw23f_h cdw23f_h 0 5e-14
cpar_cdw23f_hc cdw23f_hc 0 5e-14
cpar_cdw23f_hcf_h1 cdw23f_hcf_h1 0 5e-14
cpar_cdw23f_hcf_sd cdw23f_hcf_sd 0 5e-14
cpar_cdw23f_hs cdw23f_hs 0 5e-14
cpar_cdw23f_hsf_h1 cdw23f_hsf_h1 0 5e-14
cpar_cdw23f_hsf_sd cdw23f_hsf_sd 0 5e-14
cpar_cdw23f_kd1 cdw23f_kd1 0 5e-14
cpar_cdw23f_knb cdw23f_knb 0 5e-14
cpar_cdw23f_ko1 cdw23f_ko1 0 5e-14
cpar_cdw23f_ktail cdw23f_ktail 0 5e-14
cpar_cdw23f_kx cdw23f_kx 0 5e-14
cpar_cdw23f_mi cdw23f_mi 0 5e-14
cpar_cdw23f_op_ad cdw23f_op_ad 0 5e-14
cpar_cdw23f_op_adn cdw23f_op_adn 0 5e-14
cpar_cdw23f_op_an cdw23f_op_an 0 5e-14
cpar_cdw23f_op_aq cdw23f_op_aq 0 5e-14
cpar_cdw23f_op_aqb cdw23f_op_aqb 0 5e-14
cpar_cdw23f_op_at cdw23f_op_at 0 5e-14
cpar_cdw23f_op_gx cdw23f_op_gx 0 5e-14
cpar_cdw23f_op_p cdw23f_op_p 0 5e-14
cpar_cdw23f_op_pb cdw23f_op_pb 0 5e-14
cpar_cdw23f_op_tt cdw23f_op_tt 0 5e-14
cpar_cdw23f_q cdw23f_q 0 5e-14
cpar_cdw23f_qb cdw23f_qb 0 5e-14
cpar_cdw23f_rec cdw23f_rec 0 5e-14
cpar_cdw23f_rt cdw23f_rt 0 5e-14
cpar_cdw23f_st_x cdw23f_st_x 0 5e-14
va_cpar_cdw23f_vm_p cdw23f_vm cpar_cdw23f_vm_p 0
cpar_cdw23f_vm cpar_cdw23f_vm_p 0 5e-14
va_cpar_cdw23f_vmd_p cdw23f_vmd cpar_cdw23f_vmd_p 0
cpar_cdw23f_vmd cpar_cdw23f_vmd_p 0 5e-14
va_cpar_cdw23f_vms_p cdw23f_vms cpar_cdw23f_vms_p 0
cpar_cdw23f_vms cpar_cdw23f_vms_p 0 5e-14
cpar_cdw23r_h cdw23r_h 0 5e-14
cpar_cdw23r_hc cdw23r_hc 0 5e-14
cpar_cdw23r_hcf_h1 cdw23r_hcf_h1 0 5e-14
cpar_cdw23r_hcf_sd cdw23r_hcf_sd 0 5e-14
cpar_cdw23r_hs cdw23r_hs 0 5e-14
cpar_cdw23r_hsf_h1 cdw23r_hsf_h1 0 5e-14
cpar_cdw23r_hsf_sd cdw23r_hsf_sd 0 5e-14
cpar_cdw23r_kd1 cdw23r_kd1 0 5e-14
cpar_cdw23r_knb cdw23r_knb 0 5e-14
cpar_cdw23r_ko1 cdw23r_ko1 0 5e-14
cpar_cdw23r_ktail cdw23r_ktail 0 5e-14
cpar_cdw23r_kx cdw23r_kx 0 5e-14
cpar_cdw23r_mi cdw23r_mi 0 5e-14
cpar_cdw23r_op_ad cdw23r_op_ad 0 5e-14
cpar_cdw23r_op_adn cdw23r_op_adn 0 5e-14
cpar_cdw23r_op_an cdw23r_op_an 0 5e-14
cpar_cdw23r_op_aq cdw23r_op_aq 0 5e-14
cpar_cdw23r_op_aqb cdw23r_op_aqb 0 5e-14
cpar_cdw23r_op_at cdw23r_op_at 0 5e-14
cpar_cdw23r_op_gx cdw23r_op_gx 0 5e-14
cpar_cdw23r_op_p cdw23r_op_p 0 5e-14
cpar_cdw23r_op_pb cdw23r_op_pb 0 5e-14
cpar_cdw23r_op_tt cdw23r_op_tt 0 5e-14
cpar_cdw23r_q cdw23r_q 0 5e-14
cpar_cdw23r_qb cdw23r_qb 0 5e-14
cpar_cdw23r_rec cdw23r_rec 0 5e-14
cpar_cdw23r_rt cdw23r_rt 0 5e-14
cpar_cdw23r_st_x cdw23r_st_x 0 5e-14
va_cpar_cdw23r_vm_p cdw23r_vm cpar_cdw23r_vm_p 0
cpar_cdw23r_vm cpar_cdw23r_vm_p 0 5e-14
va_cpar_cdw23r_vmd_p cdw23r_vmd cpar_cdw23r_vmd_p 0
cpar_cdw23r_vmd cpar_cdw23r_vmd_p 0 5e-14
va_cpar_cdw23r_vms_p cdw23r_vms cpar_cdw23r_vms_p 0
cpar_cdw23r_vms cpar_cdw23r_vms_p 0 5e-14
cpar_gw2_and_a0_nb gw2_and_a0_nb 0 5e-14
cpar_gw2_and_a0_nx gw2_and_a0_nx 0 5e-14
cpar_gw2_and_a1_nb gw2_and_a1_nb 0 5e-14
cpar_gw2_and_a1_nx gw2_and_a1_nx 0 5e-14
cpar_gw2_and_a2_nb gw2_and_a2_nb 0 5e-14
cpar_gw2_and_a2_nx gw2_and_a2_nx 0 5e-14
cpar_gw2_and_a3_nb gw2_and_a3_nb 0 5e-14
cpar_gw2_and_a3_nx gw2_and_a3_nx 0 5e-14
cpar_gw2_and_a4_nb gw2_and_a4_nb 0 5e-14
cpar_gw2_and_a4_nx gw2_and_a4_nx 0 5e-14
cpar_gw2_and_a5_nb gw2_and_a5_nb 0 5e-14
cpar_gw2_and_a5_nx gw2_and_a5_nx 0 5e-14
cpar_gw2_and_a6_nb gw2_and_a6_nb 0 5e-14
cpar_gw2_and_a6_nx gw2_and_a6_nx 0 5e-14
cpar_gw2_and_a7_nb gw2_and_a7_nb 0 5e-14
cpar_gw2_and_a7_nx gw2_and_a7_nx 0 5e-14
cpar_gw2_and_a8_nb gw2_and_a8_nb 0 5e-14
cpar_gw2_and_a8_nx gw2_and_a8_nx 0 5e-14
cpar_gw2_and_g0 gw2_and_g0 0 5e-14
cpar_gw2_and_g1 gw2_and_g1 0 5e-14
cpar_gw2_and_g2 gw2_and_g2 0 5e-14
cpar_gw2_and_g3 gw2_and_g3 0 5e-14
cpar_gw2_and_g4 gw2_and_g4 0 5e-14
cpar_gw2_and_g5 gw2_and_g5 0 5e-14
cpar_gw2_and_g6 gw2_and_g6 0 5e-14
cpar_gw2_and_g7 gw2_and_g7 0 5e-14
cpar_gw2_and_g8 gw2_and_g8 0 5e-14
cpar_gw2_b1 gw2_b1 0 5e-14
cpar_gw2_b10 gw2_b10 0 5e-14
cpar_gw2_b10_n gw2_b10_n 0 5e-14
cpar_gw2_b10_q gw2_b10_q 0 5e-14
cpar_gw2_b10_t gw2_b10_t 0 5e-14
cpar_gw2_b1_n gw2_b1_n 0 5e-14
cpar_gw2_b1_q gw2_b1_q 0 5e-14
cpar_gw2_b1_t gw2_b1_t 0 5e-14
cpar_gw2_b2 gw2_b2 0 5e-14
cpar_gw2_b2_n gw2_b2_n 0 5e-14
cpar_gw2_b2_q gw2_b2_q 0 5e-14
cpar_gw2_b2_t gw2_b2_t 0 5e-14
cpar_gw2_b3 gw2_b3 0 5e-14
cpar_gw2_b3_n gw2_b3_n 0 5e-14
cpar_gw2_b3_q gw2_b3_q 0 5e-14
cpar_gw2_b3_t gw2_b3_t 0 5e-14
cpar_gw2_b4 gw2_b4 0 5e-14
cpar_gw2_b4_n gw2_b4_n 0 5e-14
cpar_gw2_b4_q gw2_b4_q 0 5e-14
cpar_gw2_b4_t gw2_b4_t 0 5e-14
cpar_gw2_b5 gw2_b5 0 5e-14
cpar_gw2_b5_n gw2_b5_n 0 5e-14
cpar_gw2_b5_q gw2_b5_q 0 5e-14
cpar_gw2_b5_t gw2_b5_t 0 5e-14
cpar_gw2_b6 gw2_b6 0 5e-14
cpar_gw2_b6_n gw2_b6_n 0 5e-14
cpar_gw2_b6_q gw2_b6_q 0 5e-14
cpar_gw2_b6_t gw2_b6_t 0 5e-14
cpar_gw2_b7 gw2_b7 0 5e-14
cpar_gw2_b7_n gw2_b7_n 0 5e-14
cpar_gw2_b7_q gw2_b7_q 0 5e-14
cpar_gw2_b7_t gw2_b7_t 0 5e-14
cpar_gw2_b8 gw2_b8 0 5e-14
cpar_gw2_b8_n gw2_b8_n 0 5e-14
cpar_gw2_b8_q gw2_b8_q 0 5e-14
cpar_gw2_b8_t gw2_b8_t 0 5e-14
cpar_gw2_b9 gw2_b9 0 5e-14
cpar_gw2_b9_n gw2_b9_n 0 5e-14
cpar_gw2_b9_q gw2_b9_q 0 5e-14
cpar_gw2_b9_t gw2_b9_t 0 5e-14
cpar_gw2_cin_x gw2_cin_x 0 5e-14
cpar_gw2_col_h gw2_col_h 0 5e-14
cpar_gw2_col_kd1 gw2_col_kd1 0 5e-14
cpar_gw2_col_knb gw2_col_knb 0 5e-14
cpar_gw2_col_ko1 gw2_col_ko1 0 5e-14
cpar_gw2_col_ktail gw2_col_ktail 0 5e-14
cpar_gw2_col_q gw2_col_q 0 5e-14
cpar_gw2_col_qb gw2_col_qb 0 5e-14
cpar_gw2_col_rec gw2_col_rec 0 5e-14
cpar_gw2_col_rt gw2_col_rt 0 5e-14
cpar_gw2_col_vm gw2_col_vm 0 5e-14
cpar_gw2_col_vmd gw2_col_vmd 0 5e-14
cpar_gw2_col_vms gw2_col_vms 0 5e-14
cpar_gw2_e10_h gw2_e10_h 0 5e-14
cpar_gw2_e10_kd1 gw2_e10_kd1 0 5e-14
cpar_gw2_e10_knb gw2_e10_knb 0 5e-14
cpar_gw2_e10_ko1 gw2_e10_ko1 0 5e-14
cpar_gw2_e10_ktail gw2_e10_ktail 0 5e-14
cpar_gw2_e10_q gw2_e10_q 0 5e-14
cpar_gw2_e10_qb gw2_e10_qb 0 5e-14
cpar_gw2_e10_rec gw2_e10_rec 0 5e-14
cpar_gw2_e10_rt gw2_e10_rt 0 5e-14
cpar_gw2_e10_vm gw2_e10_vm 0 5e-14
cpar_gw2_e10_vmd gw2_e10_vmd 0 5e-14
cpar_gw2_e10_vms gw2_e10_vms 0 5e-14
cpar_gw2_e1_h gw2_e1_h 0 5e-14
cpar_gw2_e1_kd1 gw2_e1_kd1 0 5e-14
cpar_gw2_e1_knb gw2_e1_knb 0 5e-14
cpar_gw2_e1_ko1 gw2_e1_ko1 0 5e-14
cpar_gw2_e1_ktail gw2_e1_ktail 0 5e-14
cpar_gw2_e1_q gw2_e1_q 0 5e-14
cpar_gw2_e1_qb gw2_e1_qb 0 5e-14
cpar_gw2_e1_rec gw2_e1_rec 0 5e-14
cpar_gw2_e1_rt gw2_e1_rt 0 5e-14
cpar_gw2_e1_vm gw2_e1_vm 0 5e-14
cpar_gw2_e1_vmd gw2_e1_vmd 0 5e-14
cpar_gw2_e1_vms gw2_e1_vms 0 5e-14
cpar_gw2_e2_h gw2_e2_h 0 5e-14
cpar_gw2_e2_kd1 gw2_e2_kd1 0 5e-14
cpar_gw2_e2_knb gw2_e2_knb 0 5e-14
cpar_gw2_e2_ko1 gw2_e2_ko1 0 5e-14
cpar_gw2_e2_ktail gw2_e2_ktail 0 5e-14
cpar_gw2_e2_q gw2_e2_q 0 5e-14
cpar_gw2_e2_qb gw2_e2_qb 0 5e-14
cpar_gw2_e2_rec gw2_e2_rec 0 5e-14
cpar_gw2_e2_rt gw2_e2_rt 0 5e-14
cpar_gw2_e2_vm gw2_e2_vm 0 5e-14
cpar_gw2_e2_vmd gw2_e2_vmd 0 5e-14
cpar_gw2_e2_vms gw2_e2_vms 0 5e-14
cpar_gw2_e3_h gw2_e3_h 0 5e-14
cpar_gw2_e3_kd1 gw2_e3_kd1 0 5e-14
cpar_gw2_e3_knb gw2_e3_knb 0 5e-14
cpar_gw2_e3_ko1 gw2_e3_ko1 0 5e-14
cpar_gw2_e3_ktail gw2_e3_ktail 0 5e-14
cpar_gw2_e3_q gw2_e3_q 0 5e-14
cpar_gw2_e3_qb gw2_e3_qb 0 5e-14
cpar_gw2_e3_rec gw2_e3_rec 0 5e-14
cpar_gw2_e3_rt gw2_e3_rt 0 5e-14
cpar_gw2_e3_vm gw2_e3_vm 0 5e-14
cpar_gw2_e3_vmd gw2_e3_vmd 0 5e-14
cpar_gw2_e3_vms gw2_e3_vms 0 5e-14
cpar_gw2_e4_h gw2_e4_h 0 5e-14
cpar_gw2_e4_kd1 gw2_e4_kd1 0 5e-14
cpar_gw2_e4_knb gw2_e4_knb 0 5e-14
cpar_gw2_e4_ko1 gw2_e4_ko1 0 5e-14
cpar_gw2_e4_ktail gw2_e4_ktail 0 5e-14
cpar_gw2_e4_q gw2_e4_q 0 5e-14
cpar_gw2_e4_qb gw2_e4_qb 0 5e-14
cpar_gw2_e4_rec gw2_e4_rec 0 5e-14
cpar_gw2_e4_rt gw2_e4_rt 0 5e-14
cpar_gw2_e4_vm gw2_e4_vm 0 5e-14
cpar_gw2_e4_vmd gw2_e4_vmd 0 5e-14
cpar_gw2_e4_vms gw2_e4_vms 0 5e-14
cpar_gw2_e5_h gw2_e5_h 0 5e-14
cpar_gw2_e5_kd1 gw2_e5_kd1 0 5e-14
cpar_gw2_e5_knb gw2_e5_knb 0 5e-14
cpar_gw2_e5_ko1 gw2_e5_ko1 0 5e-14
cpar_gw2_e5_ktail gw2_e5_ktail 0 5e-14
cpar_gw2_e5_q gw2_e5_q 0 5e-14
cpar_gw2_e5_qb gw2_e5_qb 0 5e-14
cpar_gw2_e5_rec gw2_e5_rec 0 5e-14
cpar_gw2_e5_rt gw2_e5_rt 0 5e-14
cpar_gw2_e5_vm gw2_e5_vm 0 5e-14
cpar_gw2_e5_vmd gw2_e5_vmd 0 5e-14
cpar_gw2_e5_vms gw2_e5_vms 0 5e-14
cpar_gw2_e6_h gw2_e6_h 0 5e-14
cpar_gw2_e6_kd1 gw2_e6_kd1 0 5e-14
cpar_gw2_e6_knb gw2_e6_knb 0 5e-14
cpar_gw2_e6_ko1 gw2_e6_ko1 0 5e-14
cpar_gw2_e6_ktail gw2_e6_ktail 0 5e-14
cpar_gw2_e6_q gw2_e6_q 0 5e-14
cpar_gw2_e6_qb gw2_e6_qb 0 5e-14
cpar_gw2_e6_rec gw2_e6_rec 0 5e-14
cpar_gw2_e6_rt gw2_e6_rt 0 5e-14
cpar_gw2_e6_vm gw2_e6_vm 0 5e-14
cpar_gw2_e6_vmd gw2_e6_vmd 0 5e-14
cpar_gw2_e6_vms gw2_e6_vms 0 5e-14
cpar_gw2_e7_h gw2_e7_h 0 5e-14
cpar_gw2_e7_kd1 gw2_e7_kd1 0 5e-14
cpar_gw2_e7_knb gw2_e7_knb 0 5e-14
cpar_gw2_e7_ko1 gw2_e7_ko1 0 5e-14
cpar_gw2_e7_ktail gw2_e7_ktail 0 5e-14
cpar_gw2_e7_q gw2_e7_q 0 5e-14
cpar_gw2_e7_qb gw2_e7_qb 0 5e-14
cpar_gw2_e7_rec gw2_e7_rec 0 5e-14
cpar_gw2_e7_rt gw2_e7_rt 0 5e-14
cpar_gw2_e7_vm gw2_e7_vm 0 5e-14
cpar_gw2_e7_vmd gw2_e7_vmd 0 5e-14
cpar_gw2_e7_vms gw2_e7_vms 0 5e-14
cpar_gw2_e8_h gw2_e8_h 0 5e-14
cpar_gw2_e8_kd1 gw2_e8_kd1 0 5e-14
cpar_gw2_e8_knb gw2_e8_knb 0 5e-14
cpar_gw2_e8_ko1 gw2_e8_ko1 0 5e-14
cpar_gw2_e8_ktail gw2_e8_ktail 0 5e-14
cpar_gw2_e8_q gw2_e8_q 0 5e-14
cpar_gw2_e8_qb gw2_e8_qb 0 5e-14
cpar_gw2_e8_rec gw2_e8_rec 0 5e-14
cpar_gw2_e8_rt gw2_e8_rt 0 5e-14
cpar_gw2_e8_vm gw2_e8_vm 0 5e-14
cpar_gw2_e8_vmd gw2_e8_vmd 0 5e-14
cpar_gw2_e8_vms gw2_e8_vms 0 5e-14
cpar_gw2_e9_h gw2_e9_h 0 5e-14
cpar_gw2_e9_kd1 gw2_e9_kd1 0 5e-14
cpar_gw2_e9_knb gw2_e9_knb 0 5e-14
cpar_gw2_e9_ko1 gw2_e9_ko1 0 5e-14
cpar_gw2_e9_ktail gw2_e9_ktail 0 5e-14
cpar_gw2_e9_q gw2_e9_q 0 5e-14
cpar_gw2_e9_qb gw2_e9_qb 0 5e-14
cpar_gw2_e9_rec gw2_e9_rec 0 5e-14
cpar_gw2_e9_rt gw2_e9_rt 0 5e-14
cpar_gw2_e9_vm gw2_e9_vm 0 5e-14
cpar_gw2_e9_vmd gw2_e9_vmd 0 5e-14
cpar_gw2_e9_vms gw2_e9_vms 0 5e-14
cpar_gw2_gb gw2_gb 0 5e-14
cpar_gw2_op_ad gw2_op_ad 0 5e-14
cpar_gw2_op_adn gw2_op_adn 0 5e-14
cpar_gw2_op_an gw2_op_an 0 5e-14
cpar_gw2_op_aq gw2_op_aq 0 5e-14
cpar_gw2_op_aqb gw2_op_aqb 0 5e-14
cpar_gw2_op_at gw2_op_at 0 5e-14
cpar_gw2_op_gx gw2_op_gx 0 5e-14
cpar_gw2_op_p gw2_op_p 0 5e-14
cpar_gw2_op_pb gw2_op_pb 0 5e-14
cpar_gw2_op_tt gw2_op_tt 0 5e-14
cpar_gw3_and_a0_nb gw3_and_a0_nb 0 5e-14
cpar_gw3_and_a0_nx gw3_and_a0_nx 0 5e-14
cpar_gw3_and_a1_nb gw3_and_a1_nb 0 5e-14
cpar_gw3_and_a1_nx gw3_and_a1_nx 0 5e-14
cpar_gw3_and_a2_nb gw3_and_a2_nb 0 5e-14
cpar_gw3_and_a2_nx gw3_and_a2_nx 0 5e-14
cpar_gw3_and_a3_nb gw3_and_a3_nb 0 5e-14
cpar_gw3_and_a3_nx gw3_and_a3_nx 0 5e-14
cpar_gw3_and_a4_nb gw3_and_a4_nb 0 5e-14
cpar_gw3_and_a4_nx gw3_and_a4_nx 0 5e-14
cpar_gw3_and_a5_nb gw3_and_a5_nb 0 5e-14
cpar_gw3_and_a5_nx gw3_and_a5_nx 0 5e-14
cpar_gw3_and_a6_nb gw3_and_a6_nb 0 5e-14
cpar_gw3_and_a6_nx gw3_and_a6_nx 0 5e-14
cpar_gw3_and_a7_nb gw3_and_a7_nb 0 5e-14
cpar_gw3_and_a7_nx gw3_and_a7_nx 0 5e-14
cpar_gw3_and_a8_nb gw3_and_a8_nb 0 5e-14
cpar_gw3_and_a8_nx gw3_and_a8_nx 0 5e-14
cpar_gw3_and_g0 gw3_and_g0 0 5e-14
cpar_gw3_and_g1 gw3_and_g1 0 5e-14
cpar_gw3_and_g2 gw3_and_g2 0 5e-14
cpar_gw3_and_g3 gw3_and_g3 0 5e-14
cpar_gw3_and_g4 gw3_and_g4 0 5e-14
cpar_gw3_and_g5 gw3_and_g5 0 5e-14
cpar_gw3_and_g6 gw3_and_g6 0 5e-14
cpar_gw3_and_g7 gw3_and_g7 0 5e-14
cpar_gw3_and_g8 gw3_and_g8 0 5e-14
cpar_gw3_b1 gw3_b1 0 5e-14
cpar_gw3_b10 gw3_b10 0 5e-14
cpar_gw3_b10_n gw3_b10_n 0 5e-14
cpar_gw3_b10_q gw3_b10_q 0 5e-14
cpar_gw3_b10_t gw3_b10_t 0 5e-14
cpar_gw3_b1_n gw3_b1_n 0 5e-14
cpar_gw3_b1_q gw3_b1_q 0 5e-14
cpar_gw3_b1_t gw3_b1_t 0 5e-14
cpar_gw3_b2 gw3_b2 0 5e-14
cpar_gw3_b2_n gw3_b2_n 0 5e-14
cpar_gw3_b2_q gw3_b2_q 0 5e-14
cpar_gw3_b2_t gw3_b2_t 0 5e-14
cpar_gw3_b3 gw3_b3 0 5e-14
cpar_gw3_b3_n gw3_b3_n 0 5e-14
cpar_gw3_b3_q gw3_b3_q 0 5e-14
cpar_gw3_b3_t gw3_b3_t 0 5e-14
cpar_gw3_b4 gw3_b4 0 5e-14
cpar_gw3_b4_n gw3_b4_n 0 5e-14
cpar_gw3_b4_q gw3_b4_q 0 5e-14
cpar_gw3_b4_t gw3_b4_t 0 5e-14
cpar_gw3_b5 gw3_b5 0 5e-14
cpar_gw3_b5_n gw3_b5_n 0 5e-14
cpar_gw3_b5_q gw3_b5_q 0 5e-14
cpar_gw3_b5_t gw3_b5_t 0 5e-14
cpar_gw3_b6 gw3_b6 0 5e-14
cpar_gw3_b6_n gw3_b6_n 0 5e-14
cpar_gw3_b6_q gw3_b6_q 0 5e-14
cpar_gw3_b6_t gw3_b6_t 0 5e-14
cpar_gw3_b7 gw3_b7 0 5e-14
cpar_gw3_b7_n gw3_b7_n 0 5e-14
cpar_gw3_b7_q gw3_b7_q 0 5e-14
cpar_gw3_b7_t gw3_b7_t 0 5e-14
cpar_gw3_b8 gw3_b8 0 5e-14
cpar_gw3_b8_n gw3_b8_n 0 5e-14
cpar_gw3_b8_q gw3_b8_q 0 5e-14
cpar_gw3_b8_t gw3_b8_t 0 5e-14
cpar_gw3_b9 gw3_b9 0 5e-14
cpar_gw3_b9_n gw3_b9_n 0 5e-14
cpar_gw3_b9_q gw3_b9_q 0 5e-14
cpar_gw3_b9_t gw3_b9_t 0 5e-14
cpar_gw3_cin_x gw3_cin_x 0 5e-14
cpar_gw3_col_h gw3_col_h 0 5e-14
cpar_gw3_col_kd1 gw3_col_kd1 0 5e-14
cpar_gw3_col_knb gw3_col_knb 0 5e-14
cpar_gw3_col_ko1 gw3_col_ko1 0 5e-14
cpar_gw3_col_ktail gw3_col_ktail 0 5e-14
cpar_gw3_col_q gw3_col_q 0 5e-14
cpar_gw3_col_qb gw3_col_qb 0 5e-14
cpar_gw3_col_rec gw3_col_rec 0 5e-14
cpar_gw3_col_rt gw3_col_rt 0 5e-14
cpar_gw3_col_vm gw3_col_vm 0 5e-14
cpar_gw3_col_vmd gw3_col_vmd 0 5e-14
cpar_gw3_col_vms gw3_col_vms 0 5e-14
cpar_gw3_e10_h gw3_e10_h 0 5e-14
cpar_gw3_e10_kd1 gw3_e10_kd1 0 5e-14
cpar_gw3_e10_knb gw3_e10_knb 0 5e-14
cpar_gw3_e10_ko1 gw3_e10_ko1 0 5e-14
cpar_gw3_e10_ktail gw3_e10_ktail 0 5e-14
cpar_gw3_e10_q gw3_e10_q 0 5e-14
cpar_gw3_e10_qb gw3_e10_qb 0 5e-14
cpar_gw3_e10_rec gw3_e10_rec 0 5e-14
cpar_gw3_e10_rt gw3_e10_rt 0 5e-14
cpar_gw3_e10_vm gw3_e10_vm 0 5e-14
cpar_gw3_e10_vmd gw3_e10_vmd 0 5e-14
cpar_gw3_e10_vms gw3_e10_vms 0 5e-14
cpar_gw3_e1_h gw3_e1_h 0 5e-14
cpar_gw3_e1_kd1 gw3_e1_kd1 0 5e-14
cpar_gw3_e1_knb gw3_e1_knb 0 5e-14
cpar_gw3_e1_ko1 gw3_e1_ko1 0 5e-14
cpar_gw3_e1_ktail gw3_e1_ktail 0 5e-14
cpar_gw3_e1_q gw3_e1_q 0 5e-14
cpar_gw3_e1_qb gw3_e1_qb 0 5e-14
cpar_gw3_e1_rec gw3_e1_rec 0 5e-14
cpar_gw3_e1_rt gw3_e1_rt 0 5e-14
cpar_gw3_e1_vm gw3_e1_vm 0 5e-14
cpar_gw3_e1_vmd gw3_e1_vmd 0 5e-14
cpar_gw3_e1_vms gw3_e1_vms 0 5e-14
cpar_gw3_e2_h gw3_e2_h 0 5e-14
cpar_gw3_e2_kd1 gw3_e2_kd1 0 5e-14
cpar_gw3_e2_knb gw3_e2_knb 0 5e-14
cpar_gw3_e2_ko1 gw3_e2_ko1 0 5e-14
cpar_gw3_e2_ktail gw3_e2_ktail 0 5e-14
cpar_gw3_e2_q gw3_e2_q 0 5e-14
cpar_gw3_e2_qb gw3_e2_qb 0 5e-14
cpar_gw3_e2_rec gw3_e2_rec 0 5e-14
cpar_gw3_e2_rt gw3_e2_rt 0 5e-14
cpar_gw3_e2_vm gw3_e2_vm 0 5e-14
cpar_gw3_e2_vmd gw3_e2_vmd 0 5e-14
cpar_gw3_e2_vms gw3_e2_vms 0 5e-14
cpar_gw3_e3_h gw3_e3_h 0 5e-14
cpar_gw3_e3_kd1 gw3_e3_kd1 0 5e-14
cpar_gw3_e3_knb gw3_e3_knb 0 5e-14
cpar_gw3_e3_ko1 gw3_e3_ko1 0 5e-14
cpar_gw3_e3_ktail gw3_e3_ktail 0 5e-14
cpar_gw3_e3_q gw3_e3_q 0 5e-14
cpar_gw3_e3_qb gw3_e3_qb 0 5e-14
cpar_gw3_e3_rec gw3_e3_rec 0 5e-14
cpar_gw3_e3_rt gw3_e3_rt 0 5e-14
cpar_gw3_e3_vm gw3_e3_vm 0 5e-14
cpar_gw3_e3_vmd gw3_e3_vmd 0 5e-14
cpar_gw3_e3_vms gw3_e3_vms 0 5e-14
cpar_gw3_e4_h gw3_e4_h 0 5e-14
cpar_gw3_e4_kd1 gw3_e4_kd1 0 5e-14
cpar_gw3_e4_knb gw3_e4_knb 0 5e-14
cpar_gw3_e4_ko1 gw3_e4_ko1 0 5e-14
cpar_gw3_e4_ktail gw3_e4_ktail 0 5e-14
cpar_gw3_e4_q gw3_e4_q 0 5e-14
cpar_gw3_e4_qb gw3_e4_qb 0 5e-14
cpar_gw3_e4_rec gw3_e4_rec 0 5e-14
cpar_gw3_e4_rt gw3_e4_rt 0 5e-14
cpar_gw3_e4_vm gw3_e4_vm 0 5e-14
cpar_gw3_e4_vmd gw3_e4_vmd 0 5e-14
cpar_gw3_e4_vms gw3_e4_vms 0 5e-14
cpar_gw3_e5_h gw3_e5_h 0 5e-14
cpar_gw3_e5_kd1 gw3_e5_kd1 0 5e-14
cpar_gw3_e5_knb gw3_e5_knb 0 5e-14
cpar_gw3_e5_ko1 gw3_e5_ko1 0 5e-14
cpar_gw3_e5_ktail gw3_e5_ktail 0 5e-14
cpar_gw3_e5_q gw3_e5_q 0 5e-14
cpar_gw3_e5_qb gw3_e5_qb 0 5e-14
cpar_gw3_e5_rec gw3_e5_rec 0 5e-14
cpar_gw3_e5_rt gw3_e5_rt 0 5e-14
cpar_gw3_e5_vm gw3_e5_vm 0 5e-14
cpar_gw3_e5_vmd gw3_e5_vmd 0 5e-14
cpar_gw3_e5_vms gw3_e5_vms 0 5e-14
cpar_gw3_e6_h gw3_e6_h 0 5e-14
cpar_gw3_e6_kd1 gw3_e6_kd1 0 5e-14
cpar_gw3_e6_knb gw3_e6_knb 0 5e-14
cpar_gw3_e6_ko1 gw3_e6_ko1 0 5e-14
cpar_gw3_e6_ktail gw3_e6_ktail 0 5e-14
cpar_gw3_e6_q gw3_e6_q 0 5e-14
cpar_gw3_e6_qb gw3_e6_qb 0 5e-14
cpar_gw3_e6_rec gw3_e6_rec 0 5e-14
cpar_gw3_e6_rt gw3_e6_rt 0 5e-14
cpar_gw3_e6_vm gw3_e6_vm 0 5e-14
cpar_gw3_e6_vmd gw3_e6_vmd 0 5e-14
cpar_gw3_e6_vms gw3_e6_vms 0 5e-14
cpar_gw3_e7_h gw3_e7_h 0 5e-14
cpar_gw3_e7_kd1 gw3_e7_kd1 0 5e-14
cpar_gw3_e7_knb gw3_e7_knb 0 5e-14
cpar_gw3_e7_ko1 gw3_e7_ko1 0 5e-14
cpar_gw3_e7_ktail gw3_e7_ktail 0 5e-14
cpar_gw3_e7_q gw3_e7_q 0 5e-14
cpar_gw3_e7_qb gw3_e7_qb 0 5e-14
cpar_gw3_e7_rec gw3_e7_rec 0 5e-14
cpar_gw3_e7_rt gw3_e7_rt 0 5e-14
cpar_gw3_e7_vm gw3_e7_vm 0 5e-14
cpar_gw3_e7_vmd gw3_e7_vmd 0 5e-14
cpar_gw3_e7_vms gw3_e7_vms 0 5e-14
cpar_gw3_e8_h gw3_e8_h 0 5e-14
cpar_gw3_e8_kd1 gw3_e8_kd1 0 5e-14
cpar_gw3_e8_knb gw3_e8_knb 0 5e-14
cpar_gw3_e8_ko1 gw3_e8_ko1 0 5e-14
cpar_gw3_e8_ktail gw3_e8_ktail 0 5e-14
cpar_gw3_e8_q gw3_e8_q 0 5e-14
cpar_gw3_e8_qb gw3_e8_qb 0 5e-14
cpar_gw3_e8_rec gw3_e8_rec 0 5e-14
cpar_gw3_e8_rt gw3_e8_rt 0 5e-14
cpar_gw3_e8_vm gw3_e8_vm 0 5e-14
cpar_gw3_e8_vmd gw3_e8_vmd 0 5e-14
cpar_gw3_e8_vms gw3_e8_vms 0 5e-14
cpar_gw3_e9_h gw3_e9_h 0 5e-14
cpar_gw3_e9_kd1 gw3_e9_kd1 0 5e-14
cpar_gw3_e9_knb gw3_e9_knb 0 5e-14
cpar_gw3_e9_ko1 gw3_e9_ko1 0 5e-14
cpar_gw3_e9_ktail gw3_e9_ktail 0 5e-14
cpar_gw3_e9_q gw3_e9_q 0 5e-14
cpar_gw3_e9_qb gw3_e9_qb 0 5e-14
cpar_gw3_e9_rec gw3_e9_rec 0 5e-14
cpar_gw3_e9_rt gw3_e9_rt 0 5e-14
cpar_gw3_e9_vm gw3_e9_vm 0 5e-14
cpar_gw3_e9_vmd gw3_e9_vmd 0 5e-14
cpar_gw3_e9_vms gw3_e9_vms 0 5e-14
cpar_gw3_gb gw3_gb 0 5e-14
cpar_gw3_op_ad gw3_op_ad 0 5e-14
cpar_gw3_op_adn gw3_op_adn 0 5e-14
cpar_gw3_op_an gw3_op_an 0 5e-14
cpar_gw3_op_aq gw3_op_aq 0 5e-14
cpar_gw3_op_aqb gw3_op_aqb 0 5e-14
cpar_gw3_op_at gw3_op_at 0 5e-14
cpar_gw3_op_gx gw3_op_gx 0 5e-14
cpar_gw3_op_p gw3_op_p 0 5e-14
cpar_gw3_op_pb gw3_op_pb 0 5e-14
cpar_gw3_op_tt gw3_op_tt 0 5e-14
cpar_hsw2_h1 hsw2_h1 0 5e-14
cpar_hsw2_sd hsw2_sd 0 5e-14
cpar_hsw3_h1 hsw3_h1 0 5e-14
cpar_hsw3_sd hsw3_sd 0 5e-14
cpar_hw2 hw2 0 5e-14
cpar_hw3 hw3 0 5e-14
cpar_ilim_n ilim_n 0 5e-14
cpar_ilimp_n ilimp_n 0 5e-14
cpar_iref_n iref_n 0 5e-14
cpar_irefp_n irefp_n 0 5e-14
cpar_istep_n istep_n 0 5e-14
va_cpar_load_neg_p load_neg cpar_load_neg_p 0
cpar_load_neg cpar_load_neg_p 0 5e-14
va_cpar_load_pos_p load_pos cpar_load_pos_p 0
cpar_load_pos cpar_load_pos_p 0 5e-14
cpar_por_hold por_hold 0 5e-14
cpar_por_ok por_ok 0 5e-14
cpar_porc porc 0 5e-14
cpar_porx porx 0 5e-14
cpar_s1_anb s1_anb 0 5e-14
cpar_s1_atl s1_atl 0 5e-14
cpar_s1_da s1_da 0 5e-14
cpar_s1_db s1_db 0 5e-14
cpar_s1_m s1_m 0 5e-14
cpar_s1_s s1_s 0 5e-14
cpar_s1_tl s1_tl 0 5e-14
cpar_s1_ya s1_ya 0 5e-14
cpar_s1_yb s1_yb 0 5e-14
cpar_s1_za s1_za 0 5e-14
cpar_s1_zb s1_zb 0 5e-14
cpar_s2_anb s2_anb 0 5e-14
cpar_s2_atl s2_atl 0 5e-14
cpar_s2_da s2_da 0 5e-14
cpar_s2_db s2_db 0 5e-14
cpar_s2_m s2_m 0 5e-14
cpar_s2_s s2_s 0 5e-14
cpar_s2_tl s2_tl 0 5e-14
cpar_s2_ya s2_ya 0 5e-14
cpar_s2_yb s2_yb 0 5e-14
cpar_s2_za s2_za 0 5e-14
cpar_s2_zb s2_zb 0 5e-14
cpar_s3_anb s3_anb 0 5e-14
cpar_s3_atl s3_atl 0 5e-14
cpar_s3_da s3_da 0 5e-14
cpar_s3_db s3_db 0 5e-14
cpar_s3_m s3_m 0 5e-14
cpar_s3_s s3_s 0 5e-14
cpar_s3_tl s3_tl 0 5e-14
cpar_s3_ya s3_ya 0 5e-14
cpar_s3_yb s3_yb 0 5e-14
cpar_s3_za s3_za 0 5e-14
cpar_s3_zb s3_zb 0 5e-14
cpar_s4_anb s4_anb 0 5e-14
cpar_s4_atl s4_atl 0 5e-14
cpar_s4_da s4_da 0 5e-14
cpar_s4_db s4_db 0 5e-14
cpar_s4_m s4_m 0 5e-14
cpar_s4_s s4_s 0 5e-14
cpar_s4_tl s4_tl 0 5e-14
cpar_s4_ya s4_ya 0 5e-14
cpar_s4_yb s4_yb 0 5e-14
cpar_s4_za s4_za 0 5e-14
cpar_s4_zb s4_zb 0 5e-14
cpar_sgw23f_h sgw23f_h 0 5e-14
cpar_sgw23f_kd1 sgw23f_kd1 0 5e-14
cpar_sgw23f_knb sgw23f_knb 0 5e-14
cpar_sgw23f_ko1 sgw23f_ko1 0 5e-14
cpar_sgw23f_ktail sgw23f_ktail 0 5e-14
cpar_sgw23f_op_ad sgw23f_op_ad 0 5e-14
cpar_sgw23f_op_adn sgw23f_op_adn 0 5e-14
cpar_sgw23f_op_an sgw23f_op_an 0 5e-14
cpar_sgw23f_op_aq sgw23f_op_aq 0 5e-14
cpar_sgw23f_op_aqb sgw23f_op_aqb 0 5e-14
cpar_sgw23f_op_at sgw23f_op_at 0 5e-14
cpar_sgw23f_op_gx sgw23f_op_gx 0 5e-14
cpar_sgw23f_op_p sgw23f_op_p 0 5e-14
cpar_sgw23f_op_pb sgw23f_op_pb 0 5e-14
cpar_sgw23f_op_tt sgw23f_op_tt 0 5e-14
cpar_sgw23f_ota_d1 sgw23f_ota_d1 0 5e-14
cpar_sgw23f_ota_nb sgw23f_ota_nb 0 5e-14
cpar_sgw23f_ota_tail sgw23f_ota_tail 0 5e-14
cpar_sgw23f_q sgw23f_q 0 5e-14
cpar_sgw23f_qb sgw23f_qb 0 5e-14
cpar_sgw23f_rec sgw23f_rec 0 5e-14
cpar_sgw23f_rt sgw23f_rt 0 5e-14
va_cpar_sgw23f_vm_p sgw23f_vm cpar_sgw23f_vm_p 0
cpar_sgw23f_vm cpar_sgw23f_vm_p 0 5e-14
va_cpar_sgw23f_vmd_p sgw23f_vmd cpar_sgw23f_vmd_p 0
cpar_sgw23f_vmd cpar_sgw23f_vmd_p 0 5e-14
va_cpar_sgw23f_vms_p sgw23f_vms cpar_sgw23f_vms_p 0
cpar_sgw23f_vms cpar_sgw23f_vms_p 0 5e-14
cpar_sgw23r_h sgw23r_h 0 5e-14
cpar_sgw23r_kd1 sgw23r_kd1 0 5e-14
cpar_sgw23r_knb sgw23r_knb 0 5e-14
cpar_sgw23r_ko1 sgw23r_ko1 0 5e-14
cpar_sgw23r_ktail sgw23r_ktail 0 5e-14
cpar_sgw23r_op_ad sgw23r_op_ad 0 5e-14
cpar_sgw23r_op_adn sgw23r_op_adn 0 5e-14
cpar_sgw23r_op_an sgw23r_op_an 0 5e-14
cpar_sgw23r_op_aq sgw23r_op_aq 0 5e-14
cpar_sgw23r_op_aqb sgw23r_op_aqb 0 5e-14
cpar_sgw23r_op_at sgw23r_op_at 0 5e-14
cpar_sgw23r_op_gx sgw23r_op_gx 0 5e-14
cpar_sgw23r_op_p sgw23r_op_p 0 5e-14
cpar_sgw23r_op_pb sgw23r_op_pb 0 5e-14
cpar_sgw23r_op_tt sgw23r_op_tt 0 5e-14
cpar_sgw23r_ota_d1 sgw23r_ota_d1 0 5e-14
cpar_sgw23r_ota_nb sgw23r_ota_nb 0 5e-14
cpar_sgw23r_ota_tail sgw23r_ota_tail 0 5e-14
cpar_sgw23r_q sgw23r_q 0 5e-14
cpar_sgw23r_qb sgw23r_qb 0 5e-14
cpar_sgw23r_rec sgw23r_rec 0 5e-14
cpar_sgw23r_rt sgw23r_rt 0 5e-14
va_cpar_sgw23r_vm_p sgw23r_vm cpar_sgw23r_vm_p 0
cpar_sgw23r_vm cpar_sgw23r_vm_p 0 5e-14
va_cpar_sgw23r_vmd_p sgw23r_vmd cpar_sgw23r_vmd_p 0
cpar_sgw23r_vmd cpar_sgw23r_vmd_p 0 5e-14
va_cpar_sgw23r_vms_p sgw23r_vms cpar_sgw23r_vms_p 0
cpar_sgw23r_vms cpar_sgw23r_vms_p 0 5e-14
cpar_spw1 spw1 0 5e-14
cpar_spw2 spw2 0 5e-14
cpar_spw3 spw3 0 5e-14
cpar_spw4 spw4 0 5e-14
cpar_spwi1_x spwi1_x 0 5e-14
cpar_spwi2_x spwi2_x 0 5e-14
cpar_spwi3_x spwi3_x 0 5e-14
cpar_spwi4_x spwi4_x 0 5e-14
cpar_spws12 spws12 0 5e-14
cpar_spws23 spws23 0 5e-14
cpar_spws34 spws34 0 5e-14
cpar_thw23f_h thw23f_h 0 5e-14
cpar_thw23f_kd1 thw23f_kd1 0 5e-14
cpar_thw23f_knb thw23f_knb 0 5e-14
cpar_thw23f_ko1 thw23f_ko1 0 5e-14
cpar_thw23f_ktail thw23f_ktail 0 5e-14
cpar_thw23f_mi thw23f_mi 0 5e-14
cpar_thw23f_op_ad thw23f_op_ad 0 5e-14
cpar_thw23f_op_adn thw23f_op_adn 0 5e-14
cpar_thw23f_op_an thw23f_op_an 0 5e-14
cpar_thw23f_op_aq thw23f_op_aq 0 5e-14
cpar_thw23f_op_aqb thw23f_op_aqb 0 5e-14
cpar_thw23f_op_at thw23f_op_at 0 5e-14
cpar_thw23f_op_gx thw23f_op_gx 0 5e-14
cpar_thw23f_op_p thw23f_op_p 0 5e-14
cpar_thw23f_op_pb thw23f_op_pb 0 5e-14
cpar_thw23f_op_tt thw23f_op_tt 0 5e-14
cpar_thw23f_q thw23f_q 0 5e-14
cpar_thw23f_qb thw23f_qb 0 5e-14
cpar_thw23f_rec thw23f_rec 0 5e-14
cpar_thw23f_rt thw23f_rt 0 5e-14
cpar_thw23f_st_x thw23f_st_x 0 5e-14
va_cpar_thw23f_vm_p thw23f_vm cpar_thw23f_vm_p 0
cpar_thw23f_vm cpar_thw23f_vm_p 0 5e-14
va_cpar_thw23f_vmd_p thw23f_vmd cpar_thw23f_vmd_p 0
cpar_thw23f_vmd cpar_thw23f_vmd_p 0 5e-14
va_cpar_thw23f_vms_p thw23f_vms cpar_thw23f_vms_p 0
cpar_thw23f_vms cpar_thw23f_vms_p 0 5e-14
cpar_thw23r_h thw23r_h 0 5e-14
cpar_thw23r_kd1 thw23r_kd1 0 5e-14
cpar_thw23r_knb thw23r_knb 0 5e-14
cpar_thw23r_ko1 thw23r_ko1 0 5e-14
cpar_thw23r_ktail thw23r_ktail 0 5e-14
cpar_thw23r_mi thw23r_mi 0 5e-14
cpar_thw23r_op_ad thw23r_op_ad 0 5e-14
cpar_thw23r_op_adn thw23r_op_adn 0 5e-14
cpar_thw23r_op_an thw23r_op_an 0 5e-14
cpar_thw23r_op_aq thw23r_op_aq 0 5e-14
cpar_thw23r_op_aqb thw23r_op_aqb 0 5e-14
cpar_thw23r_op_at thw23r_op_at 0 5e-14
cpar_thw23r_op_gx thw23r_op_gx 0 5e-14
cpar_thw23r_op_p thw23r_op_p 0 5e-14
cpar_thw23r_op_pb thw23r_op_pb 0 5e-14
cpar_thw23r_op_tt thw23r_op_tt 0 5e-14
cpar_thw23r_q thw23r_q 0 5e-14
cpar_thw23r_qb thw23r_qb 0 5e-14
cpar_thw23r_rec thw23r_rec 0 5e-14
cpar_thw23r_rt thw23r_rt 0 5e-14
cpar_thw23r_st_x thw23r_st_x 0 5e-14
va_cpar_thw23r_vm_p thw23r_vm cpar_thw23r_vm_p 0
cpar_thw23r_vm cpar_thw23r_vm_p 0 5e-14
va_cpar_thw23r_vmd_p thw23r_vmd cpar_thw23r_vmd_p 0
cpar_thw23r_vmd cpar_thw23r_vmd_p 0 5e-14
va_cpar_thw23r_vms_p thw23r_vms cpar_thw23r_vms_p 0
cpar_thw23r_vms cpar_thw23r_vms_p 0 5e-14
cpar_vdd vdd 0 5e-14
cpar_vmid vmid 0 5e-14
cpar_vrest vrest 0 5e-14
cpar_vthe vthe 0 5e-14
cpar_vthr vthr 0 5e-14
.options klu method=gear reltol=1e-5 abstol=1e-16
.save v(vdd) v(vrest) v(vmid) v(load_pos) v(load_neg) v(gw2_col_q) v(gw2_op_aq) v(gw2_op_p) v(hw2) v(gw3_col_q) v(gw3_op_aq) v(gw3_op_p) v(hw3) v(thw23f_vm) v(thw23f_q) v(thw23f_qb) v(thw23f_h) v(thw23f_rec) v(thw23f_vmd) v(thw23f_op_at) v(thw23f_op_aq) v(thw23f_op_p) v(sgw23f_vm) v(sgw23f_q) v(sgw23f_qb) v(sgw23f_h) v(sgw23f_rec) v(sgw23f_vmd) v(sgw23f_op_at) v(sgw23f_op_aq) v(sgw23f_op_p) v(cdw23f_vm) v(cdw23f_q) v(cdw23f_qb) v(cdw23f_h) v(cdw23f_rec) v(cdw23f_vmd) v(cdw23f_op_at) v(cdw23f_op_aq) v(cdw23f_op_p) v(cdw23f_hs) v(cdw23f_hc) v(thw23r_vm) v(thw23r_q) v(thw23r_qb) v(thw23r_h) v(thw23r_rec) v(thw23r_vmd) v(thw23r_op_at) v(thw23r_op_aq) v(thw23r_op_p) v(sgw23r_vm) v(sgw23r_q) v(sgw23r_qb) v(sgw23r_h) v(sgw23r_rec) v(sgw23r_vmd) v(sgw23r_op_at) v(sgw23r_op_aq) v(sgw23r_op_p) v(cdw23r_vm) v(cdw23r_q) v(cdw23r_qb) v(cdw23r_h) v(cdw23r_rec) v(cdw23r_vmd) v(cdw23r_op_at) v(cdw23r_op_aq) v(cdw23r_op_p) v(cdw23r_hs) v(cdw23r_hc) v(spw2) v(spw3) v(spws23) v(thw23f_vms) v(thw23r_vms) v(sgw23f_vms) v(sgw23r_vms) v(cdw23f_vms) v(cdw23r_vms) i(va_cthw23f_cm_p) i(va_rthw23f_rm_p) i(va_nthw23f_km1_g) i(va_nthw23f_dis_d) i(va_nthw23f_sh1_d) i(va_nthw23f_porm_d) i(va_nthw23f_rm_mo_d) i(va_cpar_thw23f_vm_p) i(va_nthw23f_dis_s) i(va_rthw23f_rdis_p) i(va_cpar_thw23f_vmd_p) i(va_nthw23f_sh1_s) i(va_nthw23f_sh2_d) i(va_cpar_thw23f_vms_p) i(va_cthw23r_cm_p) i(va_rthw23r_rm_p) i(va_nthw23r_km1_g) i(va_nthw23r_dis_d) i(va_nthw23r_sh1_d) i(va_nthw23r_porm_d) i(va_nthw23r_rm_mo_d) i(va_cpar_thw23r_vm_p) i(va_nthw23r_dis_s) i(va_rthw23r_rdis_p) i(va_cpar_thw23r_vmd_p) i(va_nthw23r_sh1_s) i(va_nthw23r_sh2_d) i(va_cpar_thw23r_vms_p) i(va_csgw23f_cm_p) i(va_rsgw23f_rm_p) i(va_nsgw23f_km1_g) i(va_nsgw23f_dis_d) i(va_nsgw23f_sh1_d) i(va_nsgw23f_porm_d) i(va_nsgw23f_ota_m2_d) i(va_nsgw23f_ota_m4_d) i(va_cpar_sgw23f_vm_p) i(va_nsgw23f_dis_s) i(va_rsgw23f_rdis_p) i(va_cpar_sgw23f_vmd_p) i(va_nsgw23f_sh1_s) i(va_nsgw23f_sh2_d) i(va_cpar_sgw23f_vms_p) i(va_csgw23r_cm_p) i(va_rsgw23r_rm_p) i(va_nsgw23r_km1_g) i(va_nsgw23r_dis_d) i(va_nsgw23r_sh1_d) i(va_nsgw23r_porm_d) i(va_nsgw23r_ota_m2_d) i(va_nsgw23r_ota_m4_d) i(va_cpar_sgw23r_vm_p) i(va_nsgw23r_dis_s) i(va_rsgw23r_rdis_p) i(va_cpar_sgw23r_vmd_p) i(va_nsgw23r_sh1_s) i(va_nsgw23r_sh2_d) i(va_cpar_sgw23r_vms_p) i(va_ccdw23f_cm_p) i(va_rcdw23f_rm_p) i(va_ncdw23f_km1_g) i(va_ncdw23f_dis_d) i(va_ncdw23f_sh1_d) i(va_ncdw23f_porm_d) i(va_ncdw23f_rm_mo_d) i(va_ncdw23f_kh_d) i(va_cpar_cdw23f_vm_p) i(va_ncdw23f_dis_s) i(va_rcdw23f_rdis_p) i(va_cpar_cdw23f_vmd_p) i(va_ncdw23f_sh1_s) i(va_ncdw23f_sh2_d) i(va_cpar_cdw23f_vms_p) i(va_ccdw23r_cm_p) i(va_rcdw23r_rm_p) i(va_ncdw23r_km1_g) i(va_ncdw23r_dis_d) i(va_ncdw23r_sh1_d) i(va_ncdw23r_porm_d) i(va_ncdw23r_rm_mo_d) i(va_ncdw23r_kh_d) i(va_cpar_cdw23r_vm_p) i(va_ncdw23r_dis_s) i(va_rcdw23r_rdis_p) i(va_cpar_cdw23r_vmd_p) i(va_ncdw23r_sh1_s) i(va_ncdw23r_sh2_d) i(va_cpar_cdw23r_vms_p) i(va_cldpos_p) i(va_rldpos_p) i(va_nagw23f_cp_d) i(va_cpar_load_pos_p) i(va_cldneg_p) i(va_rldneg_p) i(va_nagw23r_cp_d) i(va_cpar_load_neg_p) v(vsrc) i(vsrc)
.control
pre_osdi <OSDI>
set filetype=binary
tran 0.001 39.2 0 0.0005
write <RAW>
quit
.endc
.end

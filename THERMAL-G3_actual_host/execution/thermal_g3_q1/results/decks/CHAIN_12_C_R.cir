* THERMAL-G3-Q1-R CHAIN_12_C_R
.include <MODEL_LIB>
vsrc vsrc 0 PWL(0 0 0.02 3.0)
rint vsrc vdd 10
cdec vdd 0 1e-05
rvrestt vdd vrest 2000
rvrestb vrest 0 1000
cvrestc vrest 0 1e-05
rvthet vdd vthe 2000
rvtheb vthe 0 1800
cvthec vthe 0 1e-05
rvthrt vdd vthr 2400
rvthrb vthr 0 1500
cvthrc vthr 0 1e-05
rvmidt vdd vmid 2000
rvmidb vmid 0 2000
cvmidc vmid 0 1e-05
rporr vdd porc 2.2e+06
cporc porc 0 1e-06
rporra porc porx 1e+06
rporrf por_ok porx 4e+06
npori1p por_hold porx vdd vsrc pch W=2.4e-06 L=5e-07
npori1n por_hold porx 0 0 nch W=1.2e-06 L=5e-07
npori2p por_ok por_hold vdd vsrc pch W=2.4e-06 L=5e-07
npori2n por_ok por_hold 0 0 nch W=1.2e-06 L=5e-07
riref vdd iref_n 2.2e+06
nirefd iref_n iref_n 0 0 nch W=4e-06 L=4e-06
ristep vdd istep_n 5.6e+07
nistepd istep_n istep_n 0 0 nch W=4e-06 L=4e-06
nirefm irefp_n iref_n 0 0 nch W=4e-06 L=4e-06
nirefpd irefp_n irefp_n vdd vsrc pch W=4e-06 L=4e-06
rilim vdd ilim_n 1.85e+06
nilimd ilim_n ilim_n 0 0 nch W=4e-06 L=4e-06
nilimm ilimp_n ilim_n 0 0 nch W=4e-06 L=4e-06
nilimpd ilimp_n ilimp_n vdd vsrc pch W=4e-06 L=4e-06
bs1_te s1_te 0 V=(18.5+-3*(1/(1+exp(-(time-13.6)/0.05))-1/(1+exp(-(time-20.6)/0.05))))
vqes1 s1_te s1_tea DC 0
rs1_ge s1_tea s1_tp 500
cs1_cp s1_tp 0 0.01
rs1_gm s1_tp s1_tn 1000
cs1_cn s1_tn 0 0.0001
bs1_ntc vdd s1_s I=V(vdd,s1_s)/(100000*exp(4250*(1/(298.15+V(s1_tn))-1/298.15)))
bs1_heat 0 s1_th I=V(vdd,s1_s)*V(vdd,s1_s)/(100000*exp(4250*(1/(298.15+V(s1_tn))-1/298.15)))
vqhs1 s1_th s1_tn DC 0
rs1_rs s1_s 0 100000
rs1_ravg s1_s s1_m 2e+06
cs1_cavg s1_m 0 1e-06
ns1_mpor s1_m por_ok s1_s vsrc pch W=4e-06 L=1e-06
rs1_ab vdd s1_anb 750000
ns1_amb s1_anb s1_anb 0 0 nch W=4e-06 L=4e-06
ns1_amt s1_atl s1_anb 0 0 nch W=4e-06 L=4e-06
ns1_am1 s1_da s1_s s1_atl 0 nch W=1e-06 L=4e-06
ns1_am2 s1_db s1_m s1_atl 0 nch W=1e-06 L=4e-06
rs1_ara vdd s1_da 680000
rs1_arb vdd s1_db 680000
ns1_tt s1_tl ilim_n 0 0 nch W=4e-06 L=4e-06
ns1_ta s1_ya s1_db s1_tl 0 nch W=1e-05 L=2e-06
ns1_tb s1_yb s1_da s1_tl 0 nch W=1e-05 L=2e-06
ns1_la s1_ya s1_ya vdd vsrc pch W=4e-06 L=4e-06
ns1_lb s1_yb s1_yb vdd vsrc pch W=4e-06 L=4e-06
ns1_ca s1_za s1_ya vdd vsrc pch W=4e-06 L=4e-06
ns1_na s1_za s1_za 0 0 nch W=4e-06 L=4e-06
ns1_cb s1_zb s1_yb vdd vsrc pch W=4e-06 L=4e-06
ns1_nb s1_zb s1_zb 0 0 nch W=4e-06 L=4e-06
bs2_te s2_te 0 V=(18.5+-3*(1/(1+exp(-(time-10.6)/0.05))-1/(1+exp(-(time-17.6)/0.05))))
vqes2 s2_te s2_tea DC 0
rs2_ge s2_tea s2_tp 500
cs2_cp s2_tp 0 0.01
rs2_gm s2_tp s2_tn 1000
cs2_cn s2_tn 0 0.0001
bs2_ntc vdd s2_s I=V(vdd,s2_s)/(100000*exp(4250*(1/(298.15+V(s2_tn))-1/298.15)))
bs2_heat 0 s2_th I=V(vdd,s2_s)*V(vdd,s2_s)/(100000*exp(4250*(1/(298.15+V(s2_tn))-1/298.15)))
vqhs2 s2_th s2_tn DC 0
rs2_rs s2_s 0 100000
rs2_ravg s2_s s2_m 2e+06
cs2_cavg s2_m 0 1e-06
ns2_mpor s2_m por_ok s2_s vsrc pch W=4e-06 L=1e-06
rs2_ab vdd s2_anb 750000
ns2_amb s2_anb s2_anb 0 0 nch W=4e-06 L=4e-06
ns2_amt s2_atl s2_anb 0 0 nch W=4e-06 L=4e-06
ns2_am1 s2_da s2_s s2_atl 0 nch W=1e-06 L=4e-06
ns2_am2 s2_db s2_m s2_atl 0 nch W=1e-06 L=4e-06
rs2_ara vdd s2_da 680000
rs2_arb vdd s2_db 680000
ns2_tt s2_tl ilim_n 0 0 nch W=4e-06 L=4e-06
ns2_ta s2_ya s2_db s2_tl 0 nch W=1e-05 L=2e-06
ns2_tb s2_yb s2_da s2_tl 0 nch W=1e-05 L=2e-06
ns2_la s2_ya s2_ya vdd vsrc pch W=4e-06 L=4e-06
ns2_lb s2_yb s2_yb vdd vsrc pch W=4e-06 L=4e-06
ns2_ca s2_za s2_ya vdd vsrc pch W=4e-06 L=4e-06
ns2_na s2_za s2_za 0 0 nch W=4e-06 L=4e-06
ns2_cb s2_zb s2_yb vdd vsrc pch W=4e-06 L=4e-06
ns2_nb s2_zb s2_zb 0 0 nch W=4e-06 L=4e-06
bs3_te s3_te 0 V=18.5
vqes3 s3_te s3_tea DC 0
rs3_ge s3_tea s3_tp 500
cs3_cp s3_tp 0 0.01
rs3_gm s3_tp s3_tn 1000
cs3_cn s3_tn 0 0.0001
bs3_ntc vdd s3_s I=V(vdd,s3_s)/(100000*exp(4250*(1/(298.15+V(s3_tn))-1/298.15)))
bs3_heat 0 s3_th I=V(vdd,s3_s)*V(vdd,s3_s)/(100000*exp(4250*(1/(298.15+V(s3_tn))-1/298.15)))
vqhs3 s3_th s3_tn DC 0
rs3_rs s3_s 0 100000
rs3_ravg s3_s s3_m 2e+06
cs3_cavg s3_m 0 1e-06
ns3_mpor s3_m por_ok s3_s vsrc pch W=4e-06 L=1e-06
rs3_ab vdd s3_anb 750000
ns3_amb s3_anb s3_anb 0 0 nch W=4e-06 L=4e-06
ns3_amt s3_atl s3_anb 0 0 nch W=4e-06 L=4e-06
ns3_am1 s3_da s3_s s3_atl 0 nch W=1e-06 L=4e-06
ns3_am2 s3_db s3_m s3_atl 0 nch W=1e-06 L=4e-06
rs3_ara vdd s3_da 680000
rs3_arb vdd s3_db 680000
ns3_tt s3_tl ilim_n 0 0 nch W=4e-06 L=4e-06
ns3_ta s3_ya s3_db s3_tl 0 nch W=1e-05 L=2e-06
ns3_tb s3_yb s3_da s3_tl 0 nch W=1e-05 L=2e-06
ns3_la s3_ya s3_ya vdd vsrc pch W=4e-06 L=4e-06
ns3_lb s3_yb s3_yb vdd vsrc pch W=4e-06 L=4e-06
ns3_ca s3_za s3_ya vdd vsrc pch W=4e-06 L=4e-06
ns3_na s3_za s3_za 0 0 nch W=4e-06 L=4e-06
ns3_cb s3_zb s3_yb vdd vsrc pch W=4e-06 L=4e-06
ns3_nb s3_zb s3_zb 0 0 nch W=4e-06 L=4e-06
bs4_te s4_te 0 V=18.5
vqes4 s4_te s4_tea DC 0
rs4_ge s4_tea s4_tp 500
cs4_cp s4_tp 0 0.01
rs4_gm s4_tp s4_tn 1000
cs4_cn s4_tn 0 0.0001
bs4_ntc vdd s4_s I=V(vdd,s4_s)/(100000*exp(4250*(1/(298.15+V(s4_tn))-1/298.15)))
bs4_heat 0 s4_th I=V(vdd,s4_s)*V(vdd,s4_s)/(100000*exp(4250*(1/(298.15+V(s4_tn))-1/298.15)))
vqhs4 s4_th s4_tn DC 0
rs4_rs s4_s 0 100000
rs4_ravg s4_s s4_m 2e+06
cs4_cavg s4_m 0 1e-06
ns4_mpor s4_m por_ok s4_s vsrc pch W=4e-06 L=1e-06
rs4_ab vdd s4_anb 750000
ns4_amb s4_anb s4_anb 0 0 nch W=4e-06 L=4e-06
ns4_amt s4_atl s4_anb 0 0 nch W=4e-06 L=4e-06
ns4_am1 s4_da s4_s s4_atl 0 nch W=1e-06 L=4e-06
ns4_am2 s4_db s4_m s4_atl 0 nch W=1e-06 L=4e-06
rs4_ara vdd s4_da 680000
rs4_arb vdd s4_db 680000
ns4_tt s4_tl ilim_n 0 0 nch W=4e-06 L=4e-06
ns4_ta s4_ya s4_db s4_tl 0 nch W=1e-05 L=2e-06
ns4_tb s4_yb s4_da s4_tl 0 nch W=1e-05 L=2e-06
ns4_la s4_ya s4_ya vdd vsrc pch W=4e-06 L=4e-06
ns4_lb s4_yb s4_yb vdd vsrc pch W=4e-06 L=4e-06
ns4_ca s4_za s4_ya vdd vsrc pch W=4e-06 L=4e-06
ns4_na s4_za s4_za 0 0 nch W=4e-06 L=4e-06
ns4_cb s4_zb s4_yb vdd vsrc pch W=4e-06 L=4e-06
ns4_nb s4_zb s4_zb 0 0 nch W=4e-06 L=4e-06
cgc1_e1_cm gc1_e1_vm 0 1e-07
rgc1_e1_rm gc1_e1_vm vrest 1e+06
ngc1_e1_bias0 gc1_e1_vm istep_n 0 0 nch W=4e-06 L=4e-06
rgc1_e1_kb vdd gc1_e1_knb 1e+06
ngc1_e1_kmb gc1_e1_knb gc1_e1_knb 0 0 nch W=4e-06 L=4e-06
ngc1_e1_kmt gc1_e1_ktail gc1_e1_knb 0 0 nch W=4e-06 L=4e-06
ngc1_e1_km1 gc1_e1_kd1 gc1_e1_vm gc1_e1_ktail 0 nch W=4e-06 L=4e-06
ngc1_e1_km2 gc1_e1_ko1 gc1_e1_h gc1_e1_ktail 0 nch W=4e-06 L=4e-06
ngc1_e1_km3 gc1_e1_kd1 gc1_e1_kd1 vdd vsrc pch W=4e-06 L=4e-06
ngc1_e1_km4 gc1_e1_ko1 gc1_e1_kd1 vdd vsrc pch W=4e-06 L=4e-06
ngc1_e1_ki1p gc1_e1_qb gc1_e1_ko1 vdd vsrc pch W=2.4e-06 L=5e-07
ngc1_e1_ki1n gc1_e1_qb gc1_e1_ko1 0 0 nch W=1.2e-06 L=5e-07
ngc1_e1_ki2p gc1_e1_q gc1_e1_qb vdd vsrc pch W=2.4e-06 L=5e-07
ngc1_e1_ki2n gc1_e1_q gc1_e1_qb 0 0 nch W=1.2e-06 L=5e-07
rgc1_e1_hra gc1_e1_h vthe 1e+06
rgc1_e1_hrf gc1_e1_h gc1_e1_qb 1.9e+07
cgc1_e1_hc gc1_e1_h 0 2.1e-09
ngc1_e1_dis gc1_e1_vm gc1_e1_q gc1_e1_vmd 0 nch W=4e-06 L=1e-06
rgc1_e1_rdis gc1_e1_vmd vrest 220000
ngc1_e1_rp gc1_e1_rt gc1_e1_qb vdd vsrc pch W=2e-06 L=1e-06
rgc1_e1_rrc gc1_e1_rt gc1_e1_rec 10000
cgc1_e1_rc gc1_e1_rec 0 1e-07
rgc1_e1_rr gc1_e1_rec 0 8.2e+06
ngc1_e1_sh1 gc1_e1_vm gc1_e1_rec gc1_e1_vms 0 nch W=2e-06 L=1e-06
ngc1_e1_sh2 gc1_e1_vms gc1_e1_qb vrest 0 nch W=2e-06 L=1e-06
ngc1_e1_porh gc1_e1_h por_hold vthe 0 nch W=2e-06 L=1e-06
ngc1_e1_porm gc1_e1_vm por_hold vrest 0 nch W=2e-06 L=1e-06
ngc1_e1_ip gc1_e1_vm s1_yb vdd vsrc pch W=4e-06 L=4e-06
ngc1_e1_in gc1_e1_vm s1_za 0 0 nch W=4e-06 L=4e-06
ngc1_b1_sw gc1_b1_t gc1_e1_qb vdd vsrc pch W=2e-06 L=1e-06
rgc1_b1_rc gc1_b1_t gc1_b1 10000
cgc1_b1_c gc1_b1 0 1e-07
rgc1_b1_rl gc1_b1 0 2.2e+07
ngc1_b1_sh1p gc1_b1_n gc1_b1 vdd vsrc pch W=2.4e-06 L=5e-07
ngc1_b1_sh1n gc1_b1_n gc1_b1 0 0 nch W=1.2e-06 L=5e-07
ngc1_b1_sh2p gc1_b1_q gc1_b1_n vdd vsrc pch W=2.4e-06 L=5e-07
ngc1_b1_sh2n gc1_b1_q gc1_b1_n 0 0 nch W=1.2e-06 L=5e-07
cgc1_e2_cm gc1_e2_vm 0 1e-07
rgc1_e2_rm gc1_e2_vm vrest 1e+06
ngc1_e2_bias0 gc1_e2_vm istep_n 0 0 nch W=4e-06 L=4e-06
ngc1_e2_bias1 gc1_e2_vm istep_n 0 0 nch W=4e-06 L=4e-06
rgc1_e2_kb vdd gc1_e2_knb 1e+06
ngc1_e2_kmb gc1_e2_knb gc1_e2_knb 0 0 nch W=4e-06 L=4e-06
ngc1_e2_kmt gc1_e2_ktail gc1_e2_knb 0 0 nch W=4e-06 L=4e-06
ngc1_e2_km1 gc1_e2_kd1 gc1_e2_vm gc1_e2_ktail 0 nch W=4e-06 L=4e-06
ngc1_e2_km2 gc1_e2_ko1 gc1_e2_h gc1_e2_ktail 0 nch W=4e-06 L=4e-06
ngc1_e2_km3 gc1_e2_kd1 gc1_e2_kd1 vdd vsrc pch W=4e-06 L=4e-06
ngc1_e2_km4 gc1_e2_ko1 gc1_e2_kd1 vdd vsrc pch W=4e-06 L=4e-06
ngc1_e2_ki1p gc1_e2_qb gc1_e2_ko1 vdd vsrc pch W=2.4e-06 L=5e-07
ngc1_e2_ki1n gc1_e2_qb gc1_e2_ko1 0 0 nch W=1.2e-06 L=5e-07
ngc1_e2_ki2p gc1_e2_q gc1_e2_qb vdd vsrc pch W=2.4e-06 L=5e-07
ngc1_e2_ki2n gc1_e2_q gc1_e2_qb 0 0 nch W=1.2e-06 L=5e-07
rgc1_e2_hra gc1_e2_h vthe 1e+06
rgc1_e2_hrf gc1_e2_h gc1_e2_qb 1.9e+07
cgc1_e2_hc gc1_e2_h 0 2.1e-09
ngc1_e2_dis gc1_e2_vm gc1_e2_q gc1_e2_vmd 0 nch W=4e-06 L=1e-06
rgc1_e2_rdis gc1_e2_vmd vrest 220000
ngc1_e2_rp gc1_e2_rt gc1_e2_qb vdd vsrc pch W=2e-06 L=1e-06
rgc1_e2_rrc gc1_e2_rt gc1_e2_rec 10000
cgc1_e2_rc gc1_e2_rec 0 1e-07
rgc1_e2_rr gc1_e2_rec 0 8.2e+06
ngc1_e2_sh1 gc1_e2_vm gc1_e2_rec gc1_e2_vms 0 nch W=2e-06 L=1e-06
ngc1_e2_sh2 gc1_e2_vms gc1_e2_qb vrest 0 nch W=2e-06 L=1e-06
ngc1_e2_porh gc1_e2_h por_hold vthe 0 nch W=2e-06 L=1e-06
ngc1_e2_porm gc1_e2_vm por_hold vrest 0 nch W=2e-06 L=1e-06
ngc1_e2_ip gc1_e2_vm s1_yb vdd vsrc pch W=4e-06 L=4e-06
ngc1_e2_in gc1_e2_vm s1_za 0 0 nch W=4e-06 L=4e-06
ngc1_b2_sw gc1_b2_t gc1_e2_qb vdd vsrc pch W=2e-06 L=1e-06
rgc1_b2_rc gc1_b2_t gc1_b2 10000
cgc1_b2_c gc1_b2 0 1e-07
rgc1_b2_rl gc1_b2 0 2.2e+07
ngc1_b2_sh1p gc1_b2_n gc1_b2 vdd vsrc pch W=2.4e-06 L=5e-07
ngc1_b2_sh1n gc1_b2_n gc1_b2 0 0 nch W=1.2e-06 L=5e-07
ngc1_b2_sh2p gc1_b2_q gc1_b2_n vdd vsrc pch W=2.4e-06 L=5e-07
ngc1_b2_sh2n gc1_b2_q gc1_b2_n 0 0 nch W=1.2e-06 L=5e-07
cgc1_e3_cm gc1_e3_vm 0 1e-07
rgc1_e3_rm gc1_e3_vm vrest 1e+06
ngc1_e3_bias0 gc1_e3_vm istep_n 0 0 nch W=4e-06 L=4e-06
ngc1_e3_bias1 gc1_e3_vm istep_n 0 0 nch W=4e-06 L=4e-06
ngc1_e3_bias2 gc1_e3_vm istep_n 0 0 nch W=4e-06 L=4e-06
rgc1_e3_kb vdd gc1_e3_knb 1e+06
ngc1_e3_kmb gc1_e3_knb gc1_e3_knb 0 0 nch W=4e-06 L=4e-06
ngc1_e3_kmt gc1_e3_ktail gc1_e3_knb 0 0 nch W=4e-06 L=4e-06
ngc1_e3_km1 gc1_e3_kd1 gc1_e3_vm gc1_e3_ktail 0 nch W=4e-06 L=4e-06
ngc1_e3_km2 gc1_e3_ko1 gc1_e3_h gc1_e3_ktail 0 nch W=4e-06 L=4e-06
ngc1_e3_km3 gc1_e3_kd1 gc1_e3_kd1 vdd vsrc pch W=4e-06 L=4e-06
ngc1_e3_km4 gc1_e3_ko1 gc1_e3_kd1 vdd vsrc pch W=4e-06 L=4e-06
ngc1_e3_ki1p gc1_e3_qb gc1_e3_ko1 vdd vsrc pch W=2.4e-06 L=5e-07
ngc1_e3_ki1n gc1_e3_qb gc1_e3_ko1 0 0 nch W=1.2e-06 L=5e-07
ngc1_e3_ki2p gc1_e3_q gc1_e3_qb vdd vsrc pch W=2.4e-06 L=5e-07
ngc1_e3_ki2n gc1_e3_q gc1_e3_qb 0 0 nch W=1.2e-06 L=5e-07
rgc1_e3_hra gc1_e3_h vthe 1e+06
rgc1_e3_hrf gc1_e3_h gc1_e3_qb 1.9e+07
cgc1_e3_hc gc1_e3_h 0 2.1e-09
ngc1_e3_dis gc1_e3_vm gc1_e3_q gc1_e3_vmd 0 nch W=4e-06 L=1e-06
rgc1_e3_rdis gc1_e3_vmd vrest 220000
ngc1_e3_rp gc1_e3_rt gc1_e3_qb vdd vsrc pch W=2e-06 L=1e-06
rgc1_e3_rrc gc1_e3_rt gc1_e3_rec 10000
cgc1_e3_rc gc1_e3_rec 0 1e-07
rgc1_e3_rr gc1_e3_rec 0 8.2e+06
ngc1_e3_sh1 gc1_e3_vm gc1_e3_rec gc1_e3_vms 0 nch W=2e-06 L=1e-06
ngc1_e3_sh2 gc1_e3_vms gc1_e3_qb vrest 0 nch W=2e-06 L=1e-06
ngc1_e3_porh gc1_e3_h por_hold vthe 0 nch W=2e-06 L=1e-06
ngc1_e3_porm gc1_e3_vm por_hold vrest 0 nch W=2e-06 L=1e-06
ngc1_e3_ip gc1_e3_vm s1_yb vdd vsrc pch W=4e-06 L=4e-06
ngc1_e3_in gc1_e3_vm s1_za 0 0 nch W=4e-06 L=4e-06
ngc1_b3_sw gc1_b3_t gc1_e3_qb vdd vsrc pch W=2e-06 L=1e-06
rgc1_b3_rc gc1_b3_t gc1_b3 10000
cgc1_b3_c gc1_b3 0 1e-07
rgc1_b3_rl gc1_b3 0 2.2e+07
ngc1_b3_sh1p gc1_b3_n gc1_b3 vdd vsrc pch W=2.4e-06 L=5e-07
ngc1_b3_sh1n gc1_b3_n gc1_b3 0 0 nch W=1.2e-06 L=5e-07
ngc1_b3_sh2p gc1_b3_q gc1_b3_n vdd vsrc pch W=2.4e-06 L=5e-07
ngc1_b3_sh2n gc1_b3_q gc1_b3_n 0 0 nch W=1.2e-06 L=5e-07
cgc1_e4_cm gc1_e4_vm 0 1e-07
rgc1_e4_rm gc1_e4_vm vrest 1e+06
ngc1_e4_bias0 gc1_e4_vm istep_n 0 0 nch W=4e-06 L=4e-06
ngc1_e4_bias1 gc1_e4_vm istep_n 0 0 nch W=4e-06 L=4e-06
ngc1_e4_bias2 gc1_e4_vm istep_n 0 0 nch W=4e-06 L=4e-06
ngc1_e4_bias3 gc1_e4_vm istep_n 0 0 nch W=4e-06 L=4e-06
rgc1_e4_kb vdd gc1_e4_knb 1e+06
ngc1_e4_kmb gc1_e4_knb gc1_e4_knb 0 0 nch W=4e-06 L=4e-06
ngc1_e4_kmt gc1_e4_ktail gc1_e4_knb 0 0 nch W=4e-06 L=4e-06
ngc1_e4_km1 gc1_e4_kd1 gc1_e4_vm gc1_e4_ktail 0 nch W=4e-06 L=4e-06
ngc1_e4_km2 gc1_e4_ko1 gc1_e4_h gc1_e4_ktail 0 nch W=4e-06 L=4e-06
ngc1_e4_km3 gc1_e4_kd1 gc1_e4_kd1 vdd vsrc pch W=4e-06 L=4e-06
ngc1_e4_km4 gc1_e4_ko1 gc1_e4_kd1 vdd vsrc pch W=4e-06 L=4e-06
ngc1_e4_ki1p gc1_e4_qb gc1_e4_ko1 vdd vsrc pch W=2.4e-06 L=5e-07
ngc1_e4_ki1n gc1_e4_qb gc1_e4_ko1 0 0 nch W=1.2e-06 L=5e-07
ngc1_e4_ki2p gc1_e4_q gc1_e4_qb vdd vsrc pch W=2.4e-06 L=5e-07
ngc1_e4_ki2n gc1_e4_q gc1_e4_qb 0 0 nch W=1.2e-06 L=5e-07
rgc1_e4_hra gc1_e4_h vthe 1e+06
rgc1_e4_hrf gc1_e4_h gc1_e4_qb 1.9e+07
cgc1_e4_hc gc1_e4_h 0 2.1e-09
ngc1_e4_dis gc1_e4_vm gc1_e4_q gc1_e4_vmd 0 nch W=4e-06 L=1e-06
rgc1_e4_rdis gc1_e4_vmd vrest 220000
ngc1_e4_rp gc1_e4_rt gc1_e4_qb vdd vsrc pch W=2e-06 L=1e-06
rgc1_e4_rrc gc1_e4_rt gc1_e4_rec 10000
cgc1_e4_rc gc1_e4_rec 0 1e-07
rgc1_e4_rr gc1_e4_rec 0 8.2e+06
ngc1_e4_sh1 gc1_e4_vm gc1_e4_rec gc1_e4_vms 0 nch W=2e-06 L=1e-06
ngc1_e4_sh2 gc1_e4_vms gc1_e4_qb vrest 0 nch W=2e-06 L=1e-06
ngc1_e4_porh gc1_e4_h por_hold vthe 0 nch W=2e-06 L=1e-06
ngc1_e4_porm gc1_e4_vm por_hold vrest 0 nch W=2e-06 L=1e-06
ngc1_e4_ip gc1_e4_vm s1_yb vdd vsrc pch W=4e-06 L=4e-06
ngc1_e4_in gc1_e4_vm s1_za 0 0 nch W=4e-06 L=4e-06
ngc1_b4_sw gc1_b4_t gc1_e4_qb vdd vsrc pch W=2e-06 L=1e-06
rgc1_b4_rc gc1_b4_t gc1_b4 10000
cgc1_b4_c gc1_b4 0 1e-07
rgc1_b4_rl gc1_b4 0 2.2e+07
ngc1_b4_sh1p gc1_b4_n gc1_b4 vdd vsrc pch W=2.4e-06 L=5e-07
ngc1_b4_sh1n gc1_b4_n gc1_b4 0 0 nch W=1.2e-06 L=5e-07
ngc1_b4_sh2p gc1_b4_q gc1_b4_n vdd vsrc pch W=2.4e-06 L=5e-07
ngc1_b4_sh2n gc1_b4_q gc1_b4_n 0 0 nch W=1.2e-06 L=5e-07
cgc1_e5_cm gc1_e5_vm 0 1e-07
rgc1_e5_rm gc1_e5_vm vrest 1e+06
ngc1_e5_bias0 gc1_e5_vm istep_n 0 0 nch W=4e-06 L=4e-06
ngc1_e5_bias1 gc1_e5_vm istep_n 0 0 nch W=4e-06 L=4e-06
ngc1_e5_bias2 gc1_e5_vm istep_n 0 0 nch W=4e-06 L=4e-06
ngc1_e5_bias3 gc1_e5_vm istep_n 0 0 nch W=4e-06 L=4e-06
ngc1_e5_bias4 gc1_e5_vm istep_n 0 0 nch W=4e-06 L=4e-06
rgc1_e5_kb vdd gc1_e5_knb 1e+06
ngc1_e5_kmb gc1_e5_knb gc1_e5_knb 0 0 nch W=4e-06 L=4e-06
ngc1_e5_kmt gc1_e5_ktail gc1_e5_knb 0 0 nch W=4e-06 L=4e-06
ngc1_e5_km1 gc1_e5_kd1 gc1_e5_vm gc1_e5_ktail 0 nch W=4e-06 L=4e-06
ngc1_e5_km2 gc1_e5_ko1 gc1_e5_h gc1_e5_ktail 0 nch W=4e-06 L=4e-06
ngc1_e5_km3 gc1_e5_kd1 gc1_e5_kd1 vdd vsrc pch W=4e-06 L=4e-06
ngc1_e5_km4 gc1_e5_ko1 gc1_e5_kd1 vdd vsrc pch W=4e-06 L=4e-06
ngc1_e5_ki1p gc1_e5_qb gc1_e5_ko1 vdd vsrc pch W=2.4e-06 L=5e-07
ngc1_e5_ki1n gc1_e5_qb gc1_e5_ko1 0 0 nch W=1.2e-06 L=5e-07
ngc1_e5_ki2p gc1_e5_q gc1_e5_qb vdd vsrc pch W=2.4e-06 L=5e-07
ngc1_e5_ki2n gc1_e5_q gc1_e5_qb 0 0 nch W=1.2e-06 L=5e-07
rgc1_e5_hra gc1_e5_h vthe 1e+06
rgc1_e5_hrf gc1_e5_h gc1_e5_qb 1.9e+07
cgc1_e5_hc gc1_e5_h 0 2.1e-09
ngc1_e5_dis gc1_e5_vm gc1_e5_q gc1_e5_vmd 0 nch W=4e-06 L=1e-06
rgc1_e5_rdis gc1_e5_vmd vrest 220000
ngc1_e5_rp gc1_e5_rt gc1_e5_qb vdd vsrc pch W=2e-06 L=1e-06
rgc1_e5_rrc gc1_e5_rt gc1_e5_rec 10000
cgc1_e5_rc gc1_e5_rec 0 1e-07
rgc1_e5_rr gc1_e5_rec 0 8.2e+06
ngc1_e5_sh1 gc1_e5_vm gc1_e5_rec gc1_e5_vms 0 nch W=2e-06 L=1e-06
ngc1_e5_sh2 gc1_e5_vms gc1_e5_qb vrest 0 nch W=2e-06 L=1e-06
ngc1_e5_porh gc1_e5_h por_hold vthe 0 nch W=2e-06 L=1e-06
ngc1_e5_porm gc1_e5_vm por_hold vrest 0 nch W=2e-06 L=1e-06
ngc1_e5_ip gc1_e5_vm s1_yb vdd vsrc pch W=4e-06 L=4e-06
ngc1_e5_in gc1_e5_vm s1_za 0 0 nch W=4e-06 L=4e-06
ngc1_b5_sw gc1_b5_t gc1_e5_qb vdd vsrc pch W=2e-06 L=1e-06
rgc1_b5_rc gc1_b5_t gc1_b5 10000
cgc1_b5_c gc1_b5 0 1e-07
rgc1_b5_rl gc1_b5 0 2.2e+07
ngc1_b5_sh1p gc1_b5_n gc1_b5 vdd vsrc pch W=2.4e-06 L=5e-07
ngc1_b5_sh1n gc1_b5_n gc1_b5 0 0 nch W=1.2e-06 L=5e-07
ngc1_b5_sh2p gc1_b5_q gc1_b5_n vdd vsrc pch W=2.4e-06 L=5e-07
ngc1_b5_sh2n gc1_b5_q gc1_b5_n 0 0 nch W=1.2e-06 L=5e-07
cgc1_e6_cm gc1_e6_vm 0 1e-07
rgc1_e6_rm gc1_e6_vm vrest 1e+06
ngc1_e6_bias0 gc1_e6_vm istep_n 0 0 nch W=4e-06 L=4e-06
ngc1_e6_bias1 gc1_e6_vm istep_n 0 0 nch W=4e-06 L=4e-06
ngc1_e6_bias2 gc1_e6_vm istep_n 0 0 nch W=4e-06 L=4e-06
ngc1_e6_bias3 gc1_e6_vm istep_n 0 0 nch W=4e-06 L=4e-06
ngc1_e6_bias4 gc1_e6_vm istep_n 0 0 nch W=4e-06 L=4e-06
ngc1_e6_bias5 gc1_e6_vm istep_n 0 0 nch W=4e-06 L=4e-06
rgc1_e6_kb vdd gc1_e6_knb 1e+06
ngc1_e6_kmb gc1_e6_knb gc1_e6_knb 0 0 nch W=4e-06 L=4e-06
ngc1_e6_kmt gc1_e6_ktail gc1_e6_knb 0 0 nch W=4e-06 L=4e-06
ngc1_e6_km1 gc1_e6_kd1 gc1_e6_vm gc1_e6_ktail 0 nch W=4e-06 L=4e-06
ngc1_e6_km2 gc1_e6_ko1 gc1_e6_h gc1_e6_ktail 0 nch W=4e-06 L=4e-06
ngc1_e6_km3 gc1_e6_kd1 gc1_e6_kd1 vdd vsrc pch W=4e-06 L=4e-06
ngc1_e6_km4 gc1_e6_ko1 gc1_e6_kd1 vdd vsrc pch W=4e-06 L=4e-06
ngc1_e6_ki1p gc1_e6_qb gc1_e6_ko1 vdd vsrc pch W=2.4e-06 L=5e-07
ngc1_e6_ki1n gc1_e6_qb gc1_e6_ko1 0 0 nch W=1.2e-06 L=5e-07
ngc1_e6_ki2p gc1_e6_q gc1_e6_qb vdd vsrc pch W=2.4e-06 L=5e-07
ngc1_e6_ki2n gc1_e6_q gc1_e6_qb 0 0 nch W=1.2e-06 L=5e-07
rgc1_e6_hra gc1_e6_h vthe 1e+06
rgc1_e6_hrf gc1_e6_h gc1_e6_qb 1.9e+07
cgc1_e6_hc gc1_e6_h 0 2.1e-09
ngc1_e6_dis gc1_e6_vm gc1_e6_q gc1_e6_vmd 0 nch W=4e-06 L=1e-06
rgc1_e6_rdis gc1_e6_vmd vrest 220000
ngc1_e6_rp gc1_e6_rt gc1_e6_qb vdd vsrc pch W=2e-06 L=1e-06
rgc1_e6_rrc gc1_e6_rt gc1_e6_rec 10000
cgc1_e6_rc gc1_e6_rec 0 1e-07
rgc1_e6_rr gc1_e6_rec 0 8.2e+06
ngc1_e6_sh1 gc1_e6_vm gc1_e6_rec gc1_e6_vms 0 nch W=2e-06 L=1e-06
ngc1_e6_sh2 gc1_e6_vms gc1_e6_qb vrest 0 nch W=2e-06 L=1e-06
ngc1_e6_porh gc1_e6_h por_hold vthe 0 nch W=2e-06 L=1e-06
ngc1_e6_porm gc1_e6_vm por_hold vrest 0 nch W=2e-06 L=1e-06
ngc1_e6_ip gc1_e6_vm s1_yb vdd vsrc pch W=4e-06 L=4e-06
ngc1_e6_in gc1_e6_vm s1_za 0 0 nch W=4e-06 L=4e-06
ngc1_b6_sw gc1_b6_t gc1_e6_qb vdd vsrc pch W=2e-06 L=1e-06
rgc1_b6_rc gc1_b6_t gc1_b6 10000
cgc1_b6_c gc1_b6 0 1e-07
rgc1_b6_rl gc1_b6 0 2.2e+07
ngc1_b6_sh1p gc1_b6_n gc1_b6 vdd vsrc pch W=2.4e-06 L=5e-07
ngc1_b6_sh1n gc1_b6_n gc1_b6 0 0 nch W=1.2e-06 L=5e-07
ngc1_b6_sh2p gc1_b6_q gc1_b6_n vdd vsrc pch W=2.4e-06 L=5e-07
ngc1_b6_sh2n gc1_b6_q gc1_b6_n 0 0 nch W=1.2e-06 L=5e-07
cgc1_e7_cm gc1_e7_vm 0 1e-07
rgc1_e7_rm gc1_e7_vm vrest 1e+06
ngc1_e7_bias0 gc1_e7_vm istep_n 0 0 nch W=4e-06 L=4e-06
ngc1_e7_bias1 gc1_e7_vm istep_n 0 0 nch W=4e-06 L=4e-06
ngc1_e7_bias2 gc1_e7_vm istep_n 0 0 nch W=4e-06 L=4e-06
ngc1_e7_bias3 gc1_e7_vm istep_n 0 0 nch W=4e-06 L=4e-06
ngc1_e7_bias4 gc1_e7_vm istep_n 0 0 nch W=4e-06 L=4e-06
ngc1_e7_bias5 gc1_e7_vm istep_n 0 0 nch W=4e-06 L=4e-06
ngc1_e7_bias6 gc1_e7_vm istep_n 0 0 nch W=4e-06 L=4e-06
rgc1_e7_kb vdd gc1_e7_knb 1e+06
ngc1_e7_kmb gc1_e7_knb gc1_e7_knb 0 0 nch W=4e-06 L=4e-06
ngc1_e7_kmt gc1_e7_ktail gc1_e7_knb 0 0 nch W=4e-06 L=4e-06
ngc1_e7_km1 gc1_e7_kd1 gc1_e7_vm gc1_e7_ktail 0 nch W=4e-06 L=4e-06
ngc1_e7_km2 gc1_e7_ko1 gc1_e7_h gc1_e7_ktail 0 nch W=4e-06 L=4e-06
ngc1_e7_km3 gc1_e7_kd1 gc1_e7_kd1 vdd vsrc pch W=4e-06 L=4e-06
ngc1_e7_km4 gc1_e7_ko1 gc1_e7_kd1 vdd vsrc pch W=4e-06 L=4e-06
ngc1_e7_ki1p gc1_e7_qb gc1_e7_ko1 vdd vsrc pch W=2.4e-06 L=5e-07
ngc1_e7_ki1n gc1_e7_qb gc1_e7_ko1 0 0 nch W=1.2e-06 L=5e-07
ngc1_e7_ki2p gc1_e7_q gc1_e7_qb vdd vsrc pch W=2.4e-06 L=5e-07
ngc1_e7_ki2n gc1_e7_q gc1_e7_qb 0 0 nch W=1.2e-06 L=5e-07
rgc1_e7_hra gc1_e7_h vthe 1e+06
rgc1_e7_hrf gc1_e7_h gc1_e7_qb 1.9e+07
cgc1_e7_hc gc1_e7_h 0 2.1e-09
ngc1_e7_dis gc1_e7_vm gc1_e7_q gc1_e7_vmd 0 nch W=4e-06 L=1e-06
rgc1_e7_rdis gc1_e7_vmd vrest 220000
ngc1_e7_rp gc1_e7_rt gc1_e7_qb vdd vsrc pch W=2e-06 L=1e-06
rgc1_e7_rrc gc1_e7_rt gc1_e7_rec 10000
cgc1_e7_rc gc1_e7_rec 0 1e-07
rgc1_e7_rr gc1_e7_rec 0 8.2e+06
ngc1_e7_sh1 gc1_e7_vm gc1_e7_rec gc1_e7_vms 0 nch W=2e-06 L=1e-06
ngc1_e7_sh2 gc1_e7_vms gc1_e7_qb vrest 0 nch W=2e-06 L=1e-06
ngc1_e7_porh gc1_e7_h por_hold vthe 0 nch W=2e-06 L=1e-06
ngc1_e7_porm gc1_e7_vm por_hold vrest 0 nch W=2e-06 L=1e-06
ngc1_e7_ip gc1_e7_vm s1_yb vdd vsrc pch W=4e-06 L=4e-06
ngc1_e7_in gc1_e7_vm s1_za 0 0 nch W=4e-06 L=4e-06
ngc1_b7_sw gc1_b7_t gc1_e7_qb vdd vsrc pch W=2e-06 L=1e-06
rgc1_b7_rc gc1_b7_t gc1_b7 10000
cgc1_b7_c gc1_b7 0 1e-07
rgc1_b7_rl gc1_b7 0 2.2e+07
ngc1_b7_sh1p gc1_b7_n gc1_b7 vdd vsrc pch W=2.4e-06 L=5e-07
ngc1_b7_sh1n gc1_b7_n gc1_b7 0 0 nch W=1.2e-06 L=5e-07
ngc1_b7_sh2p gc1_b7_q gc1_b7_n vdd vsrc pch W=2.4e-06 L=5e-07
ngc1_b7_sh2n gc1_b7_q gc1_b7_n 0 0 nch W=1.2e-06 L=5e-07
cgc1_e8_cm gc1_e8_vm 0 1e-07
rgc1_e8_rm gc1_e8_vm vrest 1e+06
ngc1_e8_bias0 gc1_e8_vm istep_n 0 0 nch W=4e-06 L=4e-06
ngc1_e8_bias1 gc1_e8_vm istep_n 0 0 nch W=4e-06 L=4e-06
ngc1_e8_bias2 gc1_e8_vm istep_n 0 0 nch W=4e-06 L=4e-06
ngc1_e8_bias3 gc1_e8_vm istep_n 0 0 nch W=4e-06 L=4e-06
ngc1_e8_bias4 gc1_e8_vm istep_n 0 0 nch W=4e-06 L=4e-06
ngc1_e8_bias5 gc1_e8_vm istep_n 0 0 nch W=4e-06 L=4e-06
ngc1_e8_bias6 gc1_e8_vm istep_n 0 0 nch W=4e-06 L=4e-06
ngc1_e8_bias7 gc1_e8_vm istep_n 0 0 nch W=4e-06 L=4e-06
rgc1_e8_kb vdd gc1_e8_knb 1e+06
ngc1_e8_kmb gc1_e8_knb gc1_e8_knb 0 0 nch W=4e-06 L=4e-06
ngc1_e8_kmt gc1_e8_ktail gc1_e8_knb 0 0 nch W=4e-06 L=4e-06
ngc1_e8_km1 gc1_e8_kd1 gc1_e8_vm gc1_e8_ktail 0 nch W=4e-06 L=4e-06
ngc1_e8_km2 gc1_e8_ko1 gc1_e8_h gc1_e8_ktail 0 nch W=4e-06 L=4e-06
ngc1_e8_km3 gc1_e8_kd1 gc1_e8_kd1 vdd vsrc pch W=4e-06 L=4e-06
ngc1_e8_km4 gc1_e8_ko1 gc1_e8_kd1 vdd vsrc pch W=4e-06 L=4e-06
ngc1_e8_ki1p gc1_e8_qb gc1_e8_ko1 vdd vsrc pch W=2.4e-06 L=5e-07
ngc1_e8_ki1n gc1_e8_qb gc1_e8_ko1 0 0 nch W=1.2e-06 L=5e-07
ngc1_e8_ki2p gc1_e8_q gc1_e8_qb vdd vsrc pch W=2.4e-06 L=5e-07
ngc1_e8_ki2n gc1_e8_q gc1_e8_qb 0 0 nch W=1.2e-06 L=5e-07
rgc1_e8_hra gc1_e8_h vthe 1e+06
rgc1_e8_hrf gc1_e8_h gc1_e8_qb 1.9e+07
cgc1_e8_hc gc1_e8_h 0 2.1e-09
ngc1_e8_dis gc1_e8_vm gc1_e8_q gc1_e8_vmd 0 nch W=4e-06 L=1e-06
rgc1_e8_rdis gc1_e8_vmd vrest 220000
ngc1_e8_rp gc1_e8_rt gc1_e8_qb vdd vsrc pch W=2e-06 L=1e-06
rgc1_e8_rrc gc1_e8_rt gc1_e8_rec 10000
cgc1_e8_rc gc1_e8_rec 0 1e-07
rgc1_e8_rr gc1_e8_rec 0 8.2e+06
ngc1_e8_sh1 gc1_e8_vm gc1_e8_rec gc1_e8_vms 0 nch W=2e-06 L=1e-06
ngc1_e8_sh2 gc1_e8_vms gc1_e8_qb vrest 0 nch W=2e-06 L=1e-06
ngc1_e8_porh gc1_e8_h por_hold vthe 0 nch W=2e-06 L=1e-06
ngc1_e8_porm gc1_e8_vm por_hold vrest 0 nch W=2e-06 L=1e-06
ngc1_e8_ip gc1_e8_vm s1_yb vdd vsrc pch W=4e-06 L=4e-06
ngc1_e8_in gc1_e8_vm s1_za 0 0 nch W=4e-06 L=4e-06
ngc1_b8_sw gc1_b8_t gc1_e8_qb vdd vsrc pch W=2e-06 L=1e-06
rgc1_b8_rc gc1_b8_t gc1_b8 10000
cgc1_b8_c gc1_b8 0 1e-07
rgc1_b8_rl gc1_b8 0 2.2e+07
ngc1_b8_sh1p gc1_b8_n gc1_b8 vdd vsrc pch W=2.4e-06 L=5e-07
ngc1_b8_sh1n gc1_b8_n gc1_b8 0 0 nch W=1.2e-06 L=5e-07
ngc1_b8_sh2p gc1_b8_q gc1_b8_n vdd vsrc pch W=2.4e-06 L=5e-07
ngc1_b8_sh2n gc1_b8_q gc1_b8_n 0 0 nch W=1.2e-06 L=5e-07
cgc1_e9_cm gc1_e9_vm 0 1e-07
rgc1_e9_rm gc1_e9_vm vrest 1e+06
ngc1_e9_bias0 gc1_e9_vm istep_n 0 0 nch W=4e-06 L=4e-06
ngc1_e9_bias1 gc1_e9_vm istep_n 0 0 nch W=4e-06 L=4e-06
ngc1_e9_bias2 gc1_e9_vm istep_n 0 0 nch W=4e-06 L=4e-06
ngc1_e9_bias3 gc1_e9_vm istep_n 0 0 nch W=4e-06 L=4e-06
ngc1_e9_bias4 gc1_e9_vm istep_n 0 0 nch W=4e-06 L=4e-06
ngc1_e9_bias5 gc1_e9_vm istep_n 0 0 nch W=4e-06 L=4e-06
ngc1_e9_bias6 gc1_e9_vm istep_n 0 0 nch W=4e-06 L=4e-06
ngc1_e9_bias7 gc1_e9_vm istep_n 0 0 nch W=4e-06 L=4e-06
ngc1_e9_bias8 gc1_e9_vm istep_n 0 0 nch W=4e-06 L=4e-06
rgc1_e9_kb vdd gc1_e9_knb 1e+06
ngc1_e9_kmb gc1_e9_knb gc1_e9_knb 0 0 nch W=4e-06 L=4e-06
ngc1_e9_kmt gc1_e9_ktail gc1_e9_knb 0 0 nch W=4e-06 L=4e-06
ngc1_e9_km1 gc1_e9_kd1 gc1_e9_vm gc1_e9_ktail 0 nch W=4e-06 L=4e-06
ngc1_e9_km2 gc1_e9_ko1 gc1_e9_h gc1_e9_ktail 0 nch W=4e-06 L=4e-06
ngc1_e9_km3 gc1_e9_kd1 gc1_e9_kd1 vdd vsrc pch W=4e-06 L=4e-06
ngc1_e9_km4 gc1_e9_ko1 gc1_e9_kd1 vdd vsrc pch W=4e-06 L=4e-06
ngc1_e9_ki1p gc1_e9_qb gc1_e9_ko1 vdd vsrc pch W=2.4e-06 L=5e-07
ngc1_e9_ki1n gc1_e9_qb gc1_e9_ko1 0 0 nch W=1.2e-06 L=5e-07
ngc1_e9_ki2p gc1_e9_q gc1_e9_qb vdd vsrc pch W=2.4e-06 L=5e-07
ngc1_e9_ki2n gc1_e9_q gc1_e9_qb 0 0 nch W=1.2e-06 L=5e-07
rgc1_e9_hra gc1_e9_h vthe 1e+06
rgc1_e9_hrf gc1_e9_h gc1_e9_qb 1.9e+07
cgc1_e9_hc gc1_e9_h 0 2.1e-09
ngc1_e9_dis gc1_e9_vm gc1_e9_q gc1_e9_vmd 0 nch W=4e-06 L=1e-06
rgc1_e9_rdis gc1_e9_vmd vrest 220000
ngc1_e9_rp gc1_e9_rt gc1_e9_qb vdd vsrc pch W=2e-06 L=1e-06
rgc1_e9_rrc gc1_e9_rt gc1_e9_rec 10000
cgc1_e9_rc gc1_e9_rec 0 1e-07
rgc1_e9_rr gc1_e9_rec 0 8.2e+06
ngc1_e9_sh1 gc1_e9_vm gc1_e9_rec gc1_e9_vms 0 nch W=2e-06 L=1e-06
ngc1_e9_sh2 gc1_e9_vms gc1_e9_qb vrest 0 nch W=2e-06 L=1e-06
ngc1_e9_porh gc1_e9_h por_hold vthe 0 nch W=2e-06 L=1e-06
ngc1_e9_porm gc1_e9_vm por_hold vrest 0 nch W=2e-06 L=1e-06
ngc1_e9_ip gc1_e9_vm s1_yb vdd vsrc pch W=4e-06 L=4e-06
ngc1_e9_in gc1_e9_vm s1_za 0 0 nch W=4e-06 L=4e-06
ngc1_b9_sw gc1_b9_t gc1_e9_qb vdd vsrc pch W=2e-06 L=1e-06
rgc1_b9_rc gc1_b9_t gc1_b9 10000
cgc1_b9_c gc1_b9 0 1e-07
rgc1_b9_rl gc1_b9 0 2.2e+07
ngc1_b9_sh1p gc1_b9_n gc1_b9 vdd vsrc pch W=2.4e-06 L=5e-07
ngc1_b9_sh1n gc1_b9_n gc1_b9 0 0 nch W=1.2e-06 L=5e-07
ngc1_b9_sh2p gc1_b9_q gc1_b9_n vdd vsrc pch W=2.4e-06 L=5e-07
ngc1_b9_sh2n gc1_b9_q gc1_b9_n 0 0 nch W=1.2e-06 L=5e-07
cgc1_e10_cm gc1_e10_vm 0 1e-07
rgc1_e10_rm gc1_e10_vm vrest 1e+06
ngc1_e10_bias0 gc1_e10_vm istep_n 0 0 nch W=4e-06 L=4e-06
ngc1_e10_bias1 gc1_e10_vm istep_n 0 0 nch W=4e-06 L=4e-06
ngc1_e10_bias2 gc1_e10_vm istep_n 0 0 nch W=4e-06 L=4e-06
ngc1_e10_bias3 gc1_e10_vm istep_n 0 0 nch W=4e-06 L=4e-06
ngc1_e10_bias4 gc1_e10_vm istep_n 0 0 nch W=4e-06 L=4e-06
ngc1_e10_bias5 gc1_e10_vm istep_n 0 0 nch W=4e-06 L=4e-06
ngc1_e10_bias6 gc1_e10_vm istep_n 0 0 nch W=4e-06 L=4e-06
ngc1_e10_bias7 gc1_e10_vm istep_n 0 0 nch W=4e-06 L=4e-06
ngc1_e10_bias8 gc1_e10_vm istep_n 0 0 nch W=4e-06 L=4e-06
ngc1_e10_bias9 gc1_e10_vm istep_n 0 0 nch W=4e-06 L=4e-06
rgc1_e10_kb vdd gc1_e10_knb 1e+06
ngc1_e10_kmb gc1_e10_knb gc1_e10_knb 0 0 nch W=4e-06 L=4e-06
ngc1_e10_kmt gc1_e10_ktail gc1_e10_knb 0 0 nch W=4e-06 L=4e-06
ngc1_e10_km1 gc1_e10_kd1 gc1_e10_vm gc1_e10_ktail 0 nch W=4e-06 L=4e-06
ngc1_e10_km2 gc1_e10_ko1 gc1_e10_h gc1_e10_ktail 0 nch W=4e-06 L=4e-06
ngc1_e10_km3 gc1_e10_kd1 gc1_e10_kd1 vdd vsrc pch W=4e-06 L=4e-06
ngc1_e10_km4 gc1_e10_ko1 gc1_e10_kd1 vdd vsrc pch W=4e-06 L=4e-06
ngc1_e10_ki1p gc1_e10_qb gc1_e10_ko1 vdd vsrc pch W=2.4e-06 L=5e-07
ngc1_e10_ki1n gc1_e10_qb gc1_e10_ko1 0 0 nch W=1.2e-06 L=5e-07
ngc1_e10_ki2p gc1_e10_q gc1_e10_qb vdd vsrc pch W=2.4e-06 L=5e-07
ngc1_e10_ki2n gc1_e10_q gc1_e10_qb 0 0 nch W=1.2e-06 L=5e-07
rgc1_e10_hra gc1_e10_h vthe 1e+06
rgc1_e10_hrf gc1_e10_h gc1_e10_qb 1.9e+07
cgc1_e10_hc gc1_e10_h 0 2.1e-09
ngc1_e10_dis gc1_e10_vm gc1_e10_q gc1_e10_vmd 0 nch W=4e-06 L=1e-06
rgc1_e10_rdis gc1_e10_vmd vrest 220000
ngc1_e10_rp gc1_e10_rt gc1_e10_qb vdd vsrc pch W=2e-06 L=1e-06
rgc1_e10_rrc gc1_e10_rt gc1_e10_rec 10000
cgc1_e10_rc gc1_e10_rec 0 1e-07
rgc1_e10_rr gc1_e10_rec 0 8.2e+06
ngc1_e10_sh1 gc1_e10_vm gc1_e10_rec gc1_e10_vms 0 nch W=2e-06 L=1e-06
ngc1_e10_sh2 gc1_e10_vms gc1_e10_qb vrest 0 nch W=2e-06 L=1e-06
ngc1_e10_porh gc1_e10_h por_hold vthe 0 nch W=2e-06 L=1e-06
ngc1_e10_porm gc1_e10_vm por_hold vrest 0 nch W=2e-06 L=1e-06
ngc1_e10_ip gc1_e10_vm s1_yb vdd vsrc pch W=4e-06 L=4e-06
ngc1_e10_in gc1_e10_vm s1_za 0 0 nch W=4e-06 L=4e-06
ngc1_b10_sw gc1_b10_t gc1_e10_qb vdd vsrc pch W=2e-06 L=1e-06
rgc1_b10_rc gc1_b10_t gc1_b10 10000
cgc1_b10_c gc1_b10 0 1e-07
rgc1_b10_rl gc1_b10 0 2.2e+07
ngc1_b10_sh1p gc1_b10_n gc1_b10 vdd vsrc pch W=2.4e-06 L=5e-07
ngc1_b10_sh1n gc1_b10_n gc1_b10 0 0 nch W=1.2e-06 L=5e-07
ngc1_b10_sh2p gc1_b10_q gc1_b10_n vdd vsrc pch W=2.4e-06 L=5e-07
ngc1_b10_sh2n gc1_b10_q gc1_b10_n 0 0 nch W=1.2e-06 L=5e-07
ngc1_and_a0_npa gc1_and_a0_nb gc1_b1_q vdd vsrc pch W=2.4e-06 L=5e-07
ngc1_and_a0_npb gc1_and_a0_nb gc1_b2_q vdd vsrc pch W=2.4e-06 L=5e-07
ngc1_and_a0_nna gc1_and_a0_nb gc1_b1_q gc1_and_a0_nx 0 nch W=2.4e-06 L=5e-07
ngc1_and_a0_nnb gc1_and_a0_nx gc1_b2_q 0 0 nch W=2.4e-06 L=5e-07
ngc1_and_a0_ip gc1_and_g0 gc1_and_a0_nb vdd vsrc pch W=2.4e-06 L=5e-07
ngc1_and_a0_in gc1_and_g0 gc1_and_a0_nb 0 0 nch W=1.2e-06 L=5e-07
ngc1_and_a1_npa gc1_and_a1_nb gc1_b3_q vdd vsrc pch W=2.4e-06 L=5e-07
ngc1_and_a1_npb gc1_and_a1_nb gc1_b4_q vdd vsrc pch W=2.4e-06 L=5e-07
ngc1_and_a1_nna gc1_and_a1_nb gc1_b3_q gc1_and_a1_nx 0 nch W=2.4e-06 L=5e-07
ngc1_and_a1_nnb gc1_and_a1_nx gc1_b4_q 0 0 nch W=2.4e-06 L=5e-07
ngc1_and_a1_ip gc1_and_g1 gc1_and_a1_nb vdd vsrc pch W=2.4e-06 L=5e-07
ngc1_and_a1_in gc1_and_g1 gc1_and_a1_nb 0 0 nch W=1.2e-06 L=5e-07
ngc1_and_a2_npa gc1_and_a2_nb gc1_b5_q vdd vsrc pch W=2.4e-06 L=5e-07
ngc1_and_a2_npb gc1_and_a2_nb gc1_b6_q vdd vsrc pch W=2.4e-06 L=5e-07
ngc1_and_a2_nna gc1_and_a2_nb gc1_b5_q gc1_and_a2_nx 0 nch W=2.4e-06 L=5e-07
ngc1_and_a2_nnb gc1_and_a2_nx gc1_b6_q 0 0 nch W=2.4e-06 L=5e-07
ngc1_and_a2_ip gc1_and_g2 gc1_and_a2_nb vdd vsrc pch W=2.4e-06 L=5e-07
ngc1_and_a2_in gc1_and_g2 gc1_and_a2_nb 0 0 nch W=1.2e-06 L=5e-07
ngc1_and_a3_npa gc1_and_a3_nb gc1_b7_q vdd vsrc pch W=2.4e-06 L=5e-07
ngc1_and_a3_npb gc1_and_a3_nb gc1_b8_q vdd vsrc pch W=2.4e-06 L=5e-07
ngc1_and_a3_nna gc1_and_a3_nb gc1_b7_q gc1_and_a3_nx 0 nch W=2.4e-06 L=5e-07
ngc1_and_a3_nnb gc1_and_a3_nx gc1_b8_q 0 0 nch W=2.4e-06 L=5e-07
ngc1_and_a3_ip gc1_and_g3 gc1_and_a3_nb vdd vsrc pch W=2.4e-06 L=5e-07
ngc1_and_a3_in gc1_and_g3 gc1_and_a3_nb 0 0 nch W=1.2e-06 L=5e-07
ngc1_and_a4_npa gc1_and_a4_nb gc1_b9_q vdd vsrc pch W=2.4e-06 L=5e-07
ngc1_and_a4_npb gc1_and_a4_nb gc1_b10_q vdd vsrc pch W=2.4e-06 L=5e-07
ngc1_and_a4_nna gc1_and_a4_nb gc1_b9_q gc1_and_a4_nx 0 nch W=2.4e-06 L=5e-07
ngc1_and_a4_nnb gc1_and_a4_nx gc1_b10_q 0 0 nch W=2.4e-06 L=5e-07
ngc1_and_a4_ip gc1_and_g4 gc1_and_a4_nb vdd vsrc pch W=2.4e-06 L=5e-07
ngc1_and_a4_in gc1_and_g4 gc1_and_a4_nb 0 0 nch W=1.2e-06 L=5e-07
ngc1_and_a5_npa gc1_and_a5_nb gc1_and_g0 vdd vsrc pch W=2.4e-06 L=5e-07
ngc1_and_a5_npb gc1_and_a5_nb gc1_and_g1 vdd vsrc pch W=2.4e-06 L=5e-07
ngc1_and_a5_nna gc1_and_a5_nb gc1_and_g0 gc1_and_a5_nx 0 nch W=2.4e-06 L=5e-07
ngc1_and_a5_nnb gc1_and_a5_nx gc1_and_g1 0 0 nch W=2.4e-06 L=5e-07
ngc1_and_a5_ip gc1_and_g5 gc1_and_a5_nb vdd vsrc pch W=2.4e-06 L=5e-07
ngc1_and_a5_in gc1_and_g5 gc1_and_a5_nb 0 0 nch W=1.2e-06 L=5e-07
ngc1_and_a6_npa gc1_and_a6_nb gc1_and_g2 vdd vsrc pch W=2.4e-06 L=5e-07
ngc1_and_a6_npb gc1_and_a6_nb gc1_and_g3 vdd vsrc pch W=2.4e-06 L=5e-07
ngc1_and_a6_nna gc1_and_a6_nb gc1_and_g2 gc1_and_a6_nx 0 nch W=2.4e-06 L=5e-07
ngc1_and_a6_nnb gc1_and_a6_nx gc1_and_g3 0 0 nch W=2.4e-06 L=5e-07
ngc1_and_a6_ip gc1_and_g6 gc1_and_a6_nb vdd vsrc pch W=2.4e-06 L=5e-07
ngc1_and_a6_in gc1_and_g6 gc1_and_a6_nb 0 0 nch W=1.2e-06 L=5e-07
ngc1_and_a7_npa gc1_and_a7_nb gc1_and_g5 vdd vsrc pch W=2.4e-06 L=5e-07
ngc1_and_a7_npb gc1_and_a7_nb gc1_and_g6 vdd vsrc pch W=2.4e-06 L=5e-07
ngc1_and_a7_nna gc1_and_a7_nb gc1_and_g5 gc1_and_a7_nx 0 nch W=2.4e-06 L=5e-07
ngc1_and_a7_nnb gc1_and_a7_nx gc1_and_g6 0 0 nch W=2.4e-06 L=5e-07
ngc1_and_a7_ip gc1_and_g7 gc1_and_a7_nb vdd vsrc pch W=2.4e-06 L=5e-07
ngc1_and_a7_in gc1_and_g7 gc1_and_a7_nb 0 0 nch W=1.2e-06 L=5e-07
ngc1_and_a8_npa gc1_and_a8_nb gc1_and_g7 vdd vsrc pch W=2.4e-06 L=5e-07
ngc1_and_a8_npb gc1_and_a8_nb gc1_and_g4 vdd vsrc pch W=2.4e-06 L=5e-07
ngc1_and_a8_nna gc1_and_a8_nb gc1_and_g7 gc1_and_a8_nx 0 nch W=2.4e-06 L=5e-07
ngc1_and_a8_nnb gc1_and_a8_nx gc1_and_g4 0 0 nch W=2.4e-06 L=5e-07
ngc1_and_a8_ip gc1_and_g8 gc1_and_a8_nb vdd vsrc pch W=2.4e-06 L=5e-07
ngc1_and_a8_in gc1_and_g8 gc1_and_a8_nb 0 0 nch W=1.2e-06 L=5e-07
ngc1_gip gc1_gb gc1_and_g8 vdd vsrc pch W=2.4e-06 L=5e-07
ngc1_gin gc1_gb gc1_and_g8 0 0 nch W=1.2e-06 L=5e-07
cgc1_col_cm gc1_col_vm 0 1e-07
rgc1_col_rm gc1_col_vm vrest 1e+06
rgc1_col_kb vdd gc1_col_knb 1e+06
ngc1_col_kmb gc1_col_knb gc1_col_knb 0 0 nch W=4e-06 L=4e-06
ngc1_col_kmt gc1_col_ktail gc1_col_knb 0 0 nch W=4e-06 L=4e-06
ngc1_col_km1 gc1_col_kd1 gc1_col_vm gc1_col_ktail 0 nch W=4e-06 L=4e-06
ngc1_col_km2 gc1_col_ko1 gc1_col_h gc1_col_ktail 0 nch W=4e-06 L=4e-06
ngc1_col_km3 gc1_col_kd1 gc1_col_kd1 vdd vsrc pch W=4e-06 L=4e-06
ngc1_col_km4 gc1_col_ko1 gc1_col_kd1 vdd vsrc pch W=4e-06 L=4e-06
ngc1_col_ki1p gc1_col_qb gc1_col_ko1 vdd vsrc pch W=2.4e-06 L=5e-07
ngc1_col_ki1n gc1_col_qb gc1_col_ko1 0 0 nch W=1.2e-06 L=5e-07
ngc1_col_ki2p gc1_col_q gc1_col_qb vdd vsrc pch W=2.4e-06 L=5e-07
ngc1_col_ki2n gc1_col_q gc1_col_qb 0 0 nch W=1.2e-06 L=5e-07
rgc1_col_hra gc1_col_h vthe 1e+06
rgc1_col_hrf gc1_col_h gc1_col_qb 1.9e+07
cgc1_col_hc gc1_col_h 0 2.1e-09
ngc1_col_dis gc1_col_vm gc1_col_q gc1_col_vmd 0 nch W=4e-06 L=1e-06
rgc1_col_rdis gc1_col_vmd vrest 220000
ngc1_col_rp gc1_col_rt gc1_col_qb vdd vsrc pch W=2e-06 L=1e-06
rgc1_col_rrc gc1_col_rt gc1_col_rec 10000
cgc1_col_rc gc1_col_rec 0 1e-07
rgc1_col_rr gc1_col_rec 0 8.2e+06
ngc1_col_sh1 gc1_col_vm gc1_col_rec gc1_col_vms 0 nch W=2e-06 L=1e-06
ngc1_col_sh2 gc1_col_vms gc1_col_qb vrest 0 nch W=2e-06 L=1e-06
ngc1_col_porh gc1_col_h por_hold vthe 0 nch W=2e-06 L=1e-06
ngc1_col_porm gc1_col_vm por_hold vrest 0 nch W=2e-06 L=1e-06
ngc1_cin_sw gc1_cin_x gc1_gb vdd vsrc pch W=4e-06 L=1e-06
ngc1_cin_cp gc1_col_vm ilimp_n gc1_cin_x vsrc pch W=4e-06 L=4e-06
ngc1_op_tsw gc1_op_tt gc1_col_qb vdd vsrc pch W=2e-06 L=1e-06
rgc1_op_trc gc1_op_tt gc1_op_at 10000
cgc1_op_tc gc1_op_at 0 1e-07
rgc1_op_trl gc1_op_at 0 2.2e+07
ngc1_op_sh1p gc1_op_an gc1_op_at vdd vsrc pch W=2.4e-06 L=5e-07
ngc1_op_sh1n gc1_op_an gc1_op_at 0 0 nch W=1.2e-06 L=5e-07
ngc1_op_sh2p gc1_op_aq gc1_op_an vdd vsrc pch W=2.4e-06 L=5e-07
ngc1_op_sh2n gc1_op_aq gc1_op_an 0 0 nch W=1.2e-06 L=5e-07
ngc1_op_abp gc1_op_aqb gc1_op_aq vdd vsrc pch W=2.4e-06 L=5e-07
ngc1_op_abn gc1_op_aqb gc1_op_aq 0 0 nch W=1.2e-06 L=5e-07
rgc1_op_dr gc1_op_aq gc1_op_ad 1e+06
cgc1_op_dc gc1_op_ad 0 3.3e-07
ngc1_op_d2p gc1_op_adn gc1_op_ad vdd vsrc pch W=2.4e-06 L=5e-07
ngc1_op_d2n gc1_op_adn gc1_op_ad 0 0 nch W=1.2e-06 L=5e-07
ngc1_op_gpa gc1_op_pb gc1_op_aq vdd vsrc pch W=2.4e-06 L=5e-07
ngc1_op_gpb gc1_op_pb gc1_op_adn vdd vsrc pch W=2.4e-06 L=5e-07
ngc1_op_gna gc1_op_pb gc1_op_aq gc1_op_gx 0 nch W=2.4e-06 L=5e-07
ngc1_op_gnb gc1_op_gx gc1_op_adn 0 0 nch W=2.4e-06 L=5e-07
ngc1_op_op gc1_op_p gc1_op_pb vdd vsrc pch W=2.4e-06 L=5e-07
ngc1_op_on gc1_op_p gc1_op_pb 0 0 nch W=1.2e-06 L=5e-07
cgc2_e1_cm gc2_e1_vm 0 1e-07
rgc2_e1_rm gc2_e1_vm vrest 1e+06
ngc2_e1_bias0 gc2_e1_vm istep_n 0 0 nch W=4e-06 L=4e-06
rgc2_e1_kb vdd gc2_e1_knb 1e+06
ngc2_e1_kmb gc2_e1_knb gc2_e1_knb 0 0 nch W=4e-06 L=4e-06
ngc2_e1_kmt gc2_e1_ktail gc2_e1_knb 0 0 nch W=4e-06 L=4e-06
ngc2_e1_km1 gc2_e1_kd1 gc2_e1_vm gc2_e1_ktail 0 nch W=4e-06 L=4e-06
ngc2_e1_km2 gc2_e1_ko1 gc2_e1_h gc2_e1_ktail 0 nch W=4e-06 L=4e-06
ngc2_e1_km3 gc2_e1_kd1 gc2_e1_kd1 vdd vsrc pch W=4e-06 L=4e-06
ngc2_e1_km4 gc2_e1_ko1 gc2_e1_kd1 vdd vsrc pch W=4e-06 L=4e-06
ngc2_e1_ki1p gc2_e1_qb gc2_e1_ko1 vdd vsrc pch W=2.4e-06 L=5e-07
ngc2_e1_ki1n gc2_e1_qb gc2_e1_ko1 0 0 nch W=1.2e-06 L=5e-07
ngc2_e1_ki2p gc2_e1_q gc2_e1_qb vdd vsrc pch W=2.4e-06 L=5e-07
ngc2_e1_ki2n gc2_e1_q gc2_e1_qb 0 0 nch W=1.2e-06 L=5e-07
rgc2_e1_hra gc2_e1_h vthe 1e+06
rgc2_e1_hrf gc2_e1_h gc2_e1_qb 1.9e+07
cgc2_e1_hc gc2_e1_h 0 2.1e-09
ngc2_e1_dis gc2_e1_vm gc2_e1_q gc2_e1_vmd 0 nch W=4e-06 L=1e-06
rgc2_e1_rdis gc2_e1_vmd vrest 220000
ngc2_e1_rp gc2_e1_rt gc2_e1_qb vdd vsrc pch W=2e-06 L=1e-06
rgc2_e1_rrc gc2_e1_rt gc2_e1_rec 10000
cgc2_e1_rc gc2_e1_rec 0 1e-07
rgc2_e1_rr gc2_e1_rec 0 8.2e+06
ngc2_e1_sh1 gc2_e1_vm gc2_e1_rec gc2_e1_vms 0 nch W=2e-06 L=1e-06
ngc2_e1_sh2 gc2_e1_vms gc2_e1_qb vrest 0 nch W=2e-06 L=1e-06
ngc2_e1_porh gc2_e1_h por_hold vthe 0 nch W=2e-06 L=1e-06
ngc2_e1_porm gc2_e1_vm por_hold vrest 0 nch W=2e-06 L=1e-06
ngc2_e1_ip gc2_e1_vm s2_yb vdd vsrc pch W=4e-06 L=4e-06
ngc2_e1_in gc2_e1_vm s2_za 0 0 nch W=4e-06 L=4e-06
ngc2_b1_sw gc2_b1_t gc2_e1_qb vdd vsrc pch W=2e-06 L=1e-06
rgc2_b1_rc gc2_b1_t gc2_b1 10000
cgc2_b1_c gc2_b1 0 1e-07
rgc2_b1_rl gc2_b1 0 2.2e+07
ngc2_b1_sh1p gc2_b1_n gc2_b1 vdd vsrc pch W=2.4e-06 L=5e-07
ngc2_b1_sh1n gc2_b1_n gc2_b1 0 0 nch W=1.2e-06 L=5e-07
ngc2_b1_sh2p gc2_b1_q gc2_b1_n vdd vsrc pch W=2.4e-06 L=5e-07
ngc2_b1_sh2n gc2_b1_q gc2_b1_n 0 0 nch W=1.2e-06 L=5e-07
cgc2_e2_cm gc2_e2_vm 0 1e-07
rgc2_e2_rm gc2_e2_vm vrest 1e+06
ngc2_e2_bias0 gc2_e2_vm istep_n 0 0 nch W=4e-06 L=4e-06
ngc2_e2_bias1 gc2_e2_vm istep_n 0 0 nch W=4e-06 L=4e-06
rgc2_e2_kb vdd gc2_e2_knb 1e+06
ngc2_e2_kmb gc2_e2_knb gc2_e2_knb 0 0 nch W=4e-06 L=4e-06
ngc2_e2_kmt gc2_e2_ktail gc2_e2_knb 0 0 nch W=4e-06 L=4e-06
ngc2_e2_km1 gc2_e2_kd1 gc2_e2_vm gc2_e2_ktail 0 nch W=4e-06 L=4e-06
ngc2_e2_km2 gc2_e2_ko1 gc2_e2_h gc2_e2_ktail 0 nch W=4e-06 L=4e-06
ngc2_e2_km3 gc2_e2_kd1 gc2_e2_kd1 vdd vsrc pch W=4e-06 L=4e-06
ngc2_e2_km4 gc2_e2_ko1 gc2_e2_kd1 vdd vsrc pch W=4e-06 L=4e-06
ngc2_e2_ki1p gc2_e2_qb gc2_e2_ko1 vdd vsrc pch W=2.4e-06 L=5e-07
ngc2_e2_ki1n gc2_e2_qb gc2_e2_ko1 0 0 nch W=1.2e-06 L=5e-07
ngc2_e2_ki2p gc2_e2_q gc2_e2_qb vdd vsrc pch W=2.4e-06 L=5e-07
ngc2_e2_ki2n gc2_e2_q gc2_e2_qb 0 0 nch W=1.2e-06 L=5e-07
rgc2_e2_hra gc2_e2_h vthe 1e+06
rgc2_e2_hrf gc2_e2_h gc2_e2_qb 1.9e+07
cgc2_e2_hc gc2_e2_h 0 2.1e-09
ngc2_e2_dis gc2_e2_vm gc2_e2_q gc2_e2_vmd 0 nch W=4e-06 L=1e-06
rgc2_e2_rdis gc2_e2_vmd vrest 220000
ngc2_e2_rp gc2_e2_rt gc2_e2_qb vdd vsrc pch W=2e-06 L=1e-06
rgc2_e2_rrc gc2_e2_rt gc2_e2_rec 10000
cgc2_e2_rc gc2_e2_rec 0 1e-07
rgc2_e2_rr gc2_e2_rec 0 8.2e+06
ngc2_e2_sh1 gc2_e2_vm gc2_e2_rec gc2_e2_vms 0 nch W=2e-06 L=1e-06
ngc2_e2_sh2 gc2_e2_vms gc2_e2_qb vrest 0 nch W=2e-06 L=1e-06
ngc2_e2_porh gc2_e2_h por_hold vthe 0 nch W=2e-06 L=1e-06
ngc2_e2_porm gc2_e2_vm por_hold vrest 0 nch W=2e-06 L=1e-06
ngc2_e2_ip gc2_e2_vm s2_yb vdd vsrc pch W=4e-06 L=4e-06
ngc2_e2_in gc2_e2_vm s2_za 0 0 nch W=4e-06 L=4e-06
ngc2_b2_sw gc2_b2_t gc2_e2_qb vdd vsrc pch W=2e-06 L=1e-06
rgc2_b2_rc gc2_b2_t gc2_b2 10000
cgc2_b2_c gc2_b2 0 1e-07
rgc2_b2_rl gc2_b2 0 2.2e+07
ngc2_b2_sh1p gc2_b2_n gc2_b2 vdd vsrc pch W=2.4e-06 L=5e-07
ngc2_b2_sh1n gc2_b2_n gc2_b2 0 0 nch W=1.2e-06 L=5e-07
ngc2_b2_sh2p gc2_b2_q gc2_b2_n vdd vsrc pch W=2.4e-06 L=5e-07
ngc2_b2_sh2n gc2_b2_q gc2_b2_n 0 0 nch W=1.2e-06 L=5e-07
cgc2_e3_cm gc2_e3_vm 0 1e-07
rgc2_e3_rm gc2_e3_vm vrest 1e+06
ngc2_e3_bias0 gc2_e3_vm istep_n 0 0 nch W=4e-06 L=4e-06
ngc2_e3_bias1 gc2_e3_vm istep_n 0 0 nch W=4e-06 L=4e-06
ngc2_e3_bias2 gc2_e3_vm istep_n 0 0 nch W=4e-06 L=4e-06
rgc2_e3_kb vdd gc2_e3_knb 1e+06
ngc2_e3_kmb gc2_e3_knb gc2_e3_knb 0 0 nch W=4e-06 L=4e-06
ngc2_e3_kmt gc2_e3_ktail gc2_e3_knb 0 0 nch W=4e-06 L=4e-06
ngc2_e3_km1 gc2_e3_kd1 gc2_e3_vm gc2_e3_ktail 0 nch W=4e-06 L=4e-06
ngc2_e3_km2 gc2_e3_ko1 gc2_e3_h gc2_e3_ktail 0 nch W=4e-06 L=4e-06
ngc2_e3_km3 gc2_e3_kd1 gc2_e3_kd1 vdd vsrc pch W=4e-06 L=4e-06
ngc2_e3_km4 gc2_e3_ko1 gc2_e3_kd1 vdd vsrc pch W=4e-06 L=4e-06
ngc2_e3_ki1p gc2_e3_qb gc2_e3_ko1 vdd vsrc pch W=2.4e-06 L=5e-07
ngc2_e3_ki1n gc2_e3_qb gc2_e3_ko1 0 0 nch W=1.2e-06 L=5e-07
ngc2_e3_ki2p gc2_e3_q gc2_e3_qb vdd vsrc pch W=2.4e-06 L=5e-07
ngc2_e3_ki2n gc2_e3_q gc2_e3_qb 0 0 nch W=1.2e-06 L=5e-07
rgc2_e3_hra gc2_e3_h vthe 1e+06
rgc2_e3_hrf gc2_e3_h gc2_e3_qb 1.9e+07
cgc2_e3_hc gc2_e3_h 0 2.1e-09
ngc2_e3_dis gc2_e3_vm gc2_e3_q gc2_e3_vmd 0 nch W=4e-06 L=1e-06
rgc2_e3_rdis gc2_e3_vmd vrest 220000
ngc2_e3_rp gc2_e3_rt gc2_e3_qb vdd vsrc pch W=2e-06 L=1e-06
rgc2_e3_rrc gc2_e3_rt gc2_e3_rec 10000
cgc2_e3_rc gc2_e3_rec 0 1e-07
rgc2_e3_rr gc2_e3_rec 0 8.2e+06
ngc2_e3_sh1 gc2_e3_vm gc2_e3_rec gc2_e3_vms 0 nch W=2e-06 L=1e-06
ngc2_e3_sh2 gc2_e3_vms gc2_e3_qb vrest 0 nch W=2e-06 L=1e-06
ngc2_e3_porh gc2_e3_h por_hold vthe 0 nch W=2e-06 L=1e-06
ngc2_e3_porm gc2_e3_vm por_hold vrest 0 nch W=2e-06 L=1e-06
ngc2_e3_ip gc2_e3_vm s2_yb vdd vsrc pch W=4e-06 L=4e-06
ngc2_e3_in gc2_e3_vm s2_za 0 0 nch W=4e-06 L=4e-06
ngc2_b3_sw gc2_b3_t gc2_e3_qb vdd vsrc pch W=2e-06 L=1e-06
rgc2_b3_rc gc2_b3_t gc2_b3 10000
cgc2_b3_c gc2_b3 0 1e-07
rgc2_b3_rl gc2_b3 0 2.2e+07
ngc2_b3_sh1p gc2_b3_n gc2_b3 vdd vsrc pch W=2.4e-06 L=5e-07
ngc2_b3_sh1n gc2_b3_n gc2_b3 0 0 nch W=1.2e-06 L=5e-07
ngc2_b3_sh2p gc2_b3_q gc2_b3_n vdd vsrc pch W=2.4e-06 L=5e-07
ngc2_b3_sh2n gc2_b3_q gc2_b3_n 0 0 nch W=1.2e-06 L=5e-07
cgc2_e4_cm gc2_e4_vm 0 1e-07
rgc2_e4_rm gc2_e4_vm vrest 1e+06
ngc2_e4_bias0 gc2_e4_vm istep_n 0 0 nch W=4e-06 L=4e-06
ngc2_e4_bias1 gc2_e4_vm istep_n 0 0 nch W=4e-06 L=4e-06
ngc2_e4_bias2 gc2_e4_vm istep_n 0 0 nch W=4e-06 L=4e-06
ngc2_e4_bias3 gc2_e4_vm istep_n 0 0 nch W=4e-06 L=4e-06
rgc2_e4_kb vdd gc2_e4_knb 1e+06
ngc2_e4_kmb gc2_e4_knb gc2_e4_knb 0 0 nch W=4e-06 L=4e-06
ngc2_e4_kmt gc2_e4_ktail gc2_e4_knb 0 0 nch W=4e-06 L=4e-06
ngc2_e4_km1 gc2_e4_kd1 gc2_e4_vm gc2_e4_ktail 0 nch W=4e-06 L=4e-06
ngc2_e4_km2 gc2_e4_ko1 gc2_e4_h gc2_e4_ktail 0 nch W=4e-06 L=4e-06
ngc2_e4_km3 gc2_e4_kd1 gc2_e4_kd1 vdd vsrc pch W=4e-06 L=4e-06
ngc2_e4_km4 gc2_e4_ko1 gc2_e4_kd1 vdd vsrc pch W=4e-06 L=4e-06
ngc2_e4_ki1p gc2_e4_qb gc2_e4_ko1 vdd vsrc pch W=2.4e-06 L=5e-07
ngc2_e4_ki1n gc2_e4_qb gc2_e4_ko1 0 0 nch W=1.2e-06 L=5e-07
ngc2_e4_ki2p gc2_e4_q gc2_e4_qb vdd vsrc pch W=2.4e-06 L=5e-07
ngc2_e4_ki2n gc2_e4_q gc2_e4_qb 0 0 nch W=1.2e-06 L=5e-07
rgc2_e4_hra gc2_e4_h vthe 1e+06
rgc2_e4_hrf gc2_e4_h gc2_e4_qb 1.9e+07
cgc2_e4_hc gc2_e4_h 0 2.1e-09
ngc2_e4_dis gc2_e4_vm gc2_e4_q gc2_e4_vmd 0 nch W=4e-06 L=1e-06
rgc2_e4_rdis gc2_e4_vmd vrest 220000
ngc2_e4_rp gc2_e4_rt gc2_e4_qb vdd vsrc pch W=2e-06 L=1e-06
rgc2_e4_rrc gc2_e4_rt gc2_e4_rec 10000
cgc2_e4_rc gc2_e4_rec 0 1e-07
rgc2_e4_rr gc2_e4_rec 0 8.2e+06
ngc2_e4_sh1 gc2_e4_vm gc2_e4_rec gc2_e4_vms 0 nch W=2e-06 L=1e-06
ngc2_e4_sh2 gc2_e4_vms gc2_e4_qb vrest 0 nch W=2e-06 L=1e-06
ngc2_e4_porh gc2_e4_h por_hold vthe 0 nch W=2e-06 L=1e-06
ngc2_e4_porm gc2_e4_vm por_hold vrest 0 nch W=2e-06 L=1e-06
ngc2_e4_ip gc2_e4_vm s2_yb vdd vsrc pch W=4e-06 L=4e-06
ngc2_e4_in gc2_e4_vm s2_za 0 0 nch W=4e-06 L=4e-06
ngc2_b4_sw gc2_b4_t gc2_e4_qb vdd vsrc pch W=2e-06 L=1e-06
rgc2_b4_rc gc2_b4_t gc2_b4 10000
cgc2_b4_c gc2_b4 0 1e-07
rgc2_b4_rl gc2_b4 0 2.2e+07
ngc2_b4_sh1p gc2_b4_n gc2_b4 vdd vsrc pch W=2.4e-06 L=5e-07
ngc2_b4_sh1n gc2_b4_n gc2_b4 0 0 nch W=1.2e-06 L=5e-07
ngc2_b4_sh2p gc2_b4_q gc2_b4_n vdd vsrc pch W=2.4e-06 L=5e-07
ngc2_b4_sh2n gc2_b4_q gc2_b4_n 0 0 nch W=1.2e-06 L=5e-07
cgc2_e5_cm gc2_e5_vm 0 1e-07
rgc2_e5_rm gc2_e5_vm vrest 1e+06
ngc2_e5_bias0 gc2_e5_vm istep_n 0 0 nch W=4e-06 L=4e-06
ngc2_e5_bias1 gc2_e5_vm istep_n 0 0 nch W=4e-06 L=4e-06
ngc2_e5_bias2 gc2_e5_vm istep_n 0 0 nch W=4e-06 L=4e-06
ngc2_e5_bias3 gc2_e5_vm istep_n 0 0 nch W=4e-06 L=4e-06
ngc2_e5_bias4 gc2_e5_vm istep_n 0 0 nch W=4e-06 L=4e-06
rgc2_e5_kb vdd gc2_e5_knb 1e+06
ngc2_e5_kmb gc2_e5_knb gc2_e5_knb 0 0 nch W=4e-06 L=4e-06
ngc2_e5_kmt gc2_e5_ktail gc2_e5_knb 0 0 nch W=4e-06 L=4e-06
ngc2_e5_km1 gc2_e5_kd1 gc2_e5_vm gc2_e5_ktail 0 nch W=4e-06 L=4e-06
ngc2_e5_km2 gc2_e5_ko1 gc2_e5_h gc2_e5_ktail 0 nch W=4e-06 L=4e-06
ngc2_e5_km3 gc2_e5_kd1 gc2_e5_kd1 vdd vsrc pch W=4e-06 L=4e-06
ngc2_e5_km4 gc2_e5_ko1 gc2_e5_kd1 vdd vsrc pch W=4e-06 L=4e-06
ngc2_e5_ki1p gc2_e5_qb gc2_e5_ko1 vdd vsrc pch W=2.4e-06 L=5e-07
ngc2_e5_ki1n gc2_e5_qb gc2_e5_ko1 0 0 nch W=1.2e-06 L=5e-07
ngc2_e5_ki2p gc2_e5_q gc2_e5_qb vdd vsrc pch W=2.4e-06 L=5e-07
ngc2_e5_ki2n gc2_e5_q gc2_e5_qb 0 0 nch W=1.2e-06 L=5e-07
rgc2_e5_hra gc2_e5_h vthe 1e+06
rgc2_e5_hrf gc2_e5_h gc2_e5_qb 1.9e+07
cgc2_e5_hc gc2_e5_h 0 2.1e-09
ngc2_e5_dis gc2_e5_vm gc2_e5_q gc2_e5_vmd 0 nch W=4e-06 L=1e-06
rgc2_e5_rdis gc2_e5_vmd vrest 220000
ngc2_e5_rp gc2_e5_rt gc2_e5_qb vdd vsrc pch W=2e-06 L=1e-06
rgc2_e5_rrc gc2_e5_rt gc2_e5_rec 10000
cgc2_e5_rc gc2_e5_rec 0 1e-07
rgc2_e5_rr gc2_e5_rec 0 8.2e+06
ngc2_e5_sh1 gc2_e5_vm gc2_e5_rec gc2_e5_vms 0 nch W=2e-06 L=1e-06
ngc2_e5_sh2 gc2_e5_vms gc2_e5_qb vrest 0 nch W=2e-06 L=1e-06
ngc2_e5_porh gc2_e5_h por_hold vthe 0 nch W=2e-06 L=1e-06
ngc2_e5_porm gc2_e5_vm por_hold vrest 0 nch W=2e-06 L=1e-06
ngc2_e5_ip gc2_e5_vm s2_yb vdd vsrc pch W=4e-06 L=4e-06
ngc2_e5_in gc2_e5_vm s2_za 0 0 nch W=4e-06 L=4e-06
ngc2_b5_sw gc2_b5_t gc2_e5_qb vdd vsrc pch W=2e-06 L=1e-06
rgc2_b5_rc gc2_b5_t gc2_b5 10000
cgc2_b5_c gc2_b5 0 1e-07
rgc2_b5_rl gc2_b5 0 2.2e+07
ngc2_b5_sh1p gc2_b5_n gc2_b5 vdd vsrc pch W=2.4e-06 L=5e-07
ngc2_b5_sh1n gc2_b5_n gc2_b5 0 0 nch W=1.2e-06 L=5e-07
ngc2_b5_sh2p gc2_b5_q gc2_b5_n vdd vsrc pch W=2.4e-06 L=5e-07
ngc2_b5_sh2n gc2_b5_q gc2_b5_n 0 0 nch W=1.2e-06 L=5e-07
cgc2_e6_cm gc2_e6_vm 0 1e-07
rgc2_e6_rm gc2_e6_vm vrest 1e+06
ngc2_e6_bias0 gc2_e6_vm istep_n 0 0 nch W=4e-06 L=4e-06
ngc2_e6_bias1 gc2_e6_vm istep_n 0 0 nch W=4e-06 L=4e-06
ngc2_e6_bias2 gc2_e6_vm istep_n 0 0 nch W=4e-06 L=4e-06
ngc2_e6_bias3 gc2_e6_vm istep_n 0 0 nch W=4e-06 L=4e-06
ngc2_e6_bias4 gc2_e6_vm istep_n 0 0 nch W=4e-06 L=4e-06
ngc2_e6_bias5 gc2_e6_vm istep_n 0 0 nch W=4e-06 L=4e-06
rgc2_e6_kb vdd gc2_e6_knb 1e+06
ngc2_e6_kmb gc2_e6_knb gc2_e6_knb 0 0 nch W=4e-06 L=4e-06
ngc2_e6_kmt gc2_e6_ktail gc2_e6_knb 0 0 nch W=4e-06 L=4e-06
ngc2_e6_km1 gc2_e6_kd1 gc2_e6_vm gc2_e6_ktail 0 nch W=4e-06 L=4e-06
ngc2_e6_km2 gc2_e6_ko1 gc2_e6_h gc2_e6_ktail 0 nch W=4e-06 L=4e-06
ngc2_e6_km3 gc2_e6_kd1 gc2_e6_kd1 vdd vsrc pch W=4e-06 L=4e-06
ngc2_e6_km4 gc2_e6_ko1 gc2_e6_kd1 vdd vsrc pch W=4e-06 L=4e-06
ngc2_e6_ki1p gc2_e6_qb gc2_e6_ko1 vdd vsrc pch W=2.4e-06 L=5e-07
ngc2_e6_ki1n gc2_e6_qb gc2_e6_ko1 0 0 nch W=1.2e-06 L=5e-07
ngc2_e6_ki2p gc2_e6_q gc2_e6_qb vdd vsrc pch W=2.4e-06 L=5e-07
ngc2_e6_ki2n gc2_e6_q gc2_e6_qb 0 0 nch W=1.2e-06 L=5e-07
rgc2_e6_hra gc2_e6_h vthe 1e+06
rgc2_e6_hrf gc2_e6_h gc2_e6_qb 1.9e+07
cgc2_e6_hc gc2_e6_h 0 2.1e-09
ngc2_e6_dis gc2_e6_vm gc2_e6_q gc2_e6_vmd 0 nch W=4e-06 L=1e-06
rgc2_e6_rdis gc2_e6_vmd vrest 220000
ngc2_e6_rp gc2_e6_rt gc2_e6_qb vdd vsrc pch W=2e-06 L=1e-06
rgc2_e6_rrc gc2_e6_rt gc2_e6_rec 10000
cgc2_e6_rc gc2_e6_rec 0 1e-07
rgc2_e6_rr gc2_e6_rec 0 8.2e+06
ngc2_e6_sh1 gc2_e6_vm gc2_e6_rec gc2_e6_vms 0 nch W=2e-06 L=1e-06
ngc2_e6_sh2 gc2_e6_vms gc2_e6_qb vrest 0 nch W=2e-06 L=1e-06
ngc2_e6_porh gc2_e6_h por_hold vthe 0 nch W=2e-06 L=1e-06
ngc2_e6_porm gc2_e6_vm por_hold vrest 0 nch W=2e-06 L=1e-06
ngc2_e6_ip gc2_e6_vm s2_yb vdd vsrc pch W=4e-06 L=4e-06
ngc2_e6_in gc2_e6_vm s2_za 0 0 nch W=4e-06 L=4e-06
ngc2_b6_sw gc2_b6_t gc2_e6_qb vdd vsrc pch W=2e-06 L=1e-06
rgc2_b6_rc gc2_b6_t gc2_b6 10000
cgc2_b6_c gc2_b6 0 1e-07
rgc2_b6_rl gc2_b6 0 2.2e+07
ngc2_b6_sh1p gc2_b6_n gc2_b6 vdd vsrc pch W=2.4e-06 L=5e-07
ngc2_b6_sh1n gc2_b6_n gc2_b6 0 0 nch W=1.2e-06 L=5e-07
ngc2_b6_sh2p gc2_b6_q gc2_b6_n vdd vsrc pch W=2.4e-06 L=5e-07
ngc2_b6_sh2n gc2_b6_q gc2_b6_n 0 0 nch W=1.2e-06 L=5e-07
cgc2_e7_cm gc2_e7_vm 0 1e-07
rgc2_e7_rm gc2_e7_vm vrest 1e+06
ngc2_e7_bias0 gc2_e7_vm istep_n 0 0 nch W=4e-06 L=4e-06
ngc2_e7_bias1 gc2_e7_vm istep_n 0 0 nch W=4e-06 L=4e-06
ngc2_e7_bias2 gc2_e7_vm istep_n 0 0 nch W=4e-06 L=4e-06
ngc2_e7_bias3 gc2_e7_vm istep_n 0 0 nch W=4e-06 L=4e-06
ngc2_e7_bias4 gc2_e7_vm istep_n 0 0 nch W=4e-06 L=4e-06
ngc2_e7_bias5 gc2_e7_vm istep_n 0 0 nch W=4e-06 L=4e-06
ngc2_e7_bias6 gc2_e7_vm istep_n 0 0 nch W=4e-06 L=4e-06
rgc2_e7_kb vdd gc2_e7_knb 1e+06
ngc2_e7_kmb gc2_e7_knb gc2_e7_knb 0 0 nch W=4e-06 L=4e-06
ngc2_e7_kmt gc2_e7_ktail gc2_e7_knb 0 0 nch W=4e-06 L=4e-06
ngc2_e7_km1 gc2_e7_kd1 gc2_e7_vm gc2_e7_ktail 0 nch W=4e-06 L=4e-06
ngc2_e7_km2 gc2_e7_ko1 gc2_e7_h gc2_e7_ktail 0 nch W=4e-06 L=4e-06
ngc2_e7_km3 gc2_e7_kd1 gc2_e7_kd1 vdd vsrc pch W=4e-06 L=4e-06
ngc2_e7_km4 gc2_e7_ko1 gc2_e7_kd1 vdd vsrc pch W=4e-06 L=4e-06
ngc2_e7_ki1p gc2_e7_qb gc2_e7_ko1 vdd vsrc pch W=2.4e-06 L=5e-07
ngc2_e7_ki1n gc2_e7_qb gc2_e7_ko1 0 0 nch W=1.2e-06 L=5e-07
ngc2_e7_ki2p gc2_e7_q gc2_e7_qb vdd vsrc pch W=2.4e-06 L=5e-07
ngc2_e7_ki2n gc2_e7_q gc2_e7_qb 0 0 nch W=1.2e-06 L=5e-07
rgc2_e7_hra gc2_e7_h vthe 1e+06
rgc2_e7_hrf gc2_e7_h gc2_e7_qb 1.9e+07
cgc2_e7_hc gc2_e7_h 0 2.1e-09
ngc2_e7_dis gc2_e7_vm gc2_e7_q gc2_e7_vmd 0 nch W=4e-06 L=1e-06
rgc2_e7_rdis gc2_e7_vmd vrest 220000
ngc2_e7_rp gc2_e7_rt gc2_e7_qb vdd vsrc pch W=2e-06 L=1e-06
rgc2_e7_rrc gc2_e7_rt gc2_e7_rec 10000
cgc2_e7_rc gc2_e7_rec 0 1e-07
rgc2_e7_rr gc2_e7_rec 0 8.2e+06
ngc2_e7_sh1 gc2_e7_vm gc2_e7_rec gc2_e7_vms 0 nch W=2e-06 L=1e-06
ngc2_e7_sh2 gc2_e7_vms gc2_e7_qb vrest 0 nch W=2e-06 L=1e-06
ngc2_e7_porh gc2_e7_h por_hold vthe 0 nch W=2e-06 L=1e-06
ngc2_e7_porm gc2_e7_vm por_hold vrest 0 nch W=2e-06 L=1e-06
ngc2_e7_ip gc2_e7_vm s2_yb vdd vsrc pch W=4e-06 L=4e-06
ngc2_e7_in gc2_e7_vm s2_za 0 0 nch W=4e-06 L=4e-06
ngc2_b7_sw gc2_b7_t gc2_e7_qb vdd vsrc pch W=2e-06 L=1e-06
rgc2_b7_rc gc2_b7_t gc2_b7 10000
cgc2_b7_c gc2_b7 0 1e-07
rgc2_b7_rl gc2_b7 0 2.2e+07
ngc2_b7_sh1p gc2_b7_n gc2_b7 vdd vsrc pch W=2.4e-06 L=5e-07
ngc2_b7_sh1n gc2_b7_n gc2_b7 0 0 nch W=1.2e-06 L=5e-07
ngc2_b7_sh2p gc2_b7_q gc2_b7_n vdd vsrc pch W=2.4e-06 L=5e-07
ngc2_b7_sh2n gc2_b7_q gc2_b7_n 0 0 nch W=1.2e-06 L=5e-07
cgc2_e8_cm gc2_e8_vm 0 1e-07
rgc2_e8_rm gc2_e8_vm vrest 1e+06
ngc2_e8_bias0 gc2_e8_vm istep_n 0 0 nch W=4e-06 L=4e-06
ngc2_e8_bias1 gc2_e8_vm istep_n 0 0 nch W=4e-06 L=4e-06
ngc2_e8_bias2 gc2_e8_vm istep_n 0 0 nch W=4e-06 L=4e-06
ngc2_e8_bias3 gc2_e8_vm istep_n 0 0 nch W=4e-06 L=4e-06
ngc2_e8_bias4 gc2_e8_vm istep_n 0 0 nch W=4e-06 L=4e-06
ngc2_e8_bias5 gc2_e8_vm istep_n 0 0 nch W=4e-06 L=4e-06
ngc2_e8_bias6 gc2_e8_vm istep_n 0 0 nch W=4e-06 L=4e-06
ngc2_e8_bias7 gc2_e8_vm istep_n 0 0 nch W=4e-06 L=4e-06
rgc2_e8_kb vdd gc2_e8_knb 1e+06
ngc2_e8_kmb gc2_e8_knb gc2_e8_knb 0 0 nch W=4e-06 L=4e-06
ngc2_e8_kmt gc2_e8_ktail gc2_e8_knb 0 0 nch W=4e-06 L=4e-06
ngc2_e8_km1 gc2_e8_kd1 gc2_e8_vm gc2_e8_ktail 0 nch W=4e-06 L=4e-06
ngc2_e8_km2 gc2_e8_ko1 gc2_e8_h gc2_e8_ktail 0 nch W=4e-06 L=4e-06
ngc2_e8_km3 gc2_e8_kd1 gc2_e8_kd1 vdd vsrc pch W=4e-06 L=4e-06
ngc2_e8_km4 gc2_e8_ko1 gc2_e8_kd1 vdd vsrc pch W=4e-06 L=4e-06
ngc2_e8_ki1p gc2_e8_qb gc2_e8_ko1 vdd vsrc pch W=2.4e-06 L=5e-07
ngc2_e8_ki1n gc2_e8_qb gc2_e8_ko1 0 0 nch W=1.2e-06 L=5e-07
ngc2_e8_ki2p gc2_e8_q gc2_e8_qb vdd vsrc pch W=2.4e-06 L=5e-07
ngc2_e8_ki2n gc2_e8_q gc2_e8_qb 0 0 nch W=1.2e-06 L=5e-07
rgc2_e8_hra gc2_e8_h vthe 1e+06
rgc2_e8_hrf gc2_e8_h gc2_e8_qb 1.9e+07
cgc2_e8_hc gc2_e8_h 0 2.1e-09
ngc2_e8_dis gc2_e8_vm gc2_e8_q gc2_e8_vmd 0 nch W=4e-06 L=1e-06
rgc2_e8_rdis gc2_e8_vmd vrest 220000
ngc2_e8_rp gc2_e8_rt gc2_e8_qb vdd vsrc pch W=2e-06 L=1e-06
rgc2_e8_rrc gc2_e8_rt gc2_e8_rec 10000
cgc2_e8_rc gc2_e8_rec 0 1e-07
rgc2_e8_rr gc2_e8_rec 0 8.2e+06
ngc2_e8_sh1 gc2_e8_vm gc2_e8_rec gc2_e8_vms 0 nch W=2e-06 L=1e-06
ngc2_e8_sh2 gc2_e8_vms gc2_e8_qb vrest 0 nch W=2e-06 L=1e-06
ngc2_e8_porh gc2_e8_h por_hold vthe 0 nch W=2e-06 L=1e-06
ngc2_e8_porm gc2_e8_vm por_hold vrest 0 nch W=2e-06 L=1e-06
ngc2_e8_ip gc2_e8_vm s2_yb vdd vsrc pch W=4e-06 L=4e-06
ngc2_e8_in gc2_e8_vm s2_za 0 0 nch W=4e-06 L=4e-06
ngc2_b8_sw gc2_b8_t gc2_e8_qb vdd vsrc pch W=2e-06 L=1e-06
rgc2_b8_rc gc2_b8_t gc2_b8 10000
cgc2_b8_c gc2_b8 0 1e-07
rgc2_b8_rl gc2_b8 0 2.2e+07
ngc2_b8_sh1p gc2_b8_n gc2_b8 vdd vsrc pch W=2.4e-06 L=5e-07
ngc2_b8_sh1n gc2_b8_n gc2_b8 0 0 nch W=1.2e-06 L=5e-07
ngc2_b8_sh2p gc2_b8_q gc2_b8_n vdd vsrc pch W=2.4e-06 L=5e-07
ngc2_b8_sh2n gc2_b8_q gc2_b8_n 0 0 nch W=1.2e-06 L=5e-07
cgc2_e9_cm gc2_e9_vm 0 1e-07
rgc2_e9_rm gc2_e9_vm vrest 1e+06
ngc2_e9_bias0 gc2_e9_vm istep_n 0 0 nch W=4e-06 L=4e-06
ngc2_e9_bias1 gc2_e9_vm istep_n 0 0 nch W=4e-06 L=4e-06
ngc2_e9_bias2 gc2_e9_vm istep_n 0 0 nch W=4e-06 L=4e-06
ngc2_e9_bias3 gc2_e9_vm istep_n 0 0 nch W=4e-06 L=4e-06
ngc2_e9_bias4 gc2_e9_vm istep_n 0 0 nch W=4e-06 L=4e-06
ngc2_e9_bias5 gc2_e9_vm istep_n 0 0 nch W=4e-06 L=4e-06
ngc2_e9_bias6 gc2_e9_vm istep_n 0 0 nch W=4e-06 L=4e-06
ngc2_e9_bias7 gc2_e9_vm istep_n 0 0 nch W=4e-06 L=4e-06
ngc2_e9_bias8 gc2_e9_vm istep_n 0 0 nch W=4e-06 L=4e-06
rgc2_e9_kb vdd gc2_e9_knb 1e+06
ngc2_e9_kmb gc2_e9_knb gc2_e9_knb 0 0 nch W=4e-06 L=4e-06
ngc2_e9_kmt gc2_e9_ktail gc2_e9_knb 0 0 nch W=4e-06 L=4e-06
ngc2_e9_km1 gc2_e9_kd1 gc2_e9_vm gc2_e9_ktail 0 nch W=4e-06 L=4e-06
ngc2_e9_km2 gc2_e9_ko1 gc2_e9_h gc2_e9_ktail 0 nch W=4e-06 L=4e-06
ngc2_e9_km3 gc2_e9_kd1 gc2_e9_kd1 vdd vsrc pch W=4e-06 L=4e-06
ngc2_e9_km4 gc2_e9_ko1 gc2_e9_kd1 vdd vsrc pch W=4e-06 L=4e-06
ngc2_e9_ki1p gc2_e9_qb gc2_e9_ko1 vdd vsrc pch W=2.4e-06 L=5e-07
ngc2_e9_ki1n gc2_e9_qb gc2_e9_ko1 0 0 nch W=1.2e-06 L=5e-07
ngc2_e9_ki2p gc2_e9_q gc2_e9_qb vdd vsrc pch W=2.4e-06 L=5e-07
ngc2_e9_ki2n gc2_e9_q gc2_e9_qb 0 0 nch W=1.2e-06 L=5e-07
rgc2_e9_hra gc2_e9_h vthe 1e+06
rgc2_e9_hrf gc2_e9_h gc2_e9_qb 1.9e+07
cgc2_e9_hc gc2_e9_h 0 2.1e-09
ngc2_e9_dis gc2_e9_vm gc2_e9_q gc2_e9_vmd 0 nch W=4e-06 L=1e-06
rgc2_e9_rdis gc2_e9_vmd vrest 220000
ngc2_e9_rp gc2_e9_rt gc2_e9_qb vdd vsrc pch W=2e-06 L=1e-06
rgc2_e9_rrc gc2_e9_rt gc2_e9_rec 10000
cgc2_e9_rc gc2_e9_rec 0 1e-07
rgc2_e9_rr gc2_e9_rec 0 8.2e+06
ngc2_e9_sh1 gc2_e9_vm gc2_e9_rec gc2_e9_vms 0 nch W=2e-06 L=1e-06
ngc2_e9_sh2 gc2_e9_vms gc2_e9_qb vrest 0 nch W=2e-06 L=1e-06
ngc2_e9_porh gc2_e9_h por_hold vthe 0 nch W=2e-06 L=1e-06
ngc2_e9_porm gc2_e9_vm por_hold vrest 0 nch W=2e-06 L=1e-06
ngc2_e9_ip gc2_e9_vm s2_yb vdd vsrc pch W=4e-06 L=4e-06
ngc2_e9_in gc2_e9_vm s2_za 0 0 nch W=4e-06 L=4e-06
ngc2_b9_sw gc2_b9_t gc2_e9_qb vdd vsrc pch W=2e-06 L=1e-06
rgc2_b9_rc gc2_b9_t gc2_b9 10000
cgc2_b9_c gc2_b9 0 1e-07
rgc2_b9_rl gc2_b9 0 2.2e+07
ngc2_b9_sh1p gc2_b9_n gc2_b9 vdd vsrc pch W=2.4e-06 L=5e-07
ngc2_b9_sh1n gc2_b9_n gc2_b9 0 0 nch W=1.2e-06 L=5e-07
ngc2_b9_sh2p gc2_b9_q gc2_b9_n vdd vsrc pch W=2.4e-06 L=5e-07
ngc2_b9_sh2n gc2_b9_q gc2_b9_n 0 0 nch W=1.2e-06 L=5e-07
cgc2_e10_cm gc2_e10_vm 0 1e-07
rgc2_e10_rm gc2_e10_vm vrest 1e+06
ngc2_e10_bias0 gc2_e10_vm istep_n 0 0 nch W=4e-06 L=4e-06
ngc2_e10_bias1 gc2_e10_vm istep_n 0 0 nch W=4e-06 L=4e-06
ngc2_e10_bias2 gc2_e10_vm istep_n 0 0 nch W=4e-06 L=4e-06
ngc2_e10_bias3 gc2_e10_vm istep_n 0 0 nch W=4e-06 L=4e-06
ngc2_e10_bias4 gc2_e10_vm istep_n 0 0 nch W=4e-06 L=4e-06
ngc2_e10_bias5 gc2_e10_vm istep_n 0 0 nch W=4e-06 L=4e-06
ngc2_e10_bias6 gc2_e10_vm istep_n 0 0 nch W=4e-06 L=4e-06
ngc2_e10_bias7 gc2_e10_vm istep_n 0 0 nch W=4e-06 L=4e-06
ngc2_e10_bias8 gc2_e10_vm istep_n 0 0 nch W=4e-06 L=4e-06
ngc2_e10_bias9 gc2_e10_vm istep_n 0 0 nch W=4e-06 L=4e-06
rgc2_e10_kb vdd gc2_e10_knb 1e+06
ngc2_e10_kmb gc2_e10_knb gc2_e10_knb 0 0 nch W=4e-06 L=4e-06
ngc2_e10_kmt gc2_e10_ktail gc2_e10_knb 0 0 nch W=4e-06 L=4e-06
ngc2_e10_km1 gc2_e10_kd1 gc2_e10_vm gc2_e10_ktail 0 nch W=4e-06 L=4e-06
ngc2_e10_km2 gc2_e10_ko1 gc2_e10_h gc2_e10_ktail 0 nch W=4e-06 L=4e-06
ngc2_e10_km3 gc2_e10_kd1 gc2_e10_kd1 vdd vsrc pch W=4e-06 L=4e-06
ngc2_e10_km4 gc2_e10_ko1 gc2_e10_kd1 vdd vsrc pch W=4e-06 L=4e-06
ngc2_e10_ki1p gc2_e10_qb gc2_e10_ko1 vdd vsrc pch W=2.4e-06 L=5e-07
ngc2_e10_ki1n gc2_e10_qb gc2_e10_ko1 0 0 nch W=1.2e-06 L=5e-07
ngc2_e10_ki2p gc2_e10_q gc2_e10_qb vdd vsrc pch W=2.4e-06 L=5e-07
ngc2_e10_ki2n gc2_e10_q gc2_e10_qb 0 0 nch W=1.2e-06 L=5e-07
rgc2_e10_hra gc2_e10_h vthe 1e+06
rgc2_e10_hrf gc2_e10_h gc2_e10_qb 1.9e+07
cgc2_e10_hc gc2_e10_h 0 2.1e-09
ngc2_e10_dis gc2_e10_vm gc2_e10_q gc2_e10_vmd 0 nch W=4e-06 L=1e-06
rgc2_e10_rdis gc2_e10_vmd vrest 220000
ngc2_e10_rp gc2_e10_rt gc2_e10_qb vdd vsrc pch W=2e-06 L=1e-06
rgc2_e10_rrc gc2_e10_rt gc2_e10_rec 10000
cgc2_e10_rc gc2_e10_rec 0 1e-07
rgc2_e10_rr gc2_e10_rec 0 8.2e+06
ngc2_e10_sh1 gc2_e10_vm gc2_e10_rec gc2_e10_vms 0 nch W=2e-06 L=1e-06
ngc2_e10_sh2 gc2_e10_vms gc2_e10_qb vrest 0 nch W=2e-06 L=1e-06
ngc2_e10_porh gc2_e10_h por_hold vthe 0 nch W=2e-06 L=1e-06
ngc2_e10_porm gc2_e10_vm por_hold vrest 0 nch W=2e-06 L=1e-06
ngc2_e10_ip gc2_e10_vm s2_yb vdd vsrc pch W=4e-06 L=4e-06
ngc2_e10_in gc2_e10_vm s2_za 0 0 nch W=4e-06 L=4e-06
ngc2_b10_sw gc2_b10_t gc2_e10_qb vdd vsrc pch W=2e-06 L=1e-06
rgc2_b10_rc gc2_b10_t gc2_b10 10000
cgc2_b10_c gc2_b10 0 1e-07
rgc2_b10_rl gc2_b10 0 2.2e+07
ngc2_b10_sh1p gc2_b10_n gc2_b10 vdd vsrc pch W=2.4e-06 L=5e-07
ngc2_b10_sh1n gc2_b10_n gc2_b10 0 0 nch W=1.2e-06 L=5e-07
ngc2_b10_sh2p gc2_b10_q gc2_b10_n vdd vsrc pch W=2.4e-06 L=5e-07
ngc2_b10_sh2n gc2_b10_q gc2_b10_n 0 0 nch W=1.2e-06 L=5e-07
ngc2_and_a0_npa gc2_and_a0_nb gc2_b1_q vdd vsrc pch W=2.4e-06 L=5e-07
ngc2_and_a0_npb gc2_and_a0_nb gc2_b2_q vdd vsrc pch W=2.4e-06 L=5e-07
ngc2_and_a0_nna gc2_and_a0_nb gc2_b1_q gc2_and_a0_nx 0 nch W=2.4e-06 L=5e-07
ngc2_and_a0_nnb gc2_and_a0_nx gc2_b2_q 0 0 nch W=2.4e-06 L=5e-07
ngc2_and_a0_ip gc2_and_g0 gc2_and_a0_nb vdd vsrc pch W=2.4e-06 L=5e-07
ngc2_and_a0_in gc2_and_g0 gc2_and_a0_nb 0 0 nch W=1.2e-06 L=5e-07
ngc2_and_a1_npa gc2_and_a1_nb gc2_b3_q vdd vsrc pch W=2.4e-06 L=5e-07
ngc2_and_a1_npb gc2_and_a1_nb gc2_b4_q vdd vsrc pch W=2.4e-06 L=5e-07
ngc2_and_a1_nna gc2_and_a1_nb gc2_b3_q gc2_and_a1_nx 0 nch W=2.4e-06 L=5e-07
ngc2_and_a1_nnb gc2_and_a1_nx gc2_b4_q 0 0 nch W=2.4e-06 L=5e-07
ngc2_and_a1_ip gc2_and_g1 gc2_and_a1_nb vdd vsrc pch W=2.4e-06 L=5e-07
ngc2_and_a1_in gc2_and_g1 gc2_and_a1_nb 0 0 nch W=1.2e-06 L=5e-07
ngc2_and_a2_npa gc2_and_a2_nb gc2_b5_q vdd vsrc pch W=2.4e-06 L=5e-07
ngc2_and_a2_npb gc2_and_a2_nb gc2_b6_q vdd vsrc pch W=2.4e-06 L=5e-07
ngc2_and_a2_nna gc2_and_a2_nb gc2_b5_q gc2_and_a2_nx 0 nch W=2.4e-06 L=5e-07
ngc2_and_a2_nnb gc2_and_a2_nx gc2_b6_q 0 0 nch W=2.4e-06 L=5e-07
ngc2_and_a2_ip gc2_and_g2 gc2_and_a2_nb vdd vsrc pch W=2.4e-06 L=5e-07
ngc2_and_a2_in gc2_and_g2 gc2_and_a2_nb 0 0 nch W=1.2e-06 L=5e-07
ngc2_and_a3_npa gc2_and_a3_nb gc2_b7_q vdd vsrc pch W=2.4e-06 L=5e-07
ngc2_and_a3_npb gc2_and_a3_nb gc2_b8_q vdd vsrc pch W=2.4e-06 L=5e-07
ngc2_and_a3_nna gc2_and_a3_nb gc2_b7_q gc2_and_a3_nx 0 nch W=2.4e-06 L=5e-07
ngc2_and_a3_nnb gc2_and_a3_nx gc2_b8_q 0 0 nch W=2.4e-06 L=5e-07
ngc2_and_a3_ip gc2_and_g3 gc2_and_a3_nb vdd vsrc pch W=2.4e-06 L=5e-07
ngc2_and_a3_in gc2_and_g3 gc2_and_a3_nb 0 0 nch W=1.2e-06 L=5e-07
ngc2_and_a4_npa gc2_and_a4_nb gc2_b9_q vdd vsrc pch W=2.4e-06 L=5e-07
ngc2_and_a4_npb gc2_and_a4_nb gc2_b10_q vdd vsrc pch W=2.4e-06 L=5e-07
ngc2_and_a4_nna gc2_and_a4_nb gc2_b9_q gc2_and_a4_nx 0 nch W=2.4e-06 L=5e-07
ngc2_and_a4_nnb gc2_and_a4_nx gc2_b10_q 0 0 nch W=2.4e-06 L=5e-07
ngc2_and_a4_ip gc2_and_g4 gc2_and_a4_nb vdd vsrc pch W=2.4e-06 L=5e-07
ngc2_and_a4_in gc2_and_g4 gc2_and_a4_nb 0 0 nch W=1.2e-06 L=5e-07
ngc2_and_a5_npa gc2_and_a5_nb gc2_and_g0 vdd vsrc pch W=2.4e-06 L=5e-07
ngc2_and_a5_npb gc2_and_a5_nb gc2_and_g1 vdd vsrc pch W=2.4e-06 L=5e-07
ngc2_and_a5_nna gc2_and_a5_nb gc2_and_g0 gc2_and_a5_nx 0 nch W=2.4e-06 L=5e-07
ngc2_and_a5_nnb gc2_and_a5_nx gc2_and_g1 0 0 nch W=2.4e-06 L=5e-07
ngc2_and_a5_ip gc2_and_g5 gc2_and_a5_nb vdd vsrc pch W=2.4e-06 L=5e-07
ngc2_and_a5_in gc2_and_g5 gc2_and_a5_nb 0 0 nch W=1.2e-06 L=5e-07
ngc2_and_a6_npa gc2_and_a6_nb gc2_and_g2 vdd vsrc pch W=2.4e-06 L=5e-07
ngc2_and_a6_npb gc2_and_a6_nb gc2_and_g3 vdd vsrc pch W=2.4e-06 L=5e-07
ngc2_and_a6_nna gc2_and_a6_nb gc2_and_g2 gc2_and_a6_nx 0 nch W=2.4e-06 L=5e-07
ngc2_and_a6_nnb gc2_and_a6_nx gc2_and_g3 0 0 nch W=2.4e-06 L=5e-07
ngc2_and_a6_ip gc2_and_g6 gc2_and_a6_nb vdd vsrc pch W=2.4e-06 L=5e-07
ngc2_and_a6_in gc2_and_g6 gc2_and_a6_nb 0 0 nch W=1.2e-06 L=5e-07
ngc2_and_a7_npa gc2_and_a7_nb gc2_and_g5 vdd vsrc pch W=2.4e-06 L=5e-07
ngc2_and_a7_npb gc2_and_a7_nb gc2_and_g6 vdd vsrc pch W=2.4e-06 L=5e-07
ngc2_and_a7_nna gc2_and_a7_nb gc2_and_g5 gc2_and_a7_nx 0 nch W=2.4e-06 L=5e-07
ngc2_and_a7_nnb gc2_and_a7_nx gc2_and_g6 0 0 nch W=2.4e-06 L=5e-07
ngc2_and_a7_ip gc2_and_g7 gc2_and_a7_nb vdd vsrc pch W=2.4e-06 L=5e-07
ngc2_and_a7_in gc2_and_g7 gc2_and_a7_nb 0 0 nch W=1.2e-06 L=5e-07
ngc2_and_a8_npa gc2_and_a8_nb gc2_and_g7 vdd vsrc pch W=2.4e-06 L=5e-07
ngc2_and_a8_npb gc2_and_a8_nb gc2_and_g4 vdd vsrc pch W=2.4e-06 L=5e-07
ngc2_and_a8_nna gc2_and_a8_nb gc2_and_g7 gc2_and_a8_nx 0 nch W=2.4e-06 L=5e-07
ngc2_and_a8_nnb gc2_and_a8_nx gc2_and_g4 0 0 nch W=2.4e-06 L=5e-07
ngc2_and_a8_ip gc2_and_g8 gc2_and_a8_nb vdd vsrc pch W=2.4e-06 L=5e-07
ngc2_and_a8_in gc2_and_g8 gc2_and_a8_nb 0 0 nch W=1.2e-06 L=5e-07
ngc2_gip gc2_gb gc2_and_g8 vdd vsrc pch W=2.4e-06 L=5e-07
ngc2_gin gc2_gb gc2_and_g8 0 0 nch W=1.2e-06 L=5e-07
cgc2_col_cm gc2_col_vm 0 1e-07
rgc2_col_rm gc2_col_vm vrest 1e+06
rgc2_col_kb vdd gc2_col_knb 1e+06
ngc2_col_kmb gc2_col_knb gc2_col_knb 0 0 nch W=4e-06 L=4e-06
ngc2_col_kmt gc2_col_ktail gc2_col_knb 0 0 nch W=4e-06 L=4e-06
ngc2_col_km1 gc2_col_kd1 gc2_col_vm gc2_col_ktail 0 nch W=4e-06 L=4e-06
ngc2_col_km2 gc2_col_ko1 gc2_col_h gc2_col_ktail 0 nch W=4e-06 L=4e-06
ngc2_col_km3 gc2_col_kd1 gc2_col_kd1 vdd vsrc pch W=4e-06 L=4e-06
ngc2_col_km4 gc2_col_ko1 gc2_col_kd1 vdd vsrc pch W=4e-06 L=4e-06
ngc2_col_ki1p gc2_col_qb gc2_col_ko1 vdd vsrc pch W=2.4e-06 L=5e-07
ngc2_col_ki1n gc2_col_qb gc2_col_ko1 0 0 nch W=1.2e-06 L=5e-07
ngc2_col_ki2p gc2_col_q gc2_col_qb vdd vsrc pch W=2.4e-06 L=5e-07
ngc2_col_ki2n gc2_col_q gc2_col_qb 0 0 nch W=1.2e-06 L=5e-07
rgc2_col_hra gc2_col_h vthe 1e+06
rgc2_col_hrf gc2_col_h gc2_col_qb 1.9e+07
cgc2_col_hc gc2_col_h 0 2.1e-09
ngc2_col_dis gc2_col_vm gc2_col_q gc2_col_vmd 0 nch W=4e-06 L=1e-06
rgc2_col_rdis gc2_col_vmd vrest 220000
ngc2_col_rp gc2_col_rt gc2_col_qb vdd vsrc pch W=2e-06 L=1e-06
rgc2_col_rrc gc2_col_rt gc2_col_rec 10000
cgc2_col_rc gc2_col_rec 0 1e-07
rgc2_col_rr gc2_col_rec 0 8.2e+06
ngc2_col_sh1 gc2_col_vm gc2_col_rec gc2_col_vms 0 nch W=2e-06 L=1e-06
ngc2_col_sh2 gc2_col_vms gc2_col_qb vrest 0 nch W=2e-06 L=1e-06
ngc2_col_porh gc2_col_h por_hold vthe 0 nch W=2e-06 L=1e-06
ngc2_col_porm gc2_col_vm por_hold vrest 0 nch W=2e-06 L=1e-06
ngc2_cin_sw gc2_cin_x gc2_gb vdd vsrc pch W=4e-06 L=1e-06
ngc2_cin_cp gc2_col_vm ilimp_n gc2_cin_x vsrc pch W=4e-06 L=4e-06
ngc2_op_tsw gc2_op_tt gc2_col_qb vdd vsrc pch W=2e-06 L=1e-06
rgc2_op_trc gc2_op_tt gc2_op_at 10000
cgc2_op_tc gc2_op_at 0 1e-07
rgc2_op_trl gc2_op_at 0 2.2e+07
ngc2_op_sh1p gc2_op_an gc2_op_at vdd vsrc pch W=2.4e-06 L=5e-07
ngc2_op_sh1n gc2_op_an gc2_op_at 0 0 nch W=1.2e-06 L=5e-07
ngc2_op_sh2p gc2_op_aq gc2_op_an vdd vsrc pch W=2.4e-06 L=5e-07
ngc2_op_sh2n gc2_op_aq gc2_op_an 0 0 nch W=1.2e-06 L=5e-07
ngc2_op_abp gc2_op_aqb gc2_op_aq vdd vsrc pch W=2.4e-06 L=5e-07
ngc2_op_abn gc2_op_aqb gc2_op_aq 0 0 nch W=1.2e-06 L=5e-07
rgc2_op_dr gc2_op_aq gc2_op_ad 1e+06
cgc2_op_dc gc2_op_ad 0 3.3e-07
ngc2_op_d2p gc2_op_adn gc2_op_ad vdd vsrc pch W=2.4e-06 L=5e-07
ngc2_op_d2n gc2_op_adn gc2_op_ad 0 0 nch W=1.2e-06 L=5e-07
ngc2_op_gpa gc2_op_pb gc2_op_aq vdd vsrc pch W=2.4e-06 L=5e-07
ngc2_op_gpb gc2_op_pb gc2_op_adn vdd vsrc pch W=2.4e-06 L=5e-07
ngc2_op_gna gc2_op_pb gc2_op_aq gc2_op_gx 0 nch W=2.4e-06 L=5e-07
ngc2_op_gnb gc2_op_gx gc2_op_adn 0 0 nch W=2.4e-06 L=5e-07
ngc2_op_op gc2_op_p gc2_op_pb vdd vsrc pch W=2.4e-06 L=5e-07
ngc2_op_on gc2_op_p gc2_op_pb 0 0 nch W=1.2e-06 L=5e-07
nhsc1_sw hsc1_sd gc1_col_qb vdd vsrc pch W=4e-06 L=5e-07
rhsc1_rr hsc1_sd hsc1_h1 100000
chsc1_c1 hsc1_h1 0 1e-06
rhsc1_r2 hsc1_h1 hc1 1e+06
chsc1_c2 hc1 0 4.7e-07
rhsc1_rl hc1 0 4.7e+06
nhsc2_sw hsc2_sd gc2_col_qb vdd vsrc pch W=4e-06 L=5e-07
rhsc2_rr hsc2_sd hsc2_h1 100000
chsc2_c1 hsc2_h1 0 1e-06
rhsc2_r2 hsc2_h1 hc2 1e+06
chsc2_c2 hc2 0 4.7e-07
rhsc2_rl hc2 0 4.7e+06
nthc12f_st_mh thc12f_mi hc1 thc12f_st_x 0 nch W=2e-06 L=4e-06
nthc12f_st_mp thc12f_st_x gc2_op_aq 0 0 nch W=4e-06 L=1e-06
va_cthc12f_cm_p thc12f_vm cthc12f_cm_p 0
cthc12f_cm cthc12f_cm_p 0 1.5e-06
va_rthc12f_rm_p thc12f_vm rthc12f_rm_p 0
rthc12f_rm rthc12f_rm_p vrest 1e+06
rthc12f_kb vdd thc12f_knb 1e+06
nthc12f_kmb thc12f_knb thc12f_knb 0 0 nch W=4e-06 L=4e-06
nthc12f_kmt thc12f_ktail thc12f_knb 0 0 nch W=4e-06 L=4e-06
va_nthc12f_km1_g thc12f_vm nthc12f_km1_g 0
nthc12f_km1 thc12f_kd1 nthc12f_km1_g thc12f_ktail 0 nch W=4e-06 L=4e-06
nthc12f_km2 thc12f_ko1 thc12f_h thc12f_ktail 0 nch W=4e-06 L=4e-06
nthc12f_km3 thc12f_kd1 thc12f_kd1 vdd vsrc pch W=4e-06 L=4e-06
nthc12f_km4 thc12f_ko1 thc12f_kd1 vdd vsrc pch W=4e-06 L=4e-06
nthc12f_ki1p thc12f_qb thc12f_ko1 vdd vsrc pch W=2.4e-06 L=5e-07
nthc12f_ki1n thc12f_qb thc12f_ko1 0 0 nch W=1.2e-06 L=5e-07
nthc12f_ki2p thc12f_q thc12f_qb vdd vsrc pch W=2.4e-06 L=5e-07
nthc12f_ki2n thc12f_q thc12f_qb 0 0 nch W=1.2e-06 L=5e-07
rthc12f_hra thc12f_h vthr 1e+06
rthc12f_hrf thc12f_h thc12f_qb 1.9e+07
cthc12f_hc thc12f_h 0 2.1e-09
va_nthc12f_dis_d thc12f_vm nthc12f_dis_d 0
va_nthc12f_dis_s thc12f_vmd nthc12f_dis_s 0
nthc12f_dis nthc12f_dis_d thc12f_q nthc12f_dis_s 0 nch W=4e-06 L=1e-06
va_rthc12f_rdis_p thc12f_vmd rthc12f_rdis_p 0
rthc12f_rdis rthc12f_rdis_p vrest 12000
nthc12f_rp thc12f_rt thc12f_qb vdd vsrc pch W=2e-06 L=1e-06
rthc12f_rrc thc12f_rt thc12f_rec 10000
cthc12f_rc thc12f_rec 0 1e-07
rthc12f_rr thc12f_rec 0 8.2e+06
va_nthc12f_sh1_d thc12f_vm nthc12f_sh1_d 0
va_nthc12f_sh1_s thc12f_vms nthc12f_sh1_s 0
nthc12f_sh1 nthc12f_sh1_d thc12f_rec nthc12f_sh1_s 0 nch W=2e-06 L=1e-06
va_nthc12f_sh2_d thc12f_vms nthc12f_sh2_d 0
nthc12f_sh2 nthc12f_sh2_d thc12f_qb vrest 0 nch W=2e-06 L=1e-06
nthc12f_porh thc12f_h por_hold vthr 0 nch W=2e-06 L=1e-06
va_nthc12f_porm_d thc12f_vm nthc12f_porm_d 0
nthc12f_porm nthc12f_porm_d por_hold vrest 0 nch W=2e-06 L=1e-06
nthc12f_op_tsw thc12f_op_tt thc12f_qb vdd vsrc pch W=2e-06 L=1e-06
rthc12f_op_trc thc12f_op_tt thc12f_op_at 10000
cthc12f_op_tc thc12f_op_at 0 1e-07
rthc12f_op_trl thc12f_op_at 0 2.2e+07
nthc12f_op_sh1p thc12f_op_an thc12f_op_at vdd vsrc pch W=2.4e-06 L=5e-07
nthc12f_op_sh1n thc12f_op_an thc12f_op_at 0 0 nch W=1.2e-06 L=5e-07
nthc12f_op_sh2p thc12f_op_aq thc12f_op_an vdd vsrc pch W=2.4e-06 L=5e-07
nthc12f_op_sh2n thc12f_op_aq thc12f_op_an 0 0 nch W=1.2e-06 L=5e-07
nthc12f_op_abp thc12f_op_aqb thc12f_op_aq vdd vsrc pch W=2.4e-06 L=5e-07
nthc12f_op_abn thc12f_op_aqb thc12f_op_aq 0 0 nch W=1.2e-06 L=5e-07
rthc12f_op_dr thc12f_op_aq thc12f_op_ad 1e+06
cthc12f_op_dc thc12f_op_ad 0 3.3e-07
nthc12f_op_d2p thc12f_op_adn thc12f_op_ad vdd vsrc pch W=2.4e-06 L=5e-07
nthc12f_op_d2n thc12f_op_adn thc12f_op_ad 0 0 nch W=1.2e-06 L=5e-07
nthc12f_op_gpa thc12f_op_pb thc12f_op_aq vdd vsrc pch W=2.4e-06 L=5e-07
nthc12f_op_gpb thc12f_op_pb thc12f_op_adn vdd vsrc pch W=2.4e-06 L=5e-07
nthc12f_op_gna thc12f_op_pb thc12f_op_aq thc12f_op_gx 0 nch W=2.4e-06 L=5e-07
nthc12f_op_gnb thc12f_op_gx thc12f_op_adn 0 0 nch W=2.4e-06 L=5e-07
nthc12f_op_op thc12f_op_p thc12f_op_pb vdd vsrc pch W=2.4e-06 L=5e-07
nthc12f_op_on thc12f_op_p thc12f_op_pb 0 0 nch W=1.2e-06 L=5e-07
nthc12f_rm_md thc12f_mi thc12f_mi vdd vsrc pch W=4e-06 L=2e-06
va_nthc12f_rm_mo_d thc12f_vm nthc12f_rm_mo_d 0
nthc12f_rm_mo nthc12f_rm_mo_d thc12f_mi vdd vsrc pch W=1e-06 L=8e-06
nthc12r_st_mh thc12r_mi hc2 thc12r_st_x 0 nch W=2e-06 L=4e-06
nthc12r_st_mp thc12r_st_x gc1_op_aq 0 0 nch W=4e-06 L=1e-06
va_cthc12r_cm_p thc12r_vm cthc12r_cm_p 0
cthc12r_cm cthc12r_cm_p 0 1.5e-06
va_rthc12r_rm_p thc12r_vm rthc12r_rm_p 0
rthc12r_rm rthc12r_rm_p vrest 1e+06
rthc12r_kb vdd thc12r_knb 1e+06
nthc12r_kmb thc12r_knb thc12r_knb 0 0 nch W=4e-06 L=4e-06
nthc12r_kmt thc12r_ktail thc12r_knb 0 0 nch W=4e-06 L=4e-06
va_nthc12r_km1_g thc12r_vm nthc12r_km1_g 0
nthc12r_km1 thc12r_kd1 nthc12r_km1_g thc12r_ktail 0 nch W=4e-06 L=4e-06
nthc12r_km2 thc12r_ko1 thc12r_h thc12r_ktail 0 nch W=4e-06 L=4e-06
nthc12r_km3 thc12r_kd1 thc12r_kd1 vdd vsrc pch W=4e-06 L=4e-06
nthc12r_km4 thc12r_ko1 thc12r_kd1 vdd vsrc pch W=4e-06 L=4e-06
nthc12r_ki1p thc12r_qb thc12r_ko1 vdd vsrc pch W=2.4e-06 L=5e-07
nthc12r_ki1n thc12r_qb thc12r_ko1 0 0 nch W=1.2e-06 L=5e-07
nthc12r_ki2p thc12r_q thc12r_qb vdd vsrc pch W=2.4e-06 L=5e-07
nthc12r_ki2n thc12r_q thc12r_qb 0 0 nch W=1.2e-06 L=5e-07
rthc12r_hra thc12r_h vthr 1e+06
rthc12r_hrf thc12r_h thc12r_qb 1.9e+07
cthc12r_hc thc12r_h 0 2.1e-09
va_nthc12r_dis_d thc12r_vm nthc12r_dis_d 0
va_nthc12r_dis_s thc12r_vmd nthc12r_dis_s 0
nthc12r_dis nthc12r_dis_d thc12r_q nthc12r_dis_s 0 nch W=4e-06 L=1e-06
va_rthc12r_rdis_p thc12r_vmd rthc12r_rdis_p 0
rthc12r_rdis rthc12r_rdis_p vrest 12000
nthc12r_rp thc12r_rt thc12r_qb vdd vsrc pch W=2e-06 L=1e-06
rthc12r_rrc thc12r_rt thc12r_rec 10000
cthc12r_rc thc12r_rec 0 1e-07
rthc12r_rr thc12r_rec 0 8.2e+06
va_nthc12r_sh1_d thc12r_vm nthc12r_sh1_d 0
va_nthc12r_sh1_s thc12r_vms nthc12r_sh1_s 0
nthc12r_sh1 nthc12r_sh1_d thc12r_rec nthc12r_sh1_s 0 nch W=2e-06 L=1e-06
va_nthc12r_sh2_d thc12r_vms nthc12r_sh2_d 0
nthc12r_sh2 nthc12r_sh2_d thc12r_qb vrest 0 nch W=2e-06 L=1e-06
nthc12r_porh thc12r_h por_hold vthr 0 nch W=2e-06 L=1e-06
va_nthc12r_porm_d thc12r_vm nthc12r_porm_d 0
nthc12r_porm nthc12r_porm_d por_hold vrest 0 nch W=2e-06 L=1e-06
nthc12r_op_tsw thc12r_op_tt thc12r_qb vdd vsrc pch W=2e-06 L=1e-06
rthc12r_op_trc thc12r_op_tt thc12r_op_at 10000
cthc12r_op_tc thc12r_op_at 0 1e-07
rthc12r_op_trl thc12r_op_at 0 2.2e+07
nthc12r_op_sh1p thc12r_op_an thc12r_op_at vdd vsrc pch W=2.4e-06 L=5e-07
nthc12r_op_sh1n thc12r_op_an thc12r_op_at 0 0 nch W=1.2e-06 L=5e-07
nthc12r_op_sh2p thc12r_op_aq thc12r_op_an vdd vsrc pch W=2.4e-06 L=5e-07
nthc12r_op_sh2n thc12r_op_aq thc12r_op_an 0 0 nch W=1.2e-06 L=5e-07
nthc12r_op_abp thc12r_op_aqb thc12r_op_aq vdd vsrc pch W=2.4e-06 L=5e-07
nthc12r_op_abn thc12r_op_aqb thc12r_op_aq 0 0 nch W=1.2e-06 L=5e-07
rthc12r_op_dr thc12r_op_aq thc12r_op_ad 1e+06
cthc12r_op_dc thc12r_op_ad 0 3.3e-07
nthc12r_op_d2p thc12r_op_adn thc12r_op_ad vdd vsrc pch W=2.4e-06 L=5e-07
nthc12r_op_d2n thc12r_op_adn thc12r_op_ad 0 0 nch W=1.2e-06 L=5e-07
nthc12r_op_gpa thc12r_op_pb thc12r_op_aq vdd vsrc pch W=2.4e-06 L=5e-07
nthc12r_op_gpb thc12r_op_pb thc12r_op_adn vdd vsrc pch W=2.4e-06 L=5e-07
nthc12r_op_gna thc12r_op_pb thc12r_op_aq thc12r_op_gx 0 nch W=2.4e-06 L=5e-07
nthc12r_op_gnb thc12r_op_gx thc12r_op_adn 0 0 nch W=2.4e-06 L=5e-07
nthc12r_op_op thc12r_op_p thc12r_op_pb vdd vsrc pch W=2.4e-06 L=5e-07
nthc12r_op_on thc12r_op_p thc12r_op_pb 0 0 nch W=1.2e-06 L=5e-07
nthc12r_rm_md thc12r_mi thc12r_mi vdd vsrc pch W=4e-06 L=2e-06
va_nthc12r_rm_mo_d thc12r_vm nthc12r_rm_mo_d 0
nthc12r_rm_mo nthc12r_rm_mo_d thc12r_mi vdd vsrc pch W=1e-06 L=8e-06
cspcc1 spc1 0 1e-07
rspcl1 spc1 vmid 1e+06
nspci1_sw spci1_x gc1_op_aqb vdd vsrc pch W=4e-06 L=1e-06
nspci1_cp spc1 irefp_n spci1_x vsrc pch W=2e-06 L=4e-06
cspcc2 spc2 0 1e-07
rspcl2 spc2 vmid 1e+06
nspci2_sw spci2_x gc2_op_aqb vdd vsrc pch W=4e-06 L=1e-06
nspci2_cp spc2 irefp_n spci2_x vsrc pch W=2e-06 L=4e-06
cspcc3 spc3 0 1e-07
rspcl3 spc3 vmid 1e+06
nspci3_sw spci3_x vdd vdd vsrc pch W=4e-06 L=1e-06
nspci3_cp spc3 irefp_n spci3_x vsrc pch W=2e-06 L=4e-06
cspcc4 spc4 0 1e-07
rspcl4 spc4 vmid 1e+06
nspci4_sw spci4_x vdd vdd vsrc pch W=4e-06 L=1e-06
nspci4_cp spc4 irefp_n spci4_x vsrc pch W=2e-06 L=4e-06
rspcrs12 spc1 spcs12 200000
cspccs12 spcs12 0 1e-12
rspcrt12 spcs12 spc2 800000
rspcrs23 spc2 spcs23 200000
cspccs23 spcs23 0 1e-12
rspcrt23 spcs23 spc3 800000
rspcrs34 spc3 spcs34 200000
cspccs34 spcs34 0 1e-12
rspcrt34 spcs34 spc4 800000
va_csgc12f_cm_p sgc12f_vm csgc12f_cm_p 0
csgc12f_cm csgc12f_cm_p 0 1e-07
va_rsgc12f_rm_p sgc12f_vm rsgc12f_rm_p 0
rsgc12f_rm rsgc12f_rm_p vrest 1e+06
rsgc12f_kb vdd sgc12f_knb 1e+06
nsgc12f_kmb sgc12f_knb sgc12f_knb 0 0 nch W=4e-06 L=4e-06
nsgc12f_kmt sgc12f_ktail sgc12f_knb 0 0 nch W=4e-06 L=4e-06
va_nsgc12f_km1_g sgc12f_vm nsgc12f_km1_g 0
nsgc12f_km1 sgc12f_kd1 nsgc12f_km1_g sgc12f_ktail 0 nch W=4e-06 L=4e-06
nsgc12f_km2 sgc12f_ko1 sgc12f_h sgc12f_ktail 0 nch W=4e-06 L=4e-06
nsgc12f_km3 sgc12f_kd1 sgc12f_kd1 vdd vsrc pch W=4e-06 L=4e-06
nsgc12f_km4 sgc12f_ko1 sgc12f_kd1 vdd vsrc pch W=4e-06 L=4e-06
nsgc12f_ki1p sgc12f_qb sgc12f_ko1 vdd vsrc pch W=2.4e-06 L=5e-07
nsgc12f_ki1n sgc12f_qb sgc12f_ko1 0 0 nch W=1.2e-06 L=5e-07
nsgc12f_ki2p sgc12f_q sgc12f_qb vdd vsrc pch W=2.4e-06 L=5e-07
nsgc12f_ki2n sgc12f_q sgc12f_qb 0 0 nch W=1.2e-06 L=5e-07
rsgc12f_hra sgc12f_h vthr 1e+06
rsgc12f_hrf sgc12f_h sgc12f_qb 1.9e+07
csgc12f_hc sgc12f_h 0 2.1e-09
va_nsgc12f_dis_d sgc12f_vm nsgc12f_dis_d 0
va_nsgc12f_dis_s sgc12f_vmd nsgc12f_dis_s 0
nsgc12f_dis nsgc12f_dis_d sgc12f_q nsgc12f_dis_s 0 nch W=4e-06 L=1e-06
va_rsgc12f_rdis_p sgc12f_vmd rsgc12f_rdis_p 0
rsgc12f_rdis rsgc12f_rdis_p vrest 75000
nsgc12f_rp sgc12f_rt sgc12f_qb vdd vsrc pch W=2e-06 L=1e-06
rsgc12f_rrc sgc12f_rt sgc12f_rec 10000
csgc12f_rc sgc12f_rec 0 1e-07
rsgc12f_rr sgc12f_rec 0 8.2e+06
va_nsgc12f_sh1_d sgc12f_vm nsgc12f_sh1_d 0
va_nsgc12f_sh1_s sgc12f_vms nsgc12f_sh1_s 0
nsgc12f_sh1 nsgc12f_sh1_d sgc12f_rec nsgc12f_sh1_s 0 nch W=2e-06 L=1e-06
va_nsgc12f_sh2_d sgc12f_vms nsgc12f_sh2_d 0
nsgc12f_sh2 nsgc12f_sh2_d sgc12f_qb vrest 0 nch W=2e-06 L=1e-06
nsgc12f_porh sgc12f_h por_hold vthr 0 nch W=2e-06 L=1e-06
va_nsgc12f_porm_d sgc12f_vm nsgc12f_porm_d 0
nsgc12f_porm nsgc12f_porm_d por_hold vrest 0 nch W=2e-06 L=1e-06
nsgc12f_op_tsw sgc12f_op_tt sgc12f_qb vdd vsrc pch W=2e-06 L=1e-06
rsgc12f_op_trc sgc12f_op_tt sgc12f_op_at 10000
csgc12f_op_tc sgc12f_op_at 0 1e-07
rsgc12f_op_trl sgc12f_op_at 0 2.2e+07
nsgc12f_op_sh1p sgc12f_op_an sgc12f_op_at vdd vsrc pch W=2.4e-06 L=5e-07
nsgc12f_op_sh1n sgc12f_op_an sgc12f_op_at 0 0 nch W=1.2e-06 L=5e-07
nsgc12f_op_sh2p sgc12f_op_aq sgc12f_op_an vdd vsrc pch W=2.4e-06 L=5e-07
nsgc12f_op_sh2n sgc12f_op_aq sgc12f_op_an 0 0 nch W=1.2e-06 L=5e-07
nsgc12f_op_abp sgc12f_op_aqb sgc12f_op_aq vdd vsrc pch W=2.4e-06 L=5e-07
nsgc12f_op_abn sgc12f_op_aqb sgc12f_op_aq 0 0 nch W=1.2e-06 L=5e-07
rsgc12f_op_dr sgc12f_op_aq sgc12f_op_ad 1e+06
csgc12f_op_dc sgc12f_op_ad 0 3.3e-07
nsgc12f_op_d2p sgc12f_op_adn sgc12f_op_ad vdd vsrc pch W=2.4e-06 L=5e-07
nsgc12f_op_d2n sgc12f_op_adn sgc12f_op_ad 0 0 nch W=1.2e-06 L=5e-07
nsgc12f_op_gpa sgc12f_op_pb sgc12f_op_aq vdd vsrc pch W=2.4e-06 L=5e-07
nsgc12f_op_gpb sgc12f_op_pb sgc12f_op_adn vdd vsrc pch W=2.4e-06 L=5e-07
nsgc12f_op_gna sgc12f_op_pb sgc12f_op_aq sgc12f_op_gx 0 nch W=2.4e-06 L=5e-07
nsgc12f_op_gnb sgc12f_op_gx sgc12f_op_adn 0 0 nch W=2.4e-06 L=5e-07
nsgc12f_op_op sgc12f_op_p sgc12f_op_pb vdd vsrc pch W=2.4e-06 L=5e-07
nsgc12f_op_on sgc12f_op_p sgc12f_op_pb 0 0 nch W=1.2e-06 L=5e-07
rsgc12f_ota_b vdd sgc12f_ota_nb 3.3e+06
nsgc12f_ota_mb sgc12f_ota_nb sgc12f_ota_nb 0 0 nch W=4e-06 L=4e-06
nsgc12f_ota_mt sgc12f_ota_tail sgc12f_ota_nb 0 0 nch W=4e-06 L=4e-06
nsgc12f_ota_m1 sgc12f_ota_d1 spc1 sgc12f_ota_tail 0 nch W=1e-05 L=2e-06
va_nsgc12f_ota_m2_d sgc12f_vm nsgc12f_ota_m2_d 0
nsgc12f_ota_m2 nsgc12f_ota_m2_d spcs12 sgc12f_ota_tail 0 nch W=1e-05 L=2e-06
nsgc12f_ota_m3 sgc12f_ota_d1 sgc12f_ota_d1 vdd vsrc pch W=1e-05 L=2e-06
va_nsgc12f_ota_m4_d sgc12f_vm nsgc12f_ota_m4_d 0
nsgc12f_ota_m4 nsgc12f_ota_m4_d sgc12f_ota_d1 vdd vsrc pch W=1e-05 L=2e-06
va_csgc12r_cm_p sgc12r_vm csgc12r_cm_p 0
csgc12r_cm csgc12r_cm_p 0 1e-07
va_rsgc12r_rm_p sgc12r_vm rsgc12r_rm_p 0
rsgc12r_rm rsgc12r_rm_p vrest 1e+06
rsgc12r_kb vdd sgc12r_knb 1e+06
nsgc12r_kmb sgc12r_knb sgc12r_knb 0 0 nch W=4e-06 L=4e-06
nsgc12r_kmt sgc12r_ktail sgc12r_knb 0 0 nch W=4e-06 L=4e-06
va_nsgc12r_km1_g sgc12r_vm nsgc12r_km1_g 0
nsgc12r_km1 sgc12r_kd1 nsgc12r_km1_g sgc12r_ktail 0 nch W=4e-06 L=4e-06
nsgc12r_km2 sgc12r_ko1 sgc12r_h sgc12r_ktail 0 nch W=4e-06 L=4e-06
nsgc12r_km3 sgc12r_kd1 sgc12r_kd1 vdd vsrc pch W=4e-06 L=4e-06
nsgc12r_km4 sgc12r_ko1 sgc12r_kd1 vdd vsrc pch W=4e-06 L=4e-06
nsgc12r_ki1p sgc12r_qb sgc12r_ko1 vdd vsrc pch W=2.4e-06 L=5e-07
nsgc12r_ki1n sgc12r_qb sgc12r_ko1 0 0 nch W=1.2e-06 L=5e-07
nsgc12r_ki2p sgc12r_q sgc12r_qb vdd vsrc pch W=2.4e-06 L=5e-07
nsgc12r_ki2n sgc12r_q sgc12r_qb 0 0 nch W=1.2e-06 L=5e-07
rsgc12r_hra sgc12r_h vthr 1e+06
rsgc12r_hrf sgc12r_h sgc12r_qb 1.9e+07
csgc12r_hc sgc12r_h 0 2.1e-09
va_nsgc12r_dis_d sgc12r_vm nsgc12r_dis_d 0
va_nsgc12r_dis_s sgc12r_vmd nsgc12r_dis_s 0
nsgc12r_dis nsgc12r_dis_d sgc12r_q nsgc12r_dis_s 0 nch W=4e-06 L=1e-06
va_rsgc12r_rdis_p sgc12r_vmd rsgc12r_rdis_p 0
rsgc12r_rdis rsgc12r_rdis_p vrest 75000
nsgc12r_rp sgc12r_rt sgc12r_qb vdd vsrc pch W=2e-06 L=1e-06
rsgc12r_rrc sgc12r_rt sgc12r_rec 10000
csgc12r_rc sgc12r_rec 0 1e-07
rsgc12r_rr sgc12r_rec 0 8.2e+06
va_nsgc12r_sh1_d sgc12r_vm nsgc12r_sh1_d 0
va_nsgc12r_sh1_s sgc12r_vms nsgc12r_sh1_s 0
nsgc12r_sh1 nsgc12r_sh1_d sgc12r_rec nsgc12r_sh1_s 0 nch W=2e-06 L=1e-06
va_nsgc12r_sh2_d sgc12r_vms nsgc12r_sh2_d 0
nsgc12r_sh2 nsgc12r_sh2_d sgc12r_qb vrest 0 nch W=2e-06 L=1e-06
nsgc12r_porh sgc12r_h por_hold vthr 0 nch W=2e-06 L=1e-06
va_nsgc12r_porm_d sgc12r_vm nsgc12r_porm_d 0
nsgc12r_porm nsgc12r_porm_d por_hold vrest 0 nch W=2e-06 L=1e-06
nsgc12r_op_tsw sgc12r_op_tt sgc12r_qb vdd vsrc pch W=2e-06 L=1e-06
rsgc12r_op_trc sgc12r_op_tt sgc12r_op_at 10000
csgc12r_op_tc sgc12r_op_at 0 1e-07
rsgc12r_op_trl sgc12r_op_at 0 2.2e+07
nsgc12r_op_sh1p sgc12r_op_an sgc12r_op_at vdd vsrc pch W=2.4e-06 L=5e-07
nsgc12r_op_sh1n sgc12r_op_an sgc12r_op_at 0 0 nch W=1.2e-06 L=5e-07
nsgc12r_op_sh2p sgc12r_op_aq sgc12r_op_an vdd vsrc pch W=2.4e-06 L=5e-07
nsgc12r_op_sh2n sgc12r_op_aq sgc12r_op_an 0 0 nch W=1.2e-06 L=5e-07
nsgc12r_op_abp sgc12r_op_aqb sgc12r_op_aq vdd vsrc pch W=2.4e-06 L=5e-07
nsgc12r_op_abn sgc12r_op_aqb sgc12r_op_aq 0 0 nch W=1.2e-06 L=5e-07
rsgc12r_op_dr sgc12r_op_aq sgc12r_op_ad 1e+06
csgc12r_op_dc sgc12r_op_ad 0 3.3e-07
nsgc12r_op_d2p sgc12r_op_adn sgc12r_op_ad vdd vsrc pch W=2.4e-06 L=5e-07
nsgc12r_op_d2n sgc12r_op_adn sgc12r_op_ad 0 0 nch W=1.2e-06 L=5e-07
nsgc12r_op_gpa sgc12r_op_pb sgc12r_op_aq vdd vsrc pch W=2.4e-06 L=5e-07
nsgc12r_op_gpb sgc12r_op_pb sgc12r_op_adn vdd vsrc pch W=2.4e-06 L=5e-07
nsgc12r_op_gna sgc12r_op_pb sgc12r_op_aq sgc12r_op_gx 0 nch W=2.4e-06 L=5e-07
nsgc12r_op_gnb sgc12r_op_gx sgc12r_op_adn 0 0 nch W=2.4e-06 L=5e-07
nsgc12r_op_op sgc12r_op_p sgc12r_op_pb vdd vsrc pch W=2.4e-06 L=5e-07
nsgc12r_op_on sgc12r_op_p sgc12r_op_pb 0 0 nch W=1.2e-06 L=5e-07
rsgc12r_ota_b vdd sgc12r_ota_nb 3.3e+06
nsgc12r_ota_mb sgc12r_ota_nb sgc12r_ota_nb 0 0 nch W=4e-06 L=4e-06
nsgc12r_ota_mt sgc12r_ota_tail sgc12r_ota_nb 0 0 nch W=4e-06 L=4e-06
nsgc12r_ota_m1 sgc12r_ota_d1 spcs12 sgc12r_ota_tail 0 nch W=1e-05 L=2e-06
va_nsgc12r_ota_m2_d sgc12r_vm nsgc12r_ota_m2_d 0
nsgc12r_ota_m2 nsgc12r_ota_m2_d spc1 sgc12r_ota_tail 0 nch W=1e-05 L=2e-06
nsgc12r_ota_m3 sgc12r_ota_d1 sgc12r_ota_d1 vdd vsrc pch W=1e-05 L=2e-06
va_nsgc12r_ota_m4_d sgc12r_vm nsgc12r_ota_m4_d 0
nsgc12r_ota_m4 nsgc12r_ota_m4_d sgc12r_ota_d1 vdd vsrc pch W=1e-05 L=2e-06
ncdc12f_hsf_sw cdc12f_hsf_sd sgc12f_op_aqb vdd vsrc pch W=4e-06 L=5e-07
rcdc12f_hsf_rr cdc12f_hsf_sd cdc12f_hsf_h1 100000
ccdc12f_hsf_c1 cdc12f_hsf_h1 0 1e-06
rcdc12f_hsf_r2 cdc12f_hsf_h1 cdc12f_hs 1e+06
ccdc12f_hsf_c2 cdc12f_hs 0 4.7e-07
rcdc12f_hsf_rl cdc12f_hs 0 4.7e+06
ncdc12f_hcf_sw cdc12f_hcf_sd sgc12r_op_aqb vdd vsrc pch W=4e-06 L=5e-07
rcdc12f_hcf_rr cdc12f_hcf_sd cdc12f_hcf_h1 100000
ccdc12f_hcf_c1 cdc12f_hcf_h1 0 1e-06
rcdc12f_hcf_r2 cdc12f_hcf_h1 cdc12f_hc 1e+06
ccdc12f_hcf_c2 cdc12f_hc 0 4.7e-07
rcdc12f_hcf_rl cdc12f_hc 0 4.7e+06
va_ccdc12f_cm_p cdc12f_vm ccdc12f_cm_p 0
ccdc12f_cm ccdc12f_cm_p 0 1.5e-06
va_rcdc12f_rm_p cdc12f_vm rcdc12f_rm_p 0
rcdc12f_rm rcdc12f_rm_p vrest 1e+06
rcdc12f_kb vdd cdc12f_knb 1e+06
ncdc12f_kmb cdc12f_knb cdc12f_knb 0 0 nch W=4e-06 L=4e-06
ncdc12f_kmt cdc12f_ktail cdc12f_knb 0 0 nch W=4e-06 L=4e-06
va_ncdc12f_km1_g cdc12f_vm ncdc12f_km1_g 0
ncdc12f_km1 cdc12f_kd1 ncdc12f_km1_g cdc12f_ktail 0 nch W=4e-06 L=4e-06
ncdc12f_km2 cdc12f_ko1 cdc12f_h cdc12f_ktail 0 nch W=4e-06 L=4e-06
ncdc12f_km3 cdc12f_kd1 cdc12f_kd1 vdd vsrc pch W=4e-06 L=4e-06
ncdc12f_km4 cdc12f_ko1 cdc12f_kd1 vdd vsrc pch W=4e-06 L=4e-06
ncdc12f_ki1p cdc12f_qb cdc12f_ko1 vdd vsrc pch W=2.4e-06 L=5e-07
ncdc12f_ki1n cdc12f_qb cdc12f_ko1 0 0 nch W=1.2e-06 L=5e-07
ncdc12f_ki2p cdc12f_q cdc12f_qb vdd vsrc pch W=2.4e-06 L=5e-07
ncdc12f_ki2n cdc12f_q cdc12f_qb 0 0 nch W=1.2e-06 L=5e-07
rcdc12f_hra cdc12f_h vthr 1e+06
rcdc12f_hrf cdc12f_h cdc12f_qb 1.9e+07
ccdc12f_hc cdc12f_h 0 2.1e-09
va_ncdc12f_dis_d cdc12f_vm ncdc12f_dis_d 0
va_ncdc12f_dis_s cdc12f_vmd ncdc12f_dis_s 0
ncdc12f_dis ncdc12f_dis_d cdc12f_q ncdc12f_dis_s 0 nch W=4e-06 L=1e-06
va_rcdc12f_rdis_p cdc12f_vmd rcdc12f_rdis_p 0
rcdc12f_rdis rcdc12f_rdis_p vrest 12000
ncdc12f_rp cdc12f_rt cdc12f_qb vdd vsrc pch W=2e-06 L=1e-06
rcdc12f_rrc cdc12f_rt cdc12f_rec 10000
ccdc12f_rc cdc12f_rec 0 1e-07
rcdc12f_rr cdc12f_rec 0 8.2e+06
va_ncdc12f_sh1_d cdc12f_vm ncdc12f_sh1_d 0
va_ncdc12f_sh1_s cdc12f_vms ncdc12f_sh1_s 0
ncdc12f_sh1 ncdc12f_sh1_d cdc12f_rec ncdc12f_sh1_s 0 nch W=2e-06 L=1e-06
va_ncdc12f_sh2_d cdc12f_vms ncdc12f_sh2_d 0
ncdc12f_sh2 ncdc12f_sh2_d cdc12f_qb vrest 0 nch W=2e-06 L=1e-06
ncdc12f_porh cdc12f_h por_hold vthr 0 nch W=2e-06 L=1e-06
va_ncdc12f_porm_d cdc12f_vm ncdc12f_porm_d 0
ncdc12f_porm ncdc12f_porm_d por_hold vrest 0 nch W=2e-06 L=1e-06
ncdc12f_op_tsw cdc12f_op_tt cdc12f_qb vdd vsrc pch W=2e-06 L=1e-06
rcdc12f_op_trc cdc12f_op_tt cdc12f_op_at 10000
ccdc12f_op_tc cdc12f_op_at 0 1e-07
rcdc12f_op_trl cdc12f_op_at 0 2.2e+07
ncdc12f_op_sh1p cdc12f_op_an cdc12f_op_at vdd vsrc pch W=2.4e-06 L=5e-07
ncdc12f_op_sh1n cdc12f_op_an cdc12f_op_at 0 0 nch W=1.2e-06 L=5e-07
ncdc12f_op_sh2p cdc12f_op_aq cdc12f_op_an vdd vsrc pch W=2.4e-06 L=5e-07
ncdc12f_op_sh2n cdc12f_op_aq cdc12f_op_an 0 0 nch W=1.2e-06 L=5e-07
ncdc12f_op_abp cdc12f_op_aqb cdc12f_op_aq vdd vsrc pch W=2.4e-06 L=5e-07
ncdc12f_op_abn cdc12f_op_aqb cdc12f_op_aq 0 0 nch W=1.2e-06 L=5e-07
rcdc12f_op_dr cdc12f_op_aq cdc12f_op_ad 1e+06
ccdc12f_op_dc cdc12f_op_ad 0 3.3e-07
ncdc12f_op_d2p cdc12f_op_adn cdc12f_op_ad vdd vsrc pch W=2.4e-06 L=5e-07
ncdc12f_op_d2n cdc12f_op_adn cdc12f_op_ad 0 0 nch W=1.2e-06 L=5e-07
ncdc12f_op_gpa cdc12f_op_pb cdc12f_op_aq vdd vsrc pch W=2.4e-06 L=5e-07
ncdc12f_op_gpb cdc12f_op_pb cdc12f_op_adn vdd vsrc pch W=2.4e-06 L=5e-07
ncdc12f_op_gna cdc12f_op_pb cdc12f_op_aq cdc12f_op_gx 0 nch W=2.4e-06 L=5e-07
ncdc12f_op_gnb cdc12f_op_gx cdc12f_op_adn 0 0 nch W=2.4e-06 L=5e-07
ncdc12f_op_op cdc12f_op_p cdc12f_op_pb vdd vsrc pch W=2.4e-06 L=5e-07
ncdc12f_op_on cdc12f_op_p cdc12f_op_pb 0 0 nch W=1.2e-06 L=5e-07
ncdc12f_st_mh cdc12f_mi cdc12f_hs cdc12f_st_x 0 nch W=2e-06 L=4e-06
ncdc12f_st_mp cdc12f_st_x thc12f_op_aq 0 0 nch W=4e-06 L=1e-06
ncdc12f_rm_md cdc12f_mi cdc12f_mi vdd vsrc pch W=4e-06 L=2e-06
va_ncdc12f_rm_mo_d cdc12f_vm ncdc12f_rm_mo_d 0
ncdc12f_rm_mo ncdc12f_rm_mo_d cdc12f_mi vdd vsrc pch W=1e-06 L=8e-06
va_ncdc12f_kh_d cdc12f_vm ncdc12f_kh_d 0
ncdc12f_kh ncdc12f_kh_d cdc12f_hc cdc12f_kx 0 nch W=2e-06 L=4e-06
ncdc12f_kp cdc12f_kx thc12f_op_aq vrest 0 nch W=4e-06 L=1e-06
ncdc12r_hsf_sw cdc12r_hsf_sd sgc12r_op_aqb vdd vsrc pch W=4e-06 L=5e-07
rcdc12r_hsf_rr cdc12r_hsf_sd cdc12r_hsf_h1 100000
ccdc12r_hsf_c1 cdc12r_hsf_h1 0 1e-06
rcdc12r_hsf_r2 cdc12r_hsf_h1 cdc12r_hs 1e+06
ccdc12r_hsf_c2 cdc12r_hs 0 4.7e-07
rcdc12r_hsf_rl cdc12r_hs 0 4.7e+06
ncdc12r_hcf_sw cdc12r_hcf_sd sgc12f_op_aqb vdd vsrc pch W=4e-06 L=5e-07
rcdc12r_hcf_rr cdc12r_hcf_sd cdc12r_hcf_h1 100000
ccdc12r_hcf_c1 cdc12r_hcf_h1 0 1e-06
rcdc12r_hcf_r2 cdc12r_hcf_h1 cdc12r_hc 1e+06
ccdc12r_hcf_c2 cdc12r_hc 0 4.7e-07
rcdc12r_hcf_rl cdc12r_hc 0 4.7e+06
va_ccdc12r_cm_p cdc12r_vm ccdc12r_cm_p 0
ccdc12r_cm ccdc12r_cm_p 0 1.5e-06
va_rcdc12r_rm_p cdc12r_vm rcdc12r_rm_p 0
rcdc12r_rm rcdc12r_rm_p vrest 1e+06
rcdc12r_kb vdd cdc12r_knb 1e+06
ncdc12r_kmb cdc12r_knb cdc12r_knb 0 0 nch W=4e-06 L=4e-06
ncdc12r_kmt cdc12r_ktail cdc12r_knb 0 0 nch W=4e-06 L=4e-06
va_ncdc12r_km1_g cdc12r_vm ncdc12r_km1_g 0
ncdc12r_km1 cdc12r_kd1 ncdc12r_km1_g cdc12r_ktail 0 nch W=4e-06 L=4e-06
ncdc12r_km2 cdc12r_ko1 cdc12r_h cdc12r_ktail 0 nch W=4e-06 L=4e-06
ncdc12r_km3 cdc12r_kd1 cdc12r_kd1 vdd vsrc pch W=4e-06 L=4e-06
ncdc12r_km4 cdc12r_ko1 cdc12r_kd1 vdd vsrc pch W=4e-06 L=4e-06
ncdc12r_ki1p cdc12r_qb cdc12r_ko1 vdd vsrc pch W=2.4e-06 L=5e-07
ncdc12r_ki1n cdc12r_qb cdc12r_ko1 0 0 nch W=1.2e-06 L=5e-07
ncdc12r_ki2p cdc12r_q cdc12r_qb vdd vsrc pch W=2.4e-06 L=5e-07
ncdc12r_ki2n cdc12r_q cdc12r_qb 0 0 nch W=1.2e-06 L=5e-07
rcdc12r_hra cdc12r_h vthr 1e+06
rcdc12r_hrf cdc12r_h cdc12r_qb 1.9e+07
ccdc12r_hc cdc12r_h 0 2.1e-09
va_ncdc12r_dis_d cdc12r_vm ncdc12r_dis_d 0
va_ncdc12r_dis_s cdc12r_vmd ncdc12r_dis_s 0
ncdc12r_dis ncdc12r_dis_d cdc12r_q ncdc12r_dis_s 0 nch W=4e-06 L=1e-06
va_rcdc12r_rdis_p cdc12r_vmd rcdc12r_rdis_p 0
rcdc12r_rdis rcdc12r_rdis_p vrest 12000
ncdc12r_rp cdc12r_rt cdc12r_qb vdd vsrc pch W=2e-06 L=1e-06
rcdc12r_rrc cdc12r_rt cdc12r_rec 10000
ccdc12r_rc cdc12r_rec 0 1e-07
rcdc12r_rr cdc12r_rec 0 8.2e+06
va_ncdc12r_sh1_d cdc12r_vm ncdc12r_sh1_d 0
va_ncdc12r_sh1_s cdc12r_vms ncdc12r_sh1_s 0
ncdc12r_sh1 ncdc12r_sh1_d cdc12r_rec ncdc12r_sh1_s 0 nch W=2e-06 L=1e-06
va_ncdc12r_sh2_d cdc12r_vms ncdc12r_sh2_d 0
ncdc12r_sh2 ncdc12r_sh2_d cdc12r_qb vrest 0 nch W=2e-06 L=1e-06
ncdc12r_porh cdc12r_h por_hold vthr 0 nch W=2e-06 L=1e-06
va_ncdc12r_porm_d cdc12r_vm ncdc12r_porm_d 0
ncdc12r_porm ncdc12r_porm_d por_hold vrest 0 nch W=2e-06 L=1e-06
ncdc12r_op_tsw cdc12r_op_tt cdc12r_qb vdd vsrc pch W=2e-06 L=1e-06
rcdc12r_op_trc cdc12r_op_tt cdc12r_op_at 10000
ccdc12r_op_tc cdc12r_op_at 0 1e-07
rcdc12r_op_trl cdc12r_op_at 0 2.2e+07
ncdc12r_op_sh1p cdc12r_op_an cdc12r_op_at vdd vsrc pch W=2.4e-06 L=5e-07
ncdc12r_op_sh1n cdc12r_op_an cdc12r_op_at 0 0 nch W=1.2e-06 L=5e-07
ncdc12r_op_sh2p cdc12r_op_aq cdc12r_op_an vdd vsrc pch W=2.4e-06 L=5e-07
ncdc12r_op_sh2n cdc12r_op_aq cdc12r_op_an 0 0 nch W=1.2e-06 L=5e-07
ncdc12r_op_abp cdc12r_op_aqb cdc12r_op_aq vdd vsrc pch W=2.4e-06 L=5e-07
ncdc12r_op_abn cdc12r_op_aqb cdc12r_op_aq 0 0 nch W=1.2e-06 L=5e-07
rcdc12r_op_dr cdc12r_op_aq cdc12r_op_ad 1e+06
ccdc12r_op_dc cdc12r_op_ad 0 3.3e-07
ncdc12r_op_d2p cdc12r_op_adn cdc12r_op_ad vdd vsrc pch W=2.4e-06 L=5e-07
ncdc12r_op_d2n cdc12r_op_adn cdc12r_op_ad 0 0 nch W=1.2e-06 L=5e-07
ncdc12r_op_gpa cdc12r_op_pb cdc12r_op_aq vdd vsrc pch W=2.4e-06 L=5e-07
ncdc12r_op_gpb cdc12r_op_pb cdc12r_op_adn vdd vsrc pch W=2.4e-06 L=5e-07
ncdc12r_op_gna cdc12r_op_pb cdc12r_op_aq cdc12r_op_gx 0 nch W=2.4e-06 L=5e-07
ncdc12r_op_gnb cdc12r_op_gx cdc12r_op_adn 0 0 nch W=2.4e-06 L=5e-07
ncdc12r_op_op cdc12r_op_p cdc12r_op_pb vdd vsrc pch W=2.4e-06 L=5e-07
ncdc12r_op_on cdc12r_op_p cdc12r_op_pb 0 0 nch W=1.2e-06 L=5e-07
ncdc12r_st_mh cdc12r_mi cdc12r_hs cdc12r_st_x 0 nch W=2e-06 L=4e-06
ncdc12r_st_mp cdc12r_st_x thc12r_op_aq 0 0 nch W=4e-06 L=1e-06
ncdc12r_rm_md cdc12r_mi cdc12r_mi vdd vsrc pch W=4e-06 L=2e-06
va_ncdc12r_rm_mo_d cdc12r_vm ncdc12r_rm_mo_d 0
ncdc12r_rm_mo ncdc12r_rm_mo_d cdc12r_mi vdd vsrc pch W=1e-06 L=8e-06
va_ncdc12r_kh_d cdc12r_vm ncdc12r_kh_d 0
ncdc12r_kh ncdc12r_kh_d cdc12r_hc cdc12r_kx 0 nch W=2e-06 L=4e-06
ncdc12r_kp cdc12r_kx thc12r_op_aq vrest 0 nch W=4e-06 L=1e-06
va_cldpos_p load_pos cldpos_p 0
cldpos cldpos_p vmid 1e-06
va_rldpos_p load_pos rldpos_p 0
rldpos rldpos_p vmid 100000
nagc12f_sw agc12f_x cdc12f_op_aqb vdd vsrc pch W=4e-06 L=1e-06
va_nagc12f_cp_d load_pos nagc12f_cp_d 0
nagc12f_cp nagc12f_cp_d irefp_n agc12f_x vsrc pch W=4e-06 L=4e-06
va_cldneg_p load_neg cldneg_p 0
cldneg cldneg_p vmid 1e-06
va_rldneg_p load_neg rldneg_p 0
rldneg rldneg_p vmid 100000
nagc12r_sw agc12r_x cdc12r_op_aqb vdd vsrc pch W=4e-06 L=1e-06
va_nagc12r_cp_d load_neg nagc12r_cp_d 0
nagc12r_cp nagc12r_cp_d irefp_n agc12r_x vsrc pch W=4e-06 L=4e-06
cpar_agc12f_x agc12f_x 0 5e-14
cpar_agc12r_x agc12r_x 0 5e-14
cpar_cdc12f_h cdc12f_h 0 5e-14
cpar_cdc12f_hc cdc12f_hc 0 5e-14
cpar_cdc12f_hcf_h1 cdc12f_hcf_h1 0 5e-14
cpar_cdc12f_hcf_sd cdc12f_hcf_sd 0 5e-14
cpar_cdc12f_hs cdc12f_hs 0 5e-14
cpar_cdc12f_hsf_h1 cdc12f_hsf_h1 0 5e-14
cpar_cdc12f_hsf_sd cdc12f_hsf_sd 0 5e-14
cpar_cdc12f_kd1 cdc12f_kd1 0 5e-14
cpar_cdc12f_knb cdc12f_knb 0 5e-14
cpar_cdc12f_ko1 cdc12f_ko1 0 5e-14
cpar_cdc12f_ktail cdc12f_ktail 0 5e-14
cpar_cdc12f_kx cdc12f_kx 0 5e-14
cpar_cdc12f_mi cdc12f_mi 0 5e-14
cpar_cdc12f_op_ad cdc12f_op_ad 0 5e-14
cpar_cdc12f_op_adn cdc12f_op_adn 0 5e-14
cpar_cdc12f_op_an cdc12f_op_an 0 5e-14
cpar_cdc12f_op_aq cdc12f_op_aq 0 5e-14
cpar_cdc12f_op_aqb cdc12f_op_aqb 0 5e-14
cpar_cdc12f_op_at cdc12f_op_at 0 5e-14
cpar_cdc12f_op_gx cdc12f_op_gx 0 5e-14
cpar_cdc12f_op_p cdc12f_op_p 0 5e-14
cpar_cdc12f_op_pb cdc12f_op_pb 0 5e-14
cpar_cdc12f_op_tt cdc12f_op_tt 0 5e-14
cpar_cdc12f_q cdc12f_q 0 5e-14
cpar_cdc12f_qb cdc12f_qb 0 5e-14
cpar_cdc12f_rec cdc12f_rec 0 5e-14
cpar_cdc12f_rt cdc12f_rt 0 5e-14
cpar_cdc12f_st_x cdc12f_st_x 0 5e-14
va_cpar_cdc12f_vm_p cdc12f_vm cpar_cdc12f_vm_p 0
cpar_cdc12f_vm cpar_cdc12f_vm_p 0 5e-14
va_cpar_cdc12f_vmd_p cdc12f_vmd cpar_cdc12f_vmd_p 0
cpar_cdc12f_vmd cpar_cdc12f_vmd_p 0 5e-14
va_cpar_cdc12f_vms_p cdc12f_vms cpar_cdc12f_vms_p 0
cpar_cdc12f_vms cpar_cdc12f_vms_p 0 5e-14
cpar_cdc12r_h cdc12r_h 0 5e-14
cpar_cdc12r_hc cdc12r_hc 0 5e-14
cpar_cdc12r_hcf_h1 cdc12r_hcf_h1 0 5e-14
cpar_cdc12r_hcf_sd cdc12r_hcf_sd 0 5e-14
cpar_cdc12r_hs cdc12r_hs 0 5e-14
cpar_cdc12r_hsf_h1 cdc12r_hsf_h1 0 5e-14
cpar_cdc12r_hsf_sd cdc12r_hsf_sd 0 5e-14
cpar_cdc12r_kd1 cdc12r_kd1 0 5e-14
cpar_cdc12r_knb cdc12r_knb 0 5e-14
cpar_cdc12r_ko1 cdc12r_ko1 0 5e-14
cpar_cdc12r_ktail cdc12r_ktail 0 5e-14
cpar_cdc12r_kx cdc12r_kx 0 5e-14
cpar_cdc12r_mi cdc12r_mi 0 5e-14
cpar_cdc12r_op_ad cdc12r_op_ad 0 5e-14
cpar_cdc12r_op_adn cdc12r_op_adn 0 5e-14
cpar_cdc12r_op_an cdc12r_op_an 0 5e-14
cpar_cdc12r_op_aq cdc12r_op_aq 0 5e-14
cpar_cdc12r_op_aqb cdc12r_op_aqb 0 5e-14
cpar_cdc12r_op_at cdc12r_op_at 0 5e-14
cpar_cdc12r_op_gx cdc12r_op_gx 0 5e-14
cpar_cdc12r_op_p cdc12r_op_p 0 5e-14
cpar_cdc12r_op_pb cdc12r_op_pb 0 5e-14
cpar_cdc12r_op_tt cdc12r_op_tt 0 5e-14
cpar_cdc12r_q cdc12r_q 0 5e-14
cpar_cdc12r_qb cdc12r_qb 0 5e-14
cpar_cdc12r_rec cdc12r_rec 0 5e-14
cpar_cdc12r_rt cdc12r_rt 0 5e-14
cpar_cdc12r_st_x cdc12r_st_x 0 5e-14
va_cpar_cdc12r_vm_p cdc12r_vm cpar_cdc12r_vm_p 0
cpar_cdc12r_vm cpar_cdc12r_vm_p 0 5e-14
va_cpar_cdc12r_vmd_p cdc12r_vmd cpar_cdc12r_vmd_p 0
cpar_cdc12r_vmd cpar_cdc12r_vmd_p 0 5e-14
va_cpar_cdc12r_vms_p cdc12r_vms cpar_cdc12r_vms_p 0
cpar_cdc12r_vms cpar_cdc12r_vms_p 0 5e-14
cpar_gc1_and_a0_nb gc1_and_a0_nb 0 5e-14
cpar_gc1_and_a0_nx gc1_and_a0_nx 0 5e-14
cpar_gc1_and_a1_nb gc1_and_a1_nb 0 5e-14
cpar_gc1_and_a1_nx gc1_and_a1_nx 0 5e-14
cpar_gc1_and_a2_nb gc1_and_a2_nb 0 5e-14
cpar_gc1_and_a2_nx gc1_and_a2_nx 0 5e-14
cpar_gc1_and_a3_nb gc1_and_a3_nb 0 5e-14
cpar_gc1_and_a3_nx gc1_and_a3_nx 0 5e-14
cpar_gc1_and_a4_nb gc1_and_a4_nb 0 5e-14
cpar_gc1_and_a4_nx gc1_and_a4_nx 0 5e-14
cpar_gc1_and_a5_nb gc1_and_a5_nb 0 5e-14
cpar_gc1_and_a5_nx gc1_and_a5_nx 0 5e-14
cpar_gc1_and_a6_nb gc1_and_a6_nb 0 5e-14
cpar_gc1_and_a6_nx gc1_and_a6_nx 0 5e-14
cpar_gc1_and_a7_nb gc1_and_a7_nb 0 5e-14
cpar_gc1_and_a7_nx gc1_and_a7_nx 0 5e-14
cpar_gc1_and_a8_nb gc1_and_a8_nb 0 5e-14
cpar_gc1_and_a8_nx gc1_and_a8_nx 0 5e-14
cpar_gc1_and_g0 gc1_and_g0 0 5e-14
cpar_gc1_and_g1 gc1_and_g1 0 5e-14
cpar_gc1_and_g2 gc1_and_g2 0 5e-14
cpar_gc1_and_g3 gc1_and_g3 0 5e-14
cpar_gc1_and_g4 gc1_and_g4 0 5e-14
cpar_gc1_and_g5 gc1_and_g5 0 5e-14
cpar_gc1_and_g6 gc1_and_g6 0 5e-14
cpar_gc1_and_g7 gc1_and_g7 0 5e-14
cpar_gc1_and_g8 gc1_and_g8 0 5e-14
cpar_gc1_b1 gc1_b1 0 5e-14
cpar_gc1_b10 gc1_b10 0 5e-14
cpar_gc1_b10_n gc1_b10_n 0 5e-14
cpar_gc1_b10_q gc1_b10_q 0 5e-14
cpar_gc1_b10_t gc1_b10_t 0 5e-14
cpar_gc1_b1_n gc1_b1_n 0 5e-14
cpar_gc1_b1_q gc1_b1_q 0 5e-14
cpar_gc1_b1_t gc1_b1_t 0 5e-14
cpar_gc1_b2 gc1_b2 0 5e-14
cpar_gc1_b2_n gc1_b2_n 0 5e-14
cpar_gc1_b2_q gc1_b2_q 0 5e-14
cpar_gc1_b2_t gc1_b2_t 0 5e-14
cpar_gc1_b3 gc1_b3 0 5e-14
cpar_gc1_b3_n gc1_b3_n 0 5e-14
cpar_gc1_b3_q gc1_b3_q 0 5e-14
cpar_gc1_b3_t gc1_b3_t 0 5e-14
cpar_gc1_b4 gc1_b4 0 5e-14
cpar_gc1_b4_n gc1_b4_n 0 5e-14
cpar_gc1_b4_q gc1_b4_q 0 5e-14
cpar_gc1_b4_t gc1_b4_t 0 5e-14
cpar_gc1_b5 gc1_b5 0 5e-14
cpar_gc1_b5_n gc1_b5_n 0 5e-14
cpar_gc1_b5_q gc1_b5_q 0 5e-14
cpar_gc1_b5_t gc1_b5_t 0 5e-14
cpar_gc1_b6 gc1_b6 0 5e-14
cpar_gc1_b6_n gc1_b6_n 0 5e-14
cpar_gc1_b6_q gc1_b6_q 0 5e-14
cpar_gc1_b6_t gc1_b6_t 0 5e-14
cpar_gc1_b7 gc1_b7 0 5e-14
cpar_gc1_b7_n gc1_b7_n 0 5e-14
cpar_gc1_b7_q gc1_b7_q 0 5e-14
cpar_gc1_b7_t gc1_b7_t 0 5e-14
cpar_gc1_b8 gc1_b8 0 5e-14
cpar_gc1_b8_n gc1_b8_n 0 5e-14
cpar_gc1_b8_q gc1_b8_q 0 5e-14
cpar_gc1_b8_t gc1_b8_t 0 5e-14
cpar_gc1_b9 gc1_b9 0 5e-14
cpar_gc1_b9_n gc1_b9_n 0 5e-14
cpar_gc1_b9_q gc1_b9_q 0 5e-14
cpar_gc1_b9_t gc1_b9_t 0 5e-14
cpar_gc1_cin_x gc1_cin_x 0 5e-14
cpar_gc1_col_h gc1_col_h 0 5e-14
cpar_gc1_col_kd1 gc1_col_kd1 0 5e-14
cpar_gc1_col_knb gc1_col_knb 0 5e-14
cpar_gc1_col_ko1 gc1_col_ko1 0 5e-14
cpar_gc1_col_ktail gc1_col_ktail 0 5e-14
cpar_gc1_col_q gc1_col_q 0 5e-14
cpar_gc1_col_qb gc1_col_qb 0 5e-14
cpar_gc1_col_rec gc1_col_rec 0 5e-14
cpar_gc1_col_rt gc1_col_rt 0 5e-14
cpar_gc1_col_vm gc1_col_vm 0 5e-14
cpar_gc1_col_vmd gc1_col_vmd 0 5e-14
cpar_gc1_col_vms gc1_col_vms 0 5e-14
cpar_gc1_e10_h gc1_e10_h 0 5e-14
cpar_gc1_e10_kd1 gc1_e10_kd1 0 5e-14
cpar_gc1_e10_knb gc1_e10_knb 0 5e-14
cpar_gc1_e10_ko1 gc1_e10_ko1 0 5e-14
cpar_gc1_e10_ktail gc1_e10_ktail 0 5e-14
cpar_gc1_e10_q gc1_e10_q 0 5e-14
cpar_gc1_e10_qb gc1_e10_qb 0 5e-14
cpar_gc1_e10_rec gc1_e10_rec 0 5e-14
cpar_gc1_e10_rt gc1_e10_rt 0 5e-14
cpar_gc1_e10_vm gc1_e10_vm 0 5e-14
cpar_gc1_e10_vmd gc1_e10_vmd 0 5e-14
cpar_gc1_e10_vms gc1_e10_vms 0 5e-14
cpar_gc1_e1_h gc1_e1_h 0 5e-14
cpar_gc1_e1_kd1 gc1_e1_kd1 0 5e-14
cpar_gc1_e1_knb gc1_e1_knb 0 5e-14
cpar_gc1_e1_ko1 gc1_e1_ko1 0 5e-14
cpar_gc1_e1_ktail gc1_e1_ktail 0 5e-14
cpar_gc1_e1_q gc1_e1_q 0 5e-14
cpar_gc1_e1_qb gc1_e1_qb 0 5e-14
cpar_gc1_e1_rec gc1_e1_rec 0 5e-14
cpar_gc1_e1_rt gc1_e1_rt 0 5e-14
cpar_gc1_e1_vm gc1_e1_vm 0 5e-14
cpar_gc1_e1_vmd gc1_e1_vmd 0 5e-14
cpar_gc1_e1_vms gc1_e1_vms 0 5e-14
cpar_gc1_e2_h gc1_e2_h 0 5e-14
cpar_gc1_e2_kd1 gc1_e2_kd1 0 5e-14
cpar_gc1_e2_knb gc1_e2_knb 0 5e-14
cpar_gc1_e2_ko1 gc1_e2_ko1 0 5e-14
cpar_gc1_e2_ktail gc1_e2_ktail 0 5e-14
cpar_gc1_e2_q gc1_e2_q 0 5e-14
cpar_gc1_e2_qb gc1_e2_qb 0 5e-14
cpar_gc1_e2_rec gc1_e2_rec 0 5e-14
cpar_gc1_e2_rt gc1_e2_rt 0 5e-14
cpar_gc1_e2_vm gc1_e2_vm 0 5e-14
cpar_gc1_e2_vmd gc1_e2_vmd 0 5e-14
cpar_gc1_e2_vms gc1_e2_vms 0 5e-14
cpar_gc1_e3_h gc1_e3_h 0 5e-14
cpar_gc1_e3_kd1 gc1_e3_kd1 0 5e-14
cpar_gc1_e3_knb gc1_e3_knb 0 5e-14
cpar_gc1_e3_ko1 gc1_e3_ko1 0 5e-14
cpar_gc1_e3_ktail gc1_e3_ktail 0 5e-14
cpar_gc1_e3_q gc1_e3_q 0 5e-14
cpar_gc1_e3_qb gc1_e3_qb 0 5e-14
cpar_gc1_e3_rec gc1_e3_rec 0 5e-14
cpar_gc1_e3_rt gc1_e3_rt 0 5e-14
cpar_gc1_e3_vm gc1_e3_vm 0 5e-14
cpar_gc1_e3_vmd gc1_e3_vmd 0 5e-14
cpar_gc1_e3_vms gc1_e3_vms 0 5e-14
cpar_gc1_e4_h gc1_e4_h 0 5e-14
cpar_gc1_e4_kd1 gc1_e4_kd1 0 5e-14
cpar_gc1_e4_knb gc1_e4_knb 0 5e-14
cpar_gc1_e4_ko1 gc1_e4_ko1 0 5e-14
cpar_gc1_e4_ktail gc1_e4_ktail 0 5e-14
cpar_gc1_e4_q gc1_e4_q 0 5e-14
cpar_gc1_e4_qb gc1_e4_qb 0 5e-14
cpar_gc1_e4_rec gc1_e4_rec 0 5e-14
cpar_gc1_e4_rt gc1_e4_rt 0 5e-14
cpar_gc1_e4_vm gc1_e4_vm 0 5e-14
cpar_gc1_e4_vmd gc1_e4_vmd 0 5e-14
cpar_gc1_e4_vms gc1_e4_vms 0 5e-14
cpar_gc1_e5_h gc1_e5_h 0 5e-14
cpar_gc1_e5_kd1 gc1_e5_kd1 0 5e-14
cpar_gc1_e5_knb gc1_e5_knb 0 5e-14
cpar_gc1_e5_ko1 gc1_e5_ko1 0 5e-14
cpar_gc1_e5_ktail gc1_e5_ktail 0 5e-14
cpar_gc1_e5_q gc1_e5_q 0 5e-14
cpar_gc1_e5_qb gc1_e5_qb 0 5e-14
cpar_gc1_e5_rec gc1_e5_rec 0 5e-14
cpar_gc1_e5_rt gc1_e5_rt 0 5e-14
cpar_gc1_e5_vm gc1_e5_vm 0 5e-14
cpar_gc1_e5_vmd gc1_e5_vmd 0 5e-14
cpar_gc1_e5_vms gc1_e5_vms 0 5e-14
cpar_gc1_e6_h gc1_e6_h 0 5e-14
cpar_gc1_e6_kd1 gc1_e6_kd1 0 5e-14
cpar_gc1_e6_knb gc1_e6_knb 0 5e-14
cpar_gc1_e6_ko1 gc1_e6_ko1 0 5e-14
cpar_gc1_e6_ktail gc1_e6_ktail 0 5e-14
cpar_gc1_e6_q gc1_e6_q 0 5e-14
cpar_gc1_e6_qb gc1_e6_qb 0 5e-14
cpar_gc1_e6_rec gc1_e6_rec 0 5e-14
cpar_gc1_e6_rt gc1_e6_rt 0 5e-14
cpar_gc1_e6_vm gc1_e6_vm 0 5e-14
cpar_gc1_e6_vmd gc1_e6_vmd 0 5e-14
cpar_gc1_e6_vms gc1_e6_vms 0 5e-14
cpar_gc1_e7_h gc1_e7_h 0 5e-14
cpar_gc1_e7_kd1 gc1_e7_kd1 0 5e-14
cpar_gc1_e7_knb gc1_e7_knb 0 5e-14
cpar_gc1_e7_ko1 gc1_e7_ko1 0 5e-14
cpar_gc1_e7_ktail gc1_e7_ktail 0 5e-14
cpar_gc1_e7_q gc1_e7_q 0 5e-14
cpar_gc1_e7_qb gc1_e7_qb 0 5e-14
cpar_gc1_e7_rec gc1_e7_rec 0 5e-14
cpar_gc1_e7_rt gc1_e7_rt 0 5e-14
cpar_gc1_e7_vm gc1_e7_vm 0 5e-14
cpar_gc1_e7_vmd gc1_e7_vmd 0 5e-14
cpar_gc1_e7_vms gc1_e7_vms 0 5e-14
cpar_gc1_e8_h gc1_e8_h 0 5e-14
cpar_gc1_e8_kd1 gc1_e8_kd1 0 5e-14
cpar_gc1_e8_knb gc1_e8_knb 0 5e-14
cpar_gc1_e8_ko1 gc1_e8_ko1 0 5e-14
cpar_gc1_e8_ktail gc1_e8_ktail 0 5e-14
cpar_gc1_e8_q gc1_e8_q 0 5e-14
cpar_gc1_e8_qb gc1_e8_qb 0 5e-14
cpar_gc1_e8_rec gc1_e8_rec 0 5e-14
cpar_gc1_e8_rt gc1_e8_rt 0 5e-14
cpar_gc1_e8_vm gc1_e8_vm 0 5e-14
cpar_gc1_e8_vmd gc1_e8_vmd 0 5e-14
cpar_gc1_e8_vms gc1_e8_vms 0 5e-14
cpar_gc1_e9_h gc1_e9_h 0 5e-14
cpar_gc1_e9_kd1 gc1_e9_kd1 0 5e-14
cpar_gc1_e9_knb gc1_e9_knb 0 5e-14
cpar_gc1_e9_ko1 gc1_e9_ko1 0 5e-14
cpar_gc1_e9_ktail gc1_e9_ktail 0 5e-14
cpar_gc1_e9_q gc1_e9_q 0 5e-14
cpar_gc1_e9_qb gc1_e9_qb 0 5e-14
cpar_gc1_e9_rec gc1_e9_rec 0 5e-14
cpar_gc1_e9_rt gc1_e9_rt 0 5e-14
cpar_gc1_e9_vm gc1_e9_vm 0 5e-14
cpar_gc1_e9_vmd gc1_e9_vmd 0 5e-14
cpar_gc1_e9_vms gc1_e9_vms 0 5e-14
cpar_gc1_gb gc1_gb 0 5e-14
cpar_gc1_op_ad gc1_op_ad 0 5e-14
cpar_gc1_op_adn gc1_op_adn 0 5e-14
cpar_gc1_op_an gc1_op_an 0 5e-14
cpar_gc1_op_aq gc1_op_aq 0 5e-14
cpar_gc1_op_aqb gc1_op_aqb 0 5e-14
cpar_gc1_op_at gc1_op_at 0 5e-14
cpar_gc1_op_gx gc1_op_gx 0 5e-14
cpar_gc1_op_p gc1_op_p 0 5e-14
cpar_gc1_op_pb gc1_op_pb 0 5e-14
cpar_gc1_op_tt gc1_op_tt 0 5e-14
cpar_gc2_and_a0_nb gc2_and_a0_nb 0 5e-14
cpar_gc2_and_a0_nx gc2_and_a0_nx 0 5e-14
cpar_gc2_and_a1_nb gc2_and_a1_nb 0 5e-14
cpar_gc2_and_a1_nx gc2_and_a1_nx 0 5e-14
cpar_gc2_and_a2_nb gc2_and_a2_nb 0 5e-14
cpar_gc2_and_a2_nx gc2_and_a2_nx 0 5e-14
cpar_gc2_and_a3_nb gc2_and_a3_nb 0 5e-14
cpar_gc2_and_a3_nx gc2_and_a3_nx 0 5e-14
cpar_gc2_and_a4_nb gc2_and_a4_nb 0 5e-14
cpar_gc2_and_a4_nx gc2_and_a4_nx 0 5e-14
cpar_gc2_and_a5_nb gc2_and_a5_nb 0 5e-14
cpar_gc2_and_a5_nx gc2_and_a5_nx 0 5e-14
cpar_gc2_and_a6_nb gc2_and_a6_nb 0 5e-14
cpar_gc2_and_a6_nx gc2_and_a6_nx 0 5e-14
cpar_gc2_and_a7_nb gc2_and_a7_nb 0 5e-14
cpar_gc2_and_a7_nx gc2_and_a7_nx 0 5e-14
cpar_gc2_and_a8_nb gc2_and_a8_nb 0 5e-14
cpar_gc2_and_a8_nx gc2_and_a8_nx 0 5e-14
cpar_gc2_and_g0 gc2_and_g0 0 5e-14
cpar_gc2_and_g1 gc2_and_g1 0 5e-14
cpar_gc2_and_g2 gc2_and_g2 0 5e-14
cpar_gc2_and_g3 gc2_and_g3 0 5e-14
cpar_gc2_and_g4 gc2_and_g4 0 5e-14
cpar_gc2_and_g5 gc2_and_g5 0 5e-14
cpar_gc2_and_g6 gc2_and_g6 0 5e-14
cpar_gc2_and_g7 gc2_and_g7 0 5e-14
cpar_gc2_and_g8 gc2_and_g8 0 5e-14
cpar_gc2_b1 gc2_b1 0 5e-14
cpar_gc2_b10 gc2_b10 0 5e-14
cpar_gc2_b10_n gc2_b10_n 0 5e-14
cpar_gc2_b10_q gc2_b10_q 0 5e-14
cpar_gc2_b10_t gc2_b10_t 0 5e-14
cpar_gc2_b1_n gc2_b1_n 0 5e-14
cpar_gc2_b1_q gc2_b1_q 0 5e-14
cpar_gc2_b1_t gc2_b1_t 0 5e-14
cpar_gc2_b2 gc2_b2 0 5e-14
cpar_gc2_b2_n gc2_b2_n 0 5e-14
cpar_gc2_b2_q gc2_b2_q 0 5e-14
cpar_gc2_b2_t gc2_b2_t 0 5e-14
cpar_gc2_b3 gc2_b3 0 5e-14
cpar_gc2_b3_n gc2_b3_n 0 5e-14
cpar_gc2_b3_q gc2_b3_q 0 5e-14
cpar_gc2_b3_t gc2_b3_t 0 5e-14
cpar_gc2_b4 gc2_b4 0 5e-14
cpar_gc2_b4_n gc2_b4_n 0 5e-14
cpar_gc2_b4_q gc2_b4_q 0 5e-14
cpar_gc2_b4_t gc2_b4_t 0 5e-14
cpar_gc2_b5 gc2_b5 0 5e-14
cpar_gc2_b5_n gc2_b5_n 0 5e-14
cpar_gc2_b5_q gc2_b5_q 0 5e-14
cpar_gc2_b5_t gc2_b5_t 0 5e-14
cpar_gc2_b6 gc2_b6 0 5e-14
cpar_gc2_b6_n gc2_b6_n 0 5e-14
cpar_gc2_b6_q gc2_b6_q 0 5e-14
cpar_gc2_b6_t gc2_b6_t 0 5e-14
cpar_gc2_b7 gc2_b7 0 5e-14
cpar_gc2_b7_n gc2_b7_n 0 5e-14
cpar_gc2_b7_q gc2_b7_q 0 5e-14
cpar_gc2_b7_t gc2_b7_t 0 5e-14
cpar_gc2_b8 gc2_b8 0 5e-14
cpar_gc2_b8_n gc2_b8_n 0 5e-14
cpar_gc2_b8_q gc2_b8_q 0 5e-14
cpar_gc2_b8_t gc2_b8_t 0 5e-14
cpar_gc2_b9 gc2_b9 0 5e-14
cpar_gc2_b9_n gc2_b9_n 0 5e-14
cpar_gc2_b9_q gc2_b9_q 0 5e-14
cpar_gc2_b9_t gc2_b9_t 0 5e-14
cpar_gc2_cin_x gc2_cin_x 0 5e-14
cpar_gc2_col_h gc2_col_h 0 5e-14
cpar_gc2_col_kd1 gc2_col_kd1 0 5e-14
cpar_gc2_col_knb gc2_col_knb 0 5e-14
cpar_gc2_col_ko1 gc2_col_ko1 0 5e-14
cpar_gc2_col_ktail gc2_col_ktail 0 5e-14
cpar_gc2_col_q gc2_col_q 0 5e-14
cpar_gc2_col_qb gc2_col_qb 0 5e-14
cpar_gc2_col_rec gc2_col_rec 0 5e-14
cpar_gc2_col_rt gc2_col_rt 0 5e-14
cpar_gc2_col_vm gc2_col_vm 0 5e-14
cpar_gc2_col_vmd gc2_col_vmd 0 5e-14
cpar_gc2_col_vms gc2_col_vms 0 5e-14
cpar_gc2_e10_h gc2_e10_h 0 5e-14
cpar_gc2_e10_kd1 gc2_e10_kd1 0 5e-14
cpar_gc2_e10_knb gc2_e10_knb 0 5e-14
cpar_gc2_e10_ko1 gc2_e10_ko1 0 5e-14
cpar_gc2_e10_ktail gc2_e10_ktail 0 5e-14
cpar_gc2_e10_q gc2_e10_q 0 5e-14
cpar_gc2_e10_qb gc2_e10_qb 0 5e-14
cpar_gc2_e10_rec gc2_e10_rec 0 5e-14
cpar_gc2_e10_rt gc2_e10_rt 0 5e-14
cpar_gc2_e10_vm gc2_e10_vm 0 5e-14
cpar_gc2_e10_vmd gc2_e10_vmd 0 5e-14
cpar_gc2_e10_vms gc2_e10_vms 0 5e-14
cpar_gc2_e1_h gc2_e1_h 0 5e-14
cpar_gc2_e1_kd1 gc2_e1_kd1 0 5e-14
cpar_gc2_e1_knb gc2_e1_knb 0 5e-14
cpar_gc2_e1_ko1 gc2_e1_ko1 0 5e-14
cpar_gc2_e1_ktail gc2_e1_ktail 0 5e-14
cpar_gc2_e1_q gc2_e1_q 0 5e-14
cpar_gc2_e1_qb gc2_e1_qb 0 5e-14
cpar_gc2_e1_rec gc2_e1_rec 0 5e-14
cpar_gc2_e1_rt gc2_e1_rt 0 5e-14
cpar_gc2_e1_vm gc2_e1_vm 0 5e-14
cpar_gc2_e1_vmd gc2_e1_vmd 0 5e-14
cpar_gc2_e1_vms gc2_e1_vms 0 5e-14
cpar_gc2_e2_h gc2_e2_h 0 5e-14
cpar_gc2_e2_kd1 gc2_e2_kd1 0 5e-14
cpar_gc2_e2_knb gc2_e2_knb 0 5e-14
cpar_gc2_e2_ko1 gc2_e2_ko1 0 5e-14
cpar_gc2_e2_ktail gc2_e2_ktail 0 5e-14
cpar_gc2_e2_q gc2_e2_q 0 5e-14
cpar_gc2_e2_qb gc2_e2_qb 0 5e-14
cpar_gc2_e2_rec gc2_e2_rec 0 5e-14
cpar_gc2_e2_rt gc2_e2_rt 0 5e-14
cpar_gc2_e2_vm gc2_e2_vm 0 5e-14
cpar_gc2_e2_vmd gc2_e2_vmd 0 5e-14
cpar_gc2_e2_vms gc2_e2_vms 0 5e-14
cpar_gc2_e3_h gc2_e3_h 0 5e-14
cpar_gc2_e3_kd1 gc2_e3_kd1 0 5e-14
cpar_gc2_e3_knb gc2_e3_knb 0 5e-14
cpar_gc2_e3_ko1 gc2_e3_ko1 0 5e-14
cpar_gc2_e3_ktail gc2_e3_ktail 0 5e-14
cpar_gc2_e3_q gc2_e3_q 0 5e-14
cpar_gc2_e3_qb gc2_e3_qb 0 5e-14
cpar_gc2_e3_rec gc2_e3_rec 0 5e-14
cpar_gc2_e3_rt gc2_e3_rt 0 5e-14
cpar_gc2_e3_vm gc2_e3_vm 0 5e-14
cpar_gc2_e3_vmd gc2_e3_vmd 0 5e-14
cpar_gc2_e3_vms gc2_e3_vms 0 5e-14
cpar_gc2_e4_h gc2_e4_h 0 5e-14
cpar_gc2_e4_kd1 gc2_e4_kd1 0 5e-14
cpar_gc2_e4_knb gc2_e4_knb 0 5e-14
cpar_gc2_e4_ko1 gc2_e4_ko1 0 5e-14
cpar_gc2_e4_ktail gc2_e4_ktail 0 5e-14
cpar_gc2_e4_q gc2_e4_q 0 5e-14
cpar_gc2_e4_qb gc2_e4_qb 0 5e-14
cpar_gc2_e4_rec gc2_e4_rec 0 5e-14
cpar_gc2_e4_rt gc2_e4_rt 0 5e-14
cpar_gc2_e4_vm gc2_e4_vm 0 5e-14
cpar_gc2_e4_vmd gc2_e4_vmd 0 5e-14
cpar_gc2_e4_vms gc2_e4_vms 0 5e-14
cpar_gc2_e5_h gc2_e5_h 0 5e-14
cpar_gc2_e5_kd1 gc2_e5_kd1 0 5e-14
cpar_gc2_e5_knb gc2_e5_knb 0 5e-14
cpar_gc2_e5_ko1 gc2_e5_ko1 0 5e-14
cpar_gc2_e5_ktail gc2_e5_ktail 0 5e-14
cpar_gc2_e5_q gc2_e5_q 0 5e-14
cpar_gc2_e5_qb gc2_e5_qb 0 5e-14
cpar_gc2_e5_rec gc2_e5_rec 0 5e-14
cpar_gc2_e5_rt gc2_e5_rt 0 5e-14
cpar_gc2_e5_vm gc2_e5_vm 0 5e-14
cpar_gc2_e5_vmd gc2_e5_vmd 0 5e-14
cpar_gc2_e5_vms gc2_e5_vms 0 5e-14
cpar_gc2_e6_h gc2_e6_h 0 5e-14
cpar_gc2_e6_kd1 gc2_e6_kd1 0 5e-14
cpar_gc2_e6_knb gc2_e6_knb 0 5e-14
cpar_gc2_e6_ko1 gc2_e6_ko1 0 5e-14
cpar_gc2_e6_ktail gc2_e6_ktail 0 5e-14
cpar_gc2_e6_q gc2_e6_q 0 5e-14
cpar_gc2_e6_qb gc2_e6_qb 0 5e-14
cpar_gc2_e6_rec gc2_e6_rec 0 5e-14
cpar_gc2_e6_rt gc2_e6_rt 0 5e-14
cpar_gc2_e6_vm gc2_e6_vm 0 5e-14
cpar_gc2_e6_vmd gc2_e6_vmd 0 5e-14
cpar_gc2_e6_vms gc2_e6_vms 0 5e-14
cpar_gc2_e7_h gc2_e7_h 0 5e-14
cpar_gc2_e7_kd1 gc2_e7_kd1 0 5e-14
cpar_gc2_e7_knb gc2_e7_knb 0 5e-14
cpar_gc2_e7_ko1 gc2_e7_ko1 0 5e-14
cpar_gc2_e7_ktail gc2_e7_ktail 0 5e-14
cpar_gc2_e7_q gc2_e7_q 0 5e-14
cpar_gc2_e7_qb gc2_e7_qb 0 5e-14
cpar_gc2_e7_rec gc2_e7_rec 0 5e-14
cpar_gc2_e7_rt gc2_e7_rt 0 5e-14
cpar_gc2_e7_vm gc2_e7_vm 0 5e-14
cpar_gc2_e7_vmd gc2_e7_vmd 0 5e-14
cpar_gc2_e7_vms gc2_e7_vms 0 5e-14
cpar_gc2_e8_h gc2_e8_h 0 5e-14
cpar_gc2_e8_kd1 gc2_e8_kd1 0 5e-14
cpar_gc2_e8_knb gc2_e8_knb 0 5e-14
cpar_gc2_e8_ko1 gc2_e8_ko1 0 5e-14
cpar_gc2_e8_ktail gc2_e8_ktail 0 5e-14
cpar_gc2_e8_q gc2_e8_q 0 5e-14
cpar_gc2_e8_qb gc2_e8_qb 0 5e-14
cpar_gc2_e8_rec gc2_e8_rec 0 5e-14
cpar_gc2_e8_rt gc2_e8_rt 0 5e-14
cpar_gc2_e8_vm gc2_e8_vm 0 5e-14
cpar_gc2_e8_vmd gc2_e8_vmd 0 5e-14
cpar_gc2_e8_vms gc2_e8_vms 0 5e-14
cpar_gc2_e9_h gc2_e9_h 0 5e-14
cpar_gc2_e9_kd1 gc2_e9_kd1 0 5e-14
cpar_gc2_e9_knb gc2_e9_knb 0 5e-14
cpar_gc2_e9_ko1 gc2_e9_ko1 0 5e-14
cpar_gc2_e9_ktail gc2_e9_ktail 0 5e-14
cpar_gc2_e9_q gc2_e9_q 0 5e-14
cpar_gc2_e9_qb gc2_e9_qb 0 5e-14
cpar_gc2_e9_rec gc2_e9_rec 0 5e-14
cpar_gc2_e9_rt gc2_e9_rt 0 5e-14
cpar_gc2_e9_vm gc2_e9_vm 0 5e-14
cpar_gc2_e9_vmd gc2_e9_vmd 0 5e-14
cpar_gc2_e9_vms gc2_e9_vms 0 5e-14
cpar_gc2_gb gc2_gb 0 5e-14
cpar_gc2_op_ad gc2_op_ad 0 5e-14
cpar_gc2_op_adn gc2_op_adn 0 5e-14
cpar_gc2_op_an gc2_op_an 0 5e-14
cpar_gc2_op_aq gc2_op_aq 0 5e-14
cpar_gc2_op_aqb gc2_op_aqb 0 5e-14
cpar_gc2_op_at gc2_op_at 0 5e-14
cpar_gc2_op_gx gc2_op_gx 0 5e-14
cpar_gc2_op_p gc2_op_p 0 5e-14
cpar_gc2_op_pb gc2_op_pb 0 5e-14
cpar_gc2_op_tt gc2_op_tt 0 5e-14
cpar_hc1 hc1 0 5e-14
cpar_hc2 hc2 0 5e-14
cpar_hsc1_h1 hsc1_h1 0 5e-14
cpar_hsc1_sd hsc1_sd 0 5e-14
cpar_hsc2_h1 hsc2_h1 0 5e-14
cpar_hsc2_sd hsc2_sd 0 5e-14
cpar_ilim_n ilim_n 0 5e-14
cpar_ilimp_n ilimp_n 0 5e-14
cpar_iref_n iref_n 0 5e-14
cpar_irefp_n irefp_n 0 5e-14
cpar_istep_n istep_n 0 5e-14
va_cpar_load_neg_p load_neg cpar_load_neg_p 0
cpar_load_neg cpar_load_neg_p 0 5e-14
va_cpar_load_pos_p load_pos cpar_load_pos_p 0
cpar_load_pos cpar_load_pos_p 0 5e-14
cpar_por_hold por_hold 0 5e-14
cpar_por_ok por_ok 0 5e-14
cpar_porc porc 0 5e-14
cpar_porx porx 0 5e-14
cpar_s1_anb s1_anb 0 5e-14
cpar_s1_atl s1_atl 0 5e-14
cpar_s1_da s1_da 0 5e-14
cpar_s1_db s1_db 0 5e-14
cpar_s1_m s1_m 0 5e-14
cpar_s1_s s1_s 0 5e-14
cpar_s1_tl s1_tl 0 5e-14
cpar_s1_ya s1_ya 0 5e-14
cpar_s1_yb s1_yb 0 5e-14
cpar_s1_za s1_za 0 5e-14
cpar_s1_zb s1_zb 0 5e-14
cpar_s2_anb s2_anb 0 5e-14
cpar_s2_atl s2_atl 0 5e-14
cpar_s2_da s2_da 0 5e-14
cpar_s2_db s2_db 0 5e-14
cpar_s2_m s2_m 0 5e-14
cpar_s2_s s2_s 0 5e-14
cpar_s2_tl s2_tl 0 5e-14
cpar_s2_ya s2_ya 0 5e-14
cpar_s2_yb s2_yb 0 5e-14
cpar_s2_za s2_za 0 5e-14
cpar_s2_zb s2_zb 0 5e-14
cpar_s3_anb s3_anb 0 5e-14
cpar_s3_atl s3_atl 0 5e-14
cpar_s3_da s3_da 0 5e-14
cpar_s3_db s3_db 0 5e-14
cpar_s3_m s3_m 0 5e-14
cpar_s3_s s3_s 0 5e-14
cpar_s3_tl s3_tl 0 5e-14
cpar_s3_ya s3_ya 0 5e-14
cpar_s3_yb s3_yb 0 5e-14
cpar_s3_za s3_za 0 5e-14
cpar_s3_zb s3_zb 0 5e-14
cpar_s4_anb s4_anb 0 5e-14
cpar_s4_atl s4_atl 0 5e-14
cpar_s4_da s4_da 0 5e-14
cpar_s4_db s4_db 0 5e-14
cpar_s4_m s4_m 0 5e-14
cpar_s4_s s4_s 0 5e-14
cpar_s4_tl s4_tl 0 5e-14
cpar_s4_ya s4_ya 0 5e-14
cpar_s4_yb s4_yb 0 5e-14
cpar_s4_za s4_za 0 5e-14
cpar_s4_zb s4_zb 0 5e-14
cpar_sgc12f_h sgc12f_h 0 5e-14
cpar_sgc12f_kd1 sgc12f_kd1 0 5e-14
cpar_sgc12f_knb sgc12f_knb 0 5e-14
cpar_sgc12f_ko1 sgc12f_ko1 0 5e-14
cpar_sgc12f_ktail sgc12f_ktail 0 5e-14
cpar_sgc12f_op_ad sgc12f_op_ad 0 5e-14
cpar_sgc12f_op_adn sgc12f_op_adn 0 5e-14
cpar_sgc12f_op_an sgc12f_op_an 0 5e-14
cpar_sgc12f_op_aq sgc12f_op_aq 0 5e-14
cpar_sgc12f_op_aqb sgc12f_op_aqb 0 5e-14
cpar_sgc12f_op_at sgc12f_op_at 0 5e-14
cpar_sgc12f_op_gx sgc12f_op_gx 0 5e-14
cpar_sgc12f_op_p sgc12f_op_p 0 5e-14
cpar_sgc12f_op_pb sgc12f_op_pb 0 5e-14
cpar_sgc12f_op_tt sgc12f_op_tt 0 5e-14
cpar_sgc12f_ota_d1 sgc12f_ota_d1 0 5e-14
cpar_sgc12f_ota_nb sgc12f_ota_nb 0 5e-14
cpar_sgc12f_ota_tail sgc12f_ota_tail 0 5e-14
cpar_sgc12f_q sgc12f_q 0 5e-14
cpar_sgc12f_qb sgc12f_qb 0 5e-14
cpar_sgc12f_rec sgc12f_rec 0 5e-14
cpar_sgc12f_rt sgc12f_rt 0 5e-14
va_cpar_sgc12f_vm_p sgc12f_vm cpar_sgc12f_vm_p 0
cpar_sgc12f_vm cpar_sgc12f_vm_p 0 5e-14
va_cpar_sgc12f_vmd_p sgc12f_vmd cpar_sgc12f_vmd_p 0
cpar_sgc12f_vmd cpar_sgc12f_vmd_p 0 5e-14
va_cpar_sgc12f_vms_p sgc12f_vms cpar_sgc12f_vms_p 0
cpar_sgc12f_vms cpar_sgc12f_vms_p 0 5e-14
cpar_sgc12r_h sgc12r_h 0 5e-14
cpar_sgc12r_kd1 sgc12r_kd1 0 5e-14
cpar_sgc12r_knb sgc12r_knb 0 5e-14
cpar_sgc12r_ko1 sgc12r_ko1 0 5e-14
cpar_sgc12r_ktail sgc12r_ktail 0 5e-14
cpar_sgc12r_op_ad sgc12r_op_ad 0 5e-14
cpar_sgc12r_op_adn sgc12r_op_adn 0 5e-14
cpar_sgc12r_op_an sgc12r_op_an 0 5e-14
cpar_sgc12r_op_aq sgc12r_op_aq 0 5e-14
cpar_sgc12r_op_aqb sgc12r_op_aqb 0 5e-14
cpar_sgc12r_op_at sgc12r_op_at 0 5e-14
cpar_sgc12r_op_gx sgc12r_op_gx 0 5e-14
cpar_sgc12r_op_p sgc12r_op_p 0 5e-14
cpar_sgc12r_op_pb sgc12r_op_pb 0 5e-14
cpar_sgc12r_op_tt sgc12r_op_tt 0 5e-14
cpar_sgc12r_ota_d1 sgc12r_ota_d1 0 5e-14
cpar_sgc12r_ota_nb sgc12r_ota_nb 0 5e-14
cpar_sgc12r_ota_tail sgc12r_ota_tail 0 5e-14
cpar_sgc12r_q sgc12r_q 0 5e-14
cpar_sgc12r_qb sgc12r_qb 0 5e-14
cpar_sgc12r_rec sgc12r_rec 0 5e-14
cpar_sgc12r_rt sgc12r_rt 0 5e-14
va_cpar_sgc12r_vm_p sgc12r_vm cpar_sgc12r_vm_p 0
cpar_sgc12r_vm cpar_sgc12r_vm_p 0 5e-14
va_cpar_sgc12r_vmd_p sgc12r_vmd cpar_sgc12r_vmd_p 0
cpar_sgc12r_vmd cpar_sgc12r_vmd_p 0 5e-14
va_cpar_sgc12r_vms_p sgc12r_vms cpar_sgc12r_vms_p 0
cpar_sgc12r_vms cpar_sgc12r_vms_p 0 5e-14
cpar_spc1 spc1 0 5e-14
cpar_spc2 spc2 0 5e-14
cpar_spc3 spc3 0 5e-14
cpar_spc4 spc4 0 5e-14
cpar_spci1_x spci1_x 0 5e-14
cpar_spci2_x spci2_x 0 5e-14
cpar_spci3_x spci3_x 0 5e-14
cpar_spci4_x spci4_x 0 5e-14
cpar_spcs12 spcs12 0 5e-14
cpar_spcs23 spcs23 0 5e-14
cpar_spcs34 spcs34 0 5e-14
cpar_thc12f_h thc12f_h 0 5e-14
cpar_thc12f_kd1 thc12f_kd1 0 5e-14
cpar_thc12f_knb thc12f_knb 0 5e-14
cpar_thc12f_ko1 thc12f_ko1 0 5e-14
cpar_thc12f_ktail thc12f_ktail 0 5e-14
cpar_thc12f_mi thc12f_mi 0 5e-14
cpar_thc12f_op_ad thc12f_op_ad 0 5e-14
cpar_thc12f_op_adn thc12f_op_adn 0 5e-14
cpar_thc12f_op_an thc12f_op_an 0 5e-14
cpar_thc12f_op_aq thc12f_op_aq 0 5e-14
cpar_thc12f_op_aqb thc12f_op_aqb 0 5e-14
cpar_thc12f_op_at thc12f_op_at 0 5e-14
cpar_thc12f_op_gx thc12f_op_gx 0 5e-14
cpar_thc12f_op_p thc12f_op_p 0 5e-14
cpar_thc12f_op_pb thc12f_op_pb 0 5e-14
cpar_thc12f_op_tt thc12f_op_tt 0 5e-14
cpar_thc12f_q thc12f_q 0 5e-14
cpar_thc12f_qb thc12f_qb 0 5e-14
cpar_thc12f_rec thc12f_rec 0 5e-14
cpar_thc12f_rt thc12f_rt 0 5e-14
cpar_thc12f_st_x thc12f_st_x 0 5e-14
va_cpar_thc12f_vm_p thc12f_vm cpar_thc12f_vm_p 0
cpar_thc12f_vm cpar_thc12f_vm_p 0 5e-14
va_cpar_thc12f_vmd_p thc12f_vmd cpar_thc12f_vmd_p 0
cpar_thc12f_vmd cpar_thc12f_vmd_p 0 5e-14
va_cpar_thc12f_vms_p thc12f_vms cpar_thc12f_vms_p 0
cpar_thc12f_vms cpar_thc12f_vms_p 0 5e-14
cpar_thc12r_h thc12r_h 0 5e-14
cpar_thc12r_kd1 thc12r_kd1 0 5e-14
cpar_thc12r_knb thc12r_knb 0 5e-14
cpar_thc12r_ko1 thc12r_ko1 0 5e-14
cpar_thc12r_ktail thc12r_ktail 0 5e-14
cpar_thc12r_mi thc12r_mi 0 5e-14
cpar_thc12r_op_ad thc12r_op_ad 0 5e-14
cpar_thc12r_op_adn thc12r_op_adn 0 5e-14
cpar_thc12r_op_an thc12r_op_an 0 5e-14
cpar_thc12r_op_aq thc12r_op_aq 0 5e-14
cpar_thc12r_op_aqb thc12r_op_aqb 0 5e-14
cpar_thc12r_op_at thc12r_op_at 0 5e-14
cpar_thc12r_op_gx thc12r_op_gx 0 5e-14
cpar_thc12r_op_p thc12r_op_p 0 5e-14
cpar_thc12r_op_pb thc12r_op_pb 0 5e-14
cpar_thc12r_op_tt thc12r_op_tt 0 5e-14
cpar_thc12r_q thc12r_q 0 5e-14
cpar_thc12r_qb thc12r_qb 0 5e-14
cpar_thc12r_rec thc12r_rec 0 5e-14
cpar_thc12r_rt thc12r_rt 0 5e-14
cpar_thc12r_st_x thc12r_st_x 0 5e-14
va_cpar_thc12r_vm_p thc12r_vm cpar_thc12r_vm_p 0
cpar_thc12r_vm cpar_thc12r_vm_p 0 5e-14
va_cpar_thc12r_vmd_p thc12r_vmd cpar_thc12r_vmd_p 0
cpar_thc12r_vmd cpar_thc12r_vmd_p 0 5e-14
va_cpar_thc12r_vms_p thc12r_vms cpar_thc12r_vms_p 0
cpar_thc12r_vms cpar_thc12r_vms_p 0 5e-14
cpar_vdd vdd 0 5e-14
cpar_vmid vmid 0 5e-14
cpar_vrest vrest 0 5e-14
cpar_vthe vthe 0 5e-14
cpar_vthr vthr 0 5e-14
.options klu method=gear reltol=1e-5 abstol=1e-16
.save v(vdd) v(vrest) v(vmid) v(load_pos) v(load_neg) v(gc1_col_q) v(gc1_op_aq) v(gc1_op_p) v(hc1) v(gc2_col_q) v(gc2_op_aq) v(gc2_op_p) v(hc2) v(thc12f_vm) v(thc12f_q) v(thc12f_qb) v(thc12f_h) v(thc12f_rec) v(thc12f_vmd) v(thc12f_op_at) v(thc12f_op_aq) v(thc12f_op_p) v(sgc12f_vm) v(sgc12f_q) v(sgc12f_qb) v(sgc12f_h) v(sgc12f_rec) v(sgc12f_vmd) v(sgc12f_op_at) v(sgc12f_op_aq) v(sgc12f_op_p) v(cdc12f_vm) v(cdc12f_q) v(cdc12f_qb) v(cdc12f_h) v(cdc12f_rec) v(cdc12f_vmd) v(cdc12f_op_at) v(cdc12f_op_aq) v(cdc12f_op_p) v(cdc12f_hs) v(cdc12f_hc) v(thc12r_vm) v(thc12r_q) v(thc12r_qb) v(thc12r_h) v(thc12r_rec) v(thc12r_vmd) v(thc12r_op_at) v(thc12r_op_aq) v(thc12r_op_p) v(sgc12r_vm) v(sgc12r_q) v(sgc12r_qb) v(sgc12r_h) v(sgc12r_rec) v(sgc12r_vmd) v(sgc12r_op_at) v(sgc12r_op_aq) v(sgc12r_op_p) v(cdc12r_vm) v(cdc12r_q) v(cdc12r_qb) v(cdc12r_h) v(cdc12r_rec) v(cdc12r_vmd) v(cdc12r_op_at) v(cdc12r_op_aq) v(cdc12r_op_p) v(cdc12r_hs) v(cdc12r_hc) v(spc1) v(spc2) v(spcs12) v(thc12f_vms) v(thc12r_vms) v(sgc12f_vms) v(sgc12r_vms) v(cdc12f_vms) v(cdc12r_vms) i(va_cthc12f_cm_p) i(va_rthc12f_rm_p) i(va_nthc12f_km1_g) i(va_nthc12f_dis_d) i(va_nthc12f_sh1_d) i(va_nthc12f_porm_d) i(va_nthc12f_rm_mo_d) i(va_cpar_thc12f_vm_p) i(va_nthc12f_dis_s) i(va_rthc12f_rdis_p) i(va_cpar_thc12f_vmd_p) i(va_nthc12f_sh1_s) i(va_nthc12f_sh2_d) i(va_cpar_thc12f_vms_p) i(va_cthc12r_cm_p) i(va_rthc12r_rm_p) i(va_nthc12r_km1_g) i(va_nthc12r_dis_d) i(va_nthc12r_sh1_d) i(va_nthc12r_porm_d) i(va_nthc12r_rm_mo_d) i(va_cpar_thc12r_vm_p) i(va_nthc12r_dis_s) i(va_rthc12r_rdis_p) i(va_cpar_thc12r_vmd_p) i(va_nthc12r_sh1_s) i(va_nthc12r_sh2_d) i(va_cpar_thc12r_vms_p) i(va_csgc12f_cm_p) i(va_rsgc12f_rm_p) i(va_nsgc12f_km1_g) i(va_nsgc12f_dis_d) i(va_nsgc12f_sh1_d) i(va_nsgc12f_porm_d) i(va_nsgc12f_ota_m2_d) i(va_nsgc12f_ota_m4_d) i(va_cpar_sgc12f_vm_p) i(va_nsgc12f_dis_s) i(va_rsgc12f_rdis_p) i(va_cpar_sgc12f_vmd_p) i(va_nsgc12f_sh1_s) i(va_nsgc12f_sh2_d) i(va_cpar_sgc12f_vms_p) i(va_csgc12r_cm_p) i(va_rsgc12r_rm_p) i(va_nsgc12r_km1_g) i(va_nsgc12r_dis_d) i(va_nsgc12r_sh1_d) i(va_nsgc12r_porm_d) i(va_nsgc12r_ota_m2_d) i(va_nsgc12r_ota_m4_d) i(va_cpar_sgc12r_vm_p) i(va_nsgc12r_dis_s) i(va_rsgc12r_rdis_p) i(va_cpar_sgc12r_vmd_p) i(va_nsgc12r_sh1_s) i(va_nsgc12r_sh2_d) i(va_cpar_sgc12r_vms_p) i(va_ccdc12f_cm_p) i(va_rcdc12f_rm_p) i(va_ncdc12f_km1_g) i(va_ncdc12f_dis_d) i(va_ncdc12f_sh1_d) i(va_ncdc12f_porm_d) i(va_ncdc12f_rm_mo_d) i(va_ncdc12f_kh_d) i(va_cpar_cdc12f_vm_p) i(va_ncdc12f_dis_s) i(va_rcdc12f_rdis_p) i(va_cpar_cdc12f_vmd_p) i(va_ncdc12f_sh1_s) i(va_ncdc12f_sh2_d) i(va_cpar_cdc12f_vms_p) i(va_ccdc12r_cm_p) i(va_rcdc12r_rm_p) i(va_ncdc12r_km1_g) i(va_ncdc12r_dis_d) i(va_ncdc12r_sh1_d) i(va_ncdc12r_porm_d) i(va_ncdc12r_rm_mo_d) i(va_ncdc12r_kh_d) i(va_cpar_cdc12r_vm_p) i(va_ncdc12r_dis_s) i(va_rcdc12r_rdis_p) i(va_cpar_cdc12r_vmd_p) i(va_ncdc12r_sh1_s) i(va_ncdc12r_sh2_d) i(va_cpar_cdc12r_vms_p) i(va_cldpos_p) i(va_rldpos_p) i(va_nagc12f_cp_d) i(va_cpar_load_pos_p) i(va_cldneg_p) i(va_rldneg_p) i(va_nagc12r_cp_d) i(va_cpar_load_neg_p) v(vsrc) i(vsrc)
.control
pre_osdi <OSDI>
set filetype=binary
tran 0.001 40.7 0 0.0005
write <RAW>
quit
.endc
.end

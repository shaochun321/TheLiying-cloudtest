* THERMAL-G3 v3 one candidate DC_3
.include /workspace/thermal-g3-repair/gated-source-v3-2026-10-23-fc4ec434/inputs/c05_ekv26_typ.lib
vsrc vsrc 0 DC 3.0
rint vsrc vdd 10
cdec vdd 0 1e-05
va_rvrestt_n vrest rvrestt_n 0
rvrestt vdd rvrestt_n 1000
va_rvrestb_p vrest rvrestb_p 0
rvrestb rvrestb_p 0 500
va_cvrestc_p vrest cvrestc_p 0
cvrestc cvrestc_p 0 1e-05
rvthet vdd vthe 2000
rvtheb vthe 0 1800
cvthec vthe 0 1e-05
rvthrt vdd vthr 2400
rvthrb vthr 0 1500
cvthrc vthr 0 1e-05
rvmidt vdd vmid 2000
rvmidb vmid 0 2000
cvmidc vmid 0 1e-05
rporr vdd porc 2.2e+06
cporc porc 0 1e-06
rporra porc porx 1e+06
rporrf por_ok porx 4e+06
npori1p por_hold porx vdd vsrc pch W=2.4e-06 L=5e-07
npori1n por_hold porx 0 0 nch W=1.2e-06 L=5e-07
npori2p por_ok por_hold vdd vsrc pch W=2.4e-06 L=5e-07
npori2n por_ok por_hold 0 0 nch W=1.2e-06 L=5e-07
riref vdd iref_n 2.2e+06
nirefd iref_n iref_n 0 0 nch W=4e-06 L=4e-06
ristep vdd istep_n 5.6e+07
nistepd istep_n istep_n 0 0 nch W=4e-06 L=4e-06
nirefm irefp_n iref_n 0 0 nch W=4e-06 L=4e-06
nirefpd irefp_n irefp_n vdd vsrc pch W=4e-06 L=4e-06
rilim vdd ilim_n 1.85e+06
nilimd ilim_n ilim_n 0 0 nch W=4e-06 L=4e-06
nilimm ilimp_n ilim_n 0 0 nch W=4e-06 L=4e-06
nilimpd ilimp_n ilimp_n vdd vsrc pch W=4e-06 L=4e-06
bs1_te s1_te 0 V=18.5
vqes1 s1_te s1_tea DC 0
rs1_ge s1_tea s1_tp 500
cs1_cp s1_tp 0 0.01
rs1_gm s1_tp s1_tn 1000
cs1_cn s1_tn 0 0.0001
bs1_ntc vdd s1_s I=V(vdd,s1_s)/(100000*exp(4250*(1/(298.15+V(s1_tn))-1/298.15)))
bs1_heat 0 s1_th I=V(vdd,s1_s)*V(vdd,s1_s)/(100000*exp(4250*(1/(298.15+V(s1_tn))-1/298.15)))
vqhs1 s1_th s1_tn DC 0
rs1_rs s1_s 0 100000
rs1_ravg s1_s s1_m 2e+06
cs1_cavg s1_m 0 1e-06
ns1_mpor s1_m por_ok s1_s vsrc pch W=4e-06 L=1e-06
rs1_ab vdd s1_anb 750000
ns1_amb s1_anb s1_anb 0 0 nch W=4e-06 L=4e-06
ns1_amt s1_atl s1_anb 0 0 nch W=4e-06 L=4e-06
ns1_am1 s1_da s1_s s1_atl 0 nch W=1e-06 L=4e-06
ns1_am2 s1_db s1_m s1_atl 0 nch W=1e-06 L=4e-06
rs1_ara vdd s1_da 680000
rs1_arb vdd s1_db 680000
ns1_tt s1_tl ilim_n 0 0 nch W=4e-06 L=4e-06
ns1_ta s1_ya s1_db s1_tl 0 nch W=1e-05 L=2e-06
ns1_tb s1_yb s1_da s1_tl 0 nch W=1e-05 L=2e-06
ns1_la s1_ya s1_ya vdd vsrc pch W=4e-06 L=4e-06
ns1_lb s1_yb s1_yb vdd vsrc pch W=4e-06 L=4e-06
ns1_ca s1_za s1_ya vdd vsrc pch W=4e-06 L=4e-06
ns1_na s1_za s1_za 0 0 nch W=4e-06 L=4e-06
ns1_cb s1_zb s1_yb vdd vsrc pch W=4e-06 L=4e-06
ns1_nb s1_zb s1_zb 0 0 nch W=4e-06 L=4e-06
bs2_te s2_te 0 V=18.5
vqes2 s2_te s2_tea DC 0
rs2_ge s2_tea s2_tp 500
cs2_cp s2_tp 0 0.01
rs2_gm s2_tp s2_tn 1000
cs2_cn s2_tn 0 0.0001
bs2_ntc vdd s2_s I=V(vdd,s2_s)/(100000*exp(4250*(1/(298.15+V(s2_tn))-1/298.15)))
bs2_heat 0 s2_th I=V(vdd,s2_s)*V(vdd,s2_s)/(100000*exp(4250*(1/(298.15+V(s2_tn))-1/298.15)))
vqhs2 s2_th s2_tn DC 0
rs2_rs s2_s 0 100000
rs2_ravg s2_s s2_m 2e+06
cs2_cavg s2_m 0 1e-06
ns2_mpor s2_m por_ok s2_s vsrc pch W=4e-06 L=1e-06
rs2_ab vdd s2_anb 750000
ns2_amb s2_anb s2_anb 0 0 nch W=4e-06 L=4e-06
ns2_amt s2_atl s2_anb 0 0 nch W=4e-06 L=4e-06
ns2_am1 s2_da s2_s s2_atl 0 nch W=1e-06 L=4e-06
ns2_am2 s2_db s2_m s2_atl 0 nch W=1e-06 L=4e-06
rs2_ara vdd s2_da 680000
rs2_arb vdd s2_db 680000
ns2_tt s2_tl ilim_n 0 0 nch W=4e-06 L=4e-06
ns2_ta s2_ya s2_db s2_tl 0 nch W=1e-05 L=2e-06
ns2_tb s2_yb s2_da s2_tl 0 nch W=1e-05 L=2e-06
ns2_la s2_ya s2_ya vdd vsrc pch W=4e-06 L=4e-06
ns2_lb s2_yb s2_yb vdd vsrc pch W=4e-06 L=4e-06
ns2_ca s2_za s2_ya vdd vsrc pch W=4e-06 L=4e-06
ns2_na s2_za s2_za 0 0 nch W=4e-06 L=4e-06
ns2_cb s2_zb s2_yb vdd vsrc pch W=4e-06 L=4e-06
ns2_nb s2_zb s2_zb 0 0 nch W=4e-06 L=4e-06
bs3_te s3_te 0 V=18.5
vqes3 s3_te s3_tea DC 0
rs3_ge s3_tea s3_tp 500
cs3_cp s3_tp 0 0.01
rs3_gm s3_tp s3_tn 1000
cs3_cn s3_tn 0 0.0001
bs3_ntc vdd s3_s I=V(vdd,s3_s)/(100000*exp(4250*(1/(298.15+V(s3_tn))-1/298.15)))
bs3_heat 0 s3_th I=V(vdd,s3_s)*V(vdd,s3_s)/(100000*exp(4250*(1/(298.15+V(s3_tn))-1/298.15)))
vqhs3 s3_th s3_tn DC 0
rs3_rs s3_s 0 100000
rs3_ravg s3_s s3_m 2e+06
cs3_cavg s3_m 0 1e-06
ns3_mpor s3_m por_ok s3_s vsrc pch W=4e-06 L=1e-06
rs3_ab vdd s3_anb 750000
ns3_amb s3_anb s3_anb 0 0 nch W=4e-06 L=4e-06
ns3_amt s3_atl s3_anb 0 0 nch W=4e-06 L=4e-06
ns3_am1 s3_da s3_s s3_atl 0 nch W=1e-06 L=4e-06
ns3_am2 s3_db s3_m s3_atl 0 nch W=1e-06 L=4e-06
rs3_ara vdd s3_da 680000
rs3_arb vdd s3_db 680000
ns3_tt s3_tl ilim_n 0 0 nch W=4e-06 L=4e-06
ns3_ta s3_ya s3_db s3_tl 0 nch W=1e-05 L=2e-06
ns3_tb s3_yb s3_da s3_tl 0 nch W=1e-05 L=2e-06
ns3_la s3_ya s3_ya vdd vsrc pch W=4e-06 L=4e-06
ns3_lb s3_yb s3_yb vdd vsrc pch W=4e-06 L=4e-06
ns3_ca s3_za s3_ya vdd vsrc pch W=4e-06 L=4e-06
ns3_na s3_za s3_za 0 0 nch W=4e-06 L=4e-06
ns3_cb s3_zb s3_yb vdd vsrc pch W=4e-06 L=4e-06
ns3_nb s3_zb s3_zb 0 0 nch W=4e-06 L=4e-06
bs4_te s4_te 0 V=18.5
vqes4 s4_te s4_tea DC 0
rs4_ge s4_tea s4_tp 500
cs4_cp s4_tp 0 0.01
rs4_gm s4_tp s4_tn 1000
cs4_cn s4_tn 0 0.0001
bs4_ntc vdd s4_s I=V(vdd,s4_s)/(100000*exp(4250*(1/(298.15+V(s4_tn))-1/298.15)))
bs4_heat 0 s4_th I=V(vdd,s4_s)*V(vdd,s4_s)/(100000*exp(4250*(1/(298.15+V(s4_tn))-1/298.15)))
vqhs4 s4_th s4_tn DC 0
rs4_rs s4_s 0 100000
rs4_ravg s4_s s4_m 2e+06
cs4_cavg s4_m 0 1e-06
ns4_mpor s4_m por_ok s4_s vsrc pch W=4e-06 L=1e-06
rs4_ab vdd s4_anb 750000
ns4_amb s4_anb s4_anb 0 0 nch W=4e-06 L=4e-06
ns4_amt s4_atl s4_anb 0 0 nch W=4e-06 L=4e-06
ns4_am1 s4_da s4_s s4_atl 0 nch W=1e-06 L=4e-06
ns4_am2 s4_db s4_m s4_atl 0 nch W=1e-06 L=4e-06
rs4_ara vdd s4_da 680000
rs4_arb vdd s4_db 680000
ns4_tt s4_tl ilim_n 0 0 nch W=4e-06 L=4e-06
ns4_ta s4_ya s4_db s4_tl 0 nch W=1e-05 L=2e-06
ns4_tb s4_yb s4_da s4_tl 0 nch W=1e-05 L=2e-06
ns4_la s4_ya s4_ya vdd vsrc pch W=4e-06 L=4e-06
ns4_lb s4_yb s4_yb vdd vsrc pch W=4e-06 L=4e-06
ns4_ca s4_za s4_ya vdd vsrc pch W=4e-06 L=4e-06
ns4_na s4_za s4_za 0 0 nch W=4e-06 L=4e-06
ns4_cb s4_zb s4_yb vdd vsrc pch W=4e-06 L=4e-06
ns4_nb s4_zb s4_zb 0 0 nch W=4e-06 L=4e-06
cgw1_e1_cm gw1_e1_vm 0 1e-07
va_rgw1_e1_rm_n vrest rgw1_e1_rm_n 0
rgw1_e1_rm gw1_e1_vm rgw1_e1_rm_n 1e+06
ngw1_e1_bias0 gw1_e1_vm istep_n 0 0 nch W=4e-06 L=4e-06
rgw1_e1_kb vdd gw1_e1_knb 1e+06
ngw1_e1_kmb gw1_e1_knb gw1_e1_knb 0 0 nch W=4e-06 L=4e-06
ngw1_e1_kmt gw1_e1_ktail gw1_e1_knb 0 0 nch W=4e-06 L=4e-06
ngw1_e1_km1 gw1_e1_kd1 gw1_e1_vm gw1_e1_ktail 0 nch W=4e-06 L=4e-06
ngw1_e1_km2 gw1_e1_ko1 gw1_e1_h gw1_e1_ktail 0 nch W=4e-06 L=4e-06
ngw1_e1_km3 gw1_e1_kd1 gw1_e1_kd1 vdd vsrc pch W=4e-06 L=4e-06
ngw1_e1_km4 gw1_e1_ko1 gw1_e1_kd1 vdd vsrc pch W=4e-06 L=4e-06
ngw1_e1_kporclamp gw1_e1_ko1 por_hold 0 0 nch W=4e-06 L=1e-06
ngw1_e1_ki1p gw1_e1_qb gw1_e1_ko1 vdd vsrc pch W=2.4e-06 L=5e-07
ngw1_e1_ki1n gw1_e1_qb gw1_e1_ko1 0 0 nch W=1.2e-06 L=5e-07
ngw1_e1_ki2p gw1_e1_q gw1_e1_qb vdd vsrc pch W=2.4e-06 L=5e-07
ngw1_e1_ki2n gw1_e1_q gw1_e1_qb 0 0 nch W=1.2e-06 L=5e-07
rgw1_e1_hra gw1_e1_h vthe 1e+06
rgw1_e1_hrf gw1_e1_h gw1_e1_qb 1.9e+07
cgw1_e1_hc gw1_e1_h 0 2.1e-09
ngw1_e1_dis gw1_e1_vm gw1_e1_q gw1_e1_vmd 0 nch W=4e-06 L=1e-06
va_rgw1_e1_rdis_n vrest rgw1_e1_rdis_n 0
rgw1_e1_rdis gw1_e1_vmd rgw1_e1_rdis_n 220000
ngw1_e1_rp gw1_e1_rt gw1_e1_qb vdd vsrc pch W=2e-06 L=1e-06
rgw1_e1_rrc gw1_e1_rt gw1_e1_rec 10000
cgw1_e1_rc gw1_e1_rec 0 1e-07
rgw1_e1_rr gw1_e1_rec 0 8.2e+06
ngw1_e1_sh1 gw1_e1_vm gw1_e1_rec gw1_e1_vms 0 nch W=2e-06 L=1e-06
va_ngw1_e1_sh2_s vrest ngw1_e1_sh2_s 0
ngw1_e1_sh2 gw1_e1_vms gw1_e1_qb ngw1_e1_sh2_s 0 nch W=2e-06 L=1e-06
ngw1_e1_porh gw1_e1_h por_hold vthe 0 nch W=2e-06 L=1e-06
va_ngw1_e1_porm_s vrest ngw1_e1_porm_s 0
ngw1_e1_porm gw1_e1_vm por_hold ngw1_e1_porm_s 0 nch W=2e-06 L=1e-06
ngw1_e1_ip gw1_e1_vm s1_ya vdd vsrc pch W=4e-06 L=4e-06
ngw1_e1_in gw1_e1_vm s1_zb 0 0 nch W=4e-06 L=4e-06
ngw1_b1_sw gw1_b1_t gw1_e1_qb vdd vsrc pch W=2e-06 L=1e-06
rgw1_b1_rc gw1_b1_t gw1_b1 10000
cgw1_b1_c gw1_b1 0 1e-07
rgw1_b1_rl gw1_b1 0 2.2e+07
ngw1_b1_sh1p gw1_b1_n gw1_b1 vdd vsrc pch W=2.4e-06 L=5e-07
ngw1_b1_sh1n gw1_b1_n gw1_b1 0 0 nch W=1.2e-06 L=5e-07
ngw1_b1_sh2p gw1_b1_q gw1_b1_n vdd vsrc pch W=2.4e-06 L=5e-07
ngw1_b1_sh2n gw1_b1_q gw1_b1_n 0 0 nch W=1.2e-06 L=5e-07
cgw1_e2_cm gw1_e2_vm 0 1e-07
va_rgw1_e2_rm_n vrest rgw1_e2_rm_n 0
rgw1_e2_rm gw1_e2_vm rgw1_e2_rm_n 1e+06
ngw1_e2_bias0 gw1_e2_vm istep_n 0 0 nch W=4e-06 L=4e-06
ngw1_e2_bias1 gw1_e2_vm istep_n 0 0 nch W=4e-06 L=4e-06
rgw1_e2_kb vdd gw1_e2_knb 1e+06
ngw1_e2_kmb gw1_e2_knb gw1_e2_knb 0 0 nch W=4e-06 L=4e-06
ngw1_e2_kmt gw1_e2_ktail gw1_e2_knb 0 0 nch W=4e-06 L=4e-06
ngw1_e2_km1 gw1_e2_kd1 gw1_e2_vm gw1_e2_ktail 0 nch W=4e-06 L=4e-06
ngw1_e2_km2 gw1_e2_ko1 gw1_e2_h gw1_e2_ktail 0 nch W=4e-06 L=4e-06
ngw1_e2_km3 gw1_e2_kd1 gw1_e2_kd1 vdd vsrc pch W=4e-06 L=4e-06
ngw1_e2_km4 gw1_e2_ko1 gw1_e2_kd1 vdd vsrc pch W=4e-06 L=4e-06
ngw1_e2_kporclamp gw1_e2_ko1 por_hold 0 0 nch W=4e-06 L=1e-06
ngw1_e2_ki1p gw1_e2_qb gw1_e2_ko1 vdd vsrc pch W=2.4e-06 L=5e-07
ngw1_e2_ki1n gw1_e2_qb gw1_e2_ko1 0 0 nch W=1.2e-06 L=5e-07
ngw1_e2_ki2p gw1_e2_q gw1_e2_qb vdd vsrc pch W=2.4e-06 L=5e-07
ngw1_e2_ki2n gw1_e2_q gw1_e2_qb 0 0 nch W=1.2e-06 L=5e-07
rgw1_e2_hra gw1_e2_h vthe 1e+06
rgw1_e2_hrf gw1_e2_h gw1_e2_qb 1.9e+07
cgw1_e2_hc gw1_e2_h 0 2.1e-09
ngw1_e2_dis gw1_e2_vm gw1_e2_q gw1_e2_vmd 0 nch W=4e-06 L=1e-06
va_rgw1_e2_rdis_n vrest rgw1_e2_rdis_n 0
rgw1_e2_rdis gw1_e2_vmd rgw1_e2_rdis_n 220000
ngw1_e2_rp gw1_e2_rt gw1_e2_qb vdd vsrc pch W=2e-06 L=1e-06
rgw1_e2_rrc gw1_e2_rt gw1_e2_rec 10000
cgw1_e2_rc gw1_e2_rec 0 1e-07
rgw1_e2_rr gw1_e2_rec 0 8.2e+06
ngw1_e2_sh1 gw1_e2_vm gw1_e2_rec gw1_e2_vms 0 nch W=2e-06 L=1e-06
va_ngw1_e2_sh2_s vrest ngw1_e2_sh2_s 0
ngw1_e2_sh2 gw1_e2_vms gw1_e2_qb ngw1_e2_sh2_s 0 nch W=2e-06 L=1e-06
ngw1_e2_porh gw1_e2_h por_hold vthe 0 nch W=2e-06 L=1e-06
va_ngw1_e2_porm_s vrest ngw1_e2_porm_s 0
ngw1_e2_porm gw1_e2_vm por_hold ngw1_e2_porm_s 0 nch W=2e-06 L=1e-06
ngw1_e2_ip gw1_e2_vm s1_ya vdd vsrc pch W=4e-06 L=4e-06
ngw1_e2_in gw1_e2_vm s1_zb 0 0 nch W=4e-06 L=4e-06
ngw1_b2_sw gw1_b2_t gw1_e2_qb vdd vsrc pch W=2e-06 L=1e-06
rgw1_b2_rc gw1_b2_t gw1_b2 10000
cgw1_b2_c gw1_b2 0 1e-07
rgw1_b2_rl gw1_b2 0 2.2e+07
ngw1_b2_sh1p gw1_b2_n gw1_b2 vdd vsrc pch W=2.4e-06 L=5e-07
ngw1_b2_sh1n gw1_b2_n gw1_b2 0 0 nch W=1.2e-06 L=5e-07
ngw1_b2_sh2p gw1_b2_q gw1_b2_n vdd vsrc pch W=2.4e-06 L=5e-07
ngw1_b2_sh2n gw1_b2_q gw1_b2_n 0 0 nch W=1.2e-06 L=5e-07
cgw1_e3_cm gw1_e3_vm 0 1e-07
va_rgw1_e3_rm_n vrest rgw1_e3_rm_n 0
rgw1_e3_rm gw1_e3_vm rgw1_e3_rm_n 1e+06
ngw1_e3_bias0 gw1_e3_vm istep_n 0 0 nch W=4e-06 L=4e-06
ngw1_e3_bias1 gw1_e3_vm istep_n 0 0 nch W=4e-06 L=4e-06
ngw1_e3_bias2 gw1_e3_vm istep_n 0 0 nch W=4e-06 L=4e-06
rgw1_e3_kb vdd gw1_e3_knb 1e+06
ngw1_e3_kmb gw1_e3_knb gw1_e3_knb 0 0 nch W=4e-06 L=4e-06
ngw1_e3_kmt gw1_e3_ktail gw1_e3_knb 0 0 nch W=4e-06 L=4e-06
ngw1_e3_km1 gw1_e3_kd1 gw1_e3_vm gw1_e3_ktail 0 nch W=4e-06 L=4e-06
ngw1_e3_km2 gw1_e3_ko1 gw1_e3_h gw1_e3_ktail 0 nch W=4e-06 L=4e-06
ngw1_e3_km3 gw1_e3_kd1 gw1_e3_kd1 vdd vsrc pch W=4e-06 L=4e-06
ngw1_e3_km4 gw1_e3_ko1 gw1_e3_kd1 vdd vsrc pch W=4e-06 L=4e-06
ngw1_e3_kporclamp gw1_e3_ko1 por_hold 0 0 nch W=4e-06 L=1e-06
ngw1_e3_ki1p gw1_e3_qb gw1_e3_ko1 vdd vsrc pch W=2.4e-06 L=5e-07
ngw1_e3_ki1n gw1_e3_qb gw1_e3_ko1 0 0 nch W=1.2e-06 L=5e-07
ngw1_e3_ki2p gw1_e3_q gw1_e3_qb vdd vsrc pch W=2.4e-06 L=5e-07
ngw1_e3_ki2n gw1_e3_q gw1_e3_qb 0 0 nch W=1.2e-06 L=5e-07
rgw1_e3_hra gw1_e3_h vthe 1e+06
rgw1_e3_hrf gw1_e3_h gw1_e3_qb 1.9e+07
cgw1_e3_hc gw1_e3_h 0 2.1e-09
ngw1_e3_dis gw1_e3_vm gw1_e3_q gw1_e3_vmd 0 nch W=4e-06 L=1e-06
va_rgw1_e3_rdis_n vrest rgw1_e3_rdis_n 0
rgw1_e3_rdis gw1_e3_vmd rgw1_e3_rdis_n 220000
ngw1_e3_rp gw1_e3_rt gw1_e3_qb vdd vsrc pch W=2e-06 L=1e-06
rgw1_e3_rrc gw1_e3_rt gw1_e3_rec 10000
cgw1_e3_rc gw1_e3_rec 0 1e-07
rgw1_e3_rr gw1_e3_rec 0 8.2e+06
ngw1_e3_sh1 gw1_e3_vm gw1_e3_rec gw1_e3_vms 0 nch W=2e-06 L=1e-06
va_ngw1_e3_sh2_s vrest ngw1_e3_sh2_s 0
ngw1_e3_sh2 gw1_e3_vms gw1_e3_qb ngw1_e3_sh2_s 0 nch W=2e-06 L=1e-06
ngw1_e3_porh gw1_e3_h por_hold vthe 0 nch W=2e-06 L=1e-06
va_ngw1_e3_porm_s vrest ngw1_e3_porm_s 0
ngw1_e3_porm gw1_e3_vm por_hold ngw1_e3_porm_s 0 nch W=2e-06 L=1e-06
ngw1_e3_ip gw1_e3_vm s1_ya vdd vsrc pch W=4e-06 L=4e-06
ngw1_e3_in gw1_e3_vm s1_zb 0 0 nch W=4e-06 L=4e-06
ngw1_b3_sw gw1_b3_t gw1_e3_qb vdd vsrc pch W=2e-06 L=1e-06
rgw1_b3_rc gw1_b3_t gw1_b3 10000
cgw1_b3_c gw1_b3 0 1e-07
rgw1_b3_rl gw1_b3 0 2.2e+07
ngw1_b3_sh1p gw1_b3_n gw1_b3 vdd vsrc pch W=2.4e-06 L=5e-07
ngw1_b3_sh1n gw1_b3_n gw1_b3 0 0 nch W=1.2e-06 L=5e-07
ngw1_b3_sh2p gw1_b3_q gw1_b3_n vdd vsrc pch W=2.4e-06 L=5e-07
ngw1_b3_sh2n gw1_b3_q gw1_b3_n 0 0 nch W=1.2e-06 L=5e-07
cgw1_e4_cm gw1_e4_vm 0 1e-07
va_rgw1_e4_rm_n vrest rgw1_e4_rm_n 0
rgw1_e4_rm gw1_e4_vm rgw1_e4_rm_n 1e+06
ngw1_e4_bias0 gw1_e4_vm istep_n 0 0 nch W=4e-06 L=4e-06
ngw1_e4_bias1 gw1_e4_vm istep_n 0 0 nch W=4e-06 L=4e-06
ngw1_e4_bias2 gw1_e4_vm istep_n 0 0 nch W=4e-06 L=4e-06
ngw1_e4_bias3 gw1_e4_vm istep_n 0 0 nch W=4e-06 L=4e-06
rgw1_e4_kb vdd gw1_e4_knb 1e+06
ngw1_e4_kmb gw1_e4_knb gw1_e4_knb 0 0 nch W=4e-06 L=4e-06
ngw1_e4_kmt gw1_e4_ktail gw1_e4_knb 0 0 nch W=4e-06 L=4e-06
ngw1_e4_km1 gw1_e4_kd1 gw1_e4_vm gw1_e4_ktail 0 nch W=4e-06 L=4e-06
ngw1_e4_km2 gw1_e4_ko1 gw1_e4_h gw1_e4_ktail 0 nch W=4e-06 L=4e-06
ngw1_e4_km3 gw1_e4_kd1 gw1_e4_kd1 vdd vsrc pch W=4e-06 L=4e-06
ngw1_e4_km4 gw1_e4_ko1 gw1_e4_kd1 vdd vsrc pch W=4e-06 L=4e-06
ngw1_e4_kporclamp gw1_e4_ko1 por_hold 0 0 nch W=4e-06 L=1e-06
ngw1_e4_ki1p gw1_e4_qb gw1_e4_ko1 vdd vsrc pch W=2.4e-06 L=5e-07
ngw1_e4_ki1n gw1_e4_qb gw1_e4_ko1 0 0 nch W=1.2e-06 L=5e-07
ngw1_e4_ki2p gw1_e4_q gw1_e4_qb vdd vsrc pch W=2.4e-06 L=5e-07
ngw1_e4_ki2n gw1_e4_q gw1_e4_qb 0 0 nch W=1.2e-06 L=5e-07
rgw1_e4_hra gw1_e4_h vthe 1e+06
rgw1_e4_hrf gw1_e4_h gw1_e4_qb 1.9e+07
cgw1_e4_hc gw1_e4_h 0 2.1e-09
ngw1_e4_dis gw1_e4_vm gw1_e4_q gw1_e4_vmd 0 nch W=4e-06 L=1e-06
va_rgw1_e4_rdis_n vrest rgw1_e4_rdis_n 0
rgw1_e4_rdis gw1_e4_vmd rgw1_e4_rdis_n 220000
ngw1_e4_rp gw1_e4_rt gw1_e4_qb vdd vsrc pch W=2e-06 L=1e-06
rgw1_e4_rrc gw1_e4_rt gw1_e4_rec 10000
cgw1_e4_rc gw1_e4_rec 0 1e-07
rgw1_e4_rr gw1_e4_rec 0 8.2e+06
ngw1_e4_sh1 gw1_e4_vm gw1_e4_rec gw1_e4_vms 0 nch W=2e-06 L=1e-06
va_ngw1_e4_sh2_s vrest ngw1_e4_sh2_s 0
ngw1_e4_sh2 gw1_e4_vms gw1_e4_qb ngw1_e4_sh2_s 0 nch W=2e-06 L=1e-06
ngw1_e4_porh gw1_e4_h por_hold vthe 0 nch W=2e-06 L=1e-06
va_ngw1_e4_porm_s vrest ngw1_e4_porm_s 0
ngw1_e4_porm gw1_e4_vm por_hold ngw1_e4_porm_s 0 nch W=2e-06 L=1e-06
ngw1_e4_ip gw1_e4_vm s1_ya vdd vsrc pch W=4e-06 L=4e-06
ngw1_e4_in gw1_e4_vm s1_zb 0 0 nch W=4e-06 L=4e-06
ngw1_b4_sw gw1_b4_t gw1_e4_qb vdd vsrc pch W=2e-06 L=1e-06
rgw1_b4_rc gw1_b4_t gw1_b4 10000
cgw1_b4_c gw1_b4 0 1e-07
rgw1_b4_rl gw1_b4 0 2.2e+07
ngw1_b4_sh1p gw1_b4_n gw1_b4 vdd vsrc pch W=2.4e-06 L=5e-07
ngw1_b4_sh1n gw1_b4_n gw1_b4 0 0 nch W=1.2e-06 L=5e-07
ngw1_b4_sh2p gw1_b4_q gw1_b4_n vdd vsrc pch W=2.4e-06 L=5e-07
ngw1_b4_sh2n gw1_b4_q gw1_b4_n 0 0 nch W=1.2e-06 L=5e-07
cgw1_e5_cm gw1_e5_vm 0 1e-07
va_rgw1_e5_rm_n vrest rgw1_e5_rm_n 0
rgw1_e5_rm gw1_e5_vm rgw1_e5_rm_n 1e+06
ngw1_e5_bias0 gw1_e5_vm istep_n 0 0 nch W=4e-06 L=4e-06
ngw1_e5_bias1 gw1_e5_vm istep_n 0 0 nch W=4e-06 L=4e-06
ngw1_e5_bias2 gw1_e5_vm istep_n 0 0 nch W=4e-06 L=4e-06
ngw1_e5_bias3 gw1_e5_vm istep_n 0 0 nch W=4e-06 L=4e-06
ngw1_e5_bias4 gw1_e5_vm istep_n 0 0 nch W=4e-06 L=4e-06
rgw1_e5_kb vdd gw1_e5_knb 1e+06
ngw1_e5_kmb gw1_e5_knb gw1_e5_knb 0 0 nch W=4e-06 L=4e-06
ngw1_e5_kmt gw1_e5_ktail gw1_e5_knb 0 0 nch W=4e-06 L=4e-06
ngw1_e5_km1 gw1_e5_kd1 gw1_e5_vm gw1_e5_ktail 0 nch W=4e-06 L=4e-06
ngw1_e5_km2 gw1_e5_ko1 gw1_e5_h gw1_e5_ktail 0 nch W=4e-06 L=4e-06
ngw1_e5_km3 gw1_e5_kd1 gw1_e5_kd1 vdd vsrc pch W=4e-06 L=4e-06
ngw1_e5_km4 gw1_e5_ko1 gw1_e5_kd1 vdd vsrc pch W=4e-06 L=4e-06
ngw1_e5_kporclamp gw1_e5_ko1 por_hold 0 0 nch W=4e-06 L=1e-06
ngw1_e5_ki1p gw1_e5_qb gw1_e5_ko1 vdd vsrc pch W=2.4e-06 L=5e-07
ngw1_e5_ki1n gw1_e5_qb gw1_e5_ko1 0 0 nch W=1.2e-06 L=5e-07
ngw1_e5_ki2p gw1_e5_q gw1_e5_qb vdd vsrc pch W=2.4e-06 L=5e-07
ngw1_e5_ki2n gw1_e5_q gw1_e5_qb 0 0 nch W=1.2e-06 L=5e-07
rgw1_e5_hra gw1_e5_h vthe 1e+06
rgw1_e5_hrf gw1_e5_h gw1_e5_qb 1.9e+07
cgw1_e5_hc gw1_e5_h 0 2.1e-09
ngw1_e5_dis gw1_e5_vm gw1_e5_q gw1_e5_vmd 0 nch W=4e-06 L=1e-06
va_rgw1_e5_rdis_n vrest rgw1_e5_rdis_n 0
rgw1_e5_rdis gw1_e5_vmd rgw1_e5_rdis_n 220000
ngw1_e5_rp gw1_e5_rt gw1_e5_qb vdd vsrc pch W=2e-06 L=1e-06
rgw1_e5_rrc gw1_e5_rt gw1_e5_rec 10000
cgw1_e5_rc gw1_e5_rec 0 1e-07
rgw1_e5_rr gw1_e5_rec 0 8.2e+06
ngw1_e5_sh1 gw1_e5_vm gw1_e5_rec gw1_e5_vms 0 nch W=2e-06 L=1e-06
va_ngw1_e5_sh2_s vrest ngw1_e5_sh2_s 0
ngw1_e5_sh2 gw1_e5_vms gw1_e5_qb ngw1_e5_sh2_s 0 nch W=2e-06 L=1e-06
ngw1_e5_porh gw1_e5_h por_hold vthe 0 nch W=2e-06 L=1e-06
va_ngw1_e5_porm_s vrest ngw1_e5_porm_s 0
ngw1_e5_porm gw1_e5_vm por_hold ngw1_e5_porm_s 0 nch W=2e-06 L=1e-06
ngw1_e5_ip gw1_e5_vm s1_ya vdd vsrc pch W=4e-06 L=4e-06
ngw1_e5_in gw1_e5_vm s1_zb 0 0 nch W=4e-06 L=4e-06
ngw1_b5_sw gw1_b5_t gw1_e5_qb vdd vsrc pch W=2e-06 L=1e-06
rgw1_b5_rc gw1_b5_t gw1_b5 10000
cgw1_b5_c gw1_b5 0 1e-07
rgw1_b5_rl gw1_b5 0 2.2e+07
ngw1_b5_sh1p gw1_b5_n gw1_b5 vdd vsrc pch W=2.4e-06 L=5e-07
ngw1_b5_sh1n gw1_b5_n gw1_b5 0 0 nch W=1.2e-06 L=5e-07
ngw1_b5_sh2p gw1_b5_q gw1_b5_n vdd vsrc pch W=2.4e-06 L=5e-07
ngw1_b5_sh2n gw1_b5_q gw1_b5_n 0 0 nch W=1.2e-06 L=5e-07
cgw1_e6_cm gw1_e6_vm 0 1e-07
va_rgw1_e6_rm_n vrest rgw1_e6_rm_n 0
rgw1_e6_rm gw1_e6_vm rgw1_e6_rm_n 1e+06
ngw1_e6_bias0 gw1_e6_vm istep_n 0 0 nch W=4e-06 L=4e-06
ngw1_e6_bias1 gw1_e6_vm istep_n 0 0 nch W=4e-06 L=4e-06
ngw1_e6_bias2 gw1_e6_vm istep_n 0 0 nch W=4e-06 L=4e-06
ngw1_e6_bias3 gw1_e6_vm istep_n 0 0 nch W=4e-06 L=4e-06
ngw1_e6_bias4 gw1_e6_vm istep_n 0 0 nch W=4e-06 L=4e-06
ngw1_e6_bias5 gw1_e6_vm istep_n 0 0 nch W=4e-06 L=4e-06
rgw1_e6_kb vdd gw1_e6_knb 1e+06
ngw1_e6_kmb gw1_e6_knb gw1_e6_knb 0 0 nch W=4e-06 L=4e-06
ngw1_e6_kmt gw1_e6_ktail gw1_e6_knb 0 0 nch W=4e-06 L=4e-06
ngw1_e6_km1 gw1_e6_kd1 gw1_e6_vm gw1_e6_ktail 0 nch W=4e-06 L=4e-06
ngw1_e6_km2 gw1_e6_ko1 gw1_e6_h gw1_e6_ktail 0 nch W=4e-06 L=4e-06
ngw1_e6_km3 gw1_e6_kd1 gw1_e6_kd1 vdd vsrc pch W=4e-06 L=4e-06
ngw1_e6_km4 gw1_e6_ko1 gw1_e6_kd1 vdd vsrc pch W=4e-06 L=4e-06
ngw1_e6_kporclamp gw1_e6_ko1 por_hold 0 0 nch W=4e-06 L=1e-06
ngw1_e6_ki1p gw1_e6_qb gw1_e6_ko1 vdd vsrc pch W=2.4e-06 L=5e-07
ngw1_e6_ki1n gw1_e6_qb gw1_e6_ko1 0 0 nch W=1.2e-06 L=5e-07
ngw1_e6_ki2p gw1_e6_q gw1_e6_qb vdd vsrc pch W=2.4e-06 L=5e-07
ngw1_e6_ki2n gw1_e6_q gw1_e6_qb 0 0 nch W=1.2e-06 L=5e-07
rgw1_e6_hra gw1_e6_h vthe 1e+06
rgw1_e6_hrf gw1_e6_h gw1_e6_qb 1.9e+07
cgw1_e6_hc gw1_e6_h 0 2.1e-09
ngw1_e6_dis gw1_e6_vm gw1_e6_q gw1_e6_vmd 0 nch W=4e-06 L=1e-06
va_rgw1_e6_rdis_n vrest rgw1_e6_rdis_n 0
rgw1_e6_rdis gw1_e6_vmd rgw1_e6_rdis_n 220000
ngw1_e6_rp gw1_e6_rt gw1_e6_qb vdd vsrc pch W=2e-06 L=1e-06
rgw1_e6_rrc gw1_e6_rt gw1_e6_rec 10000
cgw1_e6_rc gw1_e6_rec 0 1e-07
rgw1_e6_rr gw1_e6_rec 0 8.2e+06
ngw1_e6_sh1 gw1_e6_vm gw1_e6_rec gw1_e6_vms 0 nch W=2e-06 L=1e-06
va_ngw1_e6_sh2_s vrest ngw1_e6_sh2_s 0
ngw1_e6_sh2 gw1_e6_vms gw1_e6_qb ngw1_e6_sh2_s 0 nch W=2e-06 L=1e-06
ngw1_e6_porh gw1_e6_h por_hold vthe 0 nch W=2e-06 L=1e-06
va_ngw1_e6_porm_s vrest ngw1_e6_porm_s 0
ngw1_e6_porm gw1_e6_vm por_hold ngw1_e6_porm_s 0 nch W=2e-06 L=1e-06
ngw1_e6_ip gw1_e6_vm s1_ya vdd vsrc pch W=4e-06 L=4e-06
ngw1_e6_in gw1_e6_vm s1_zb 0 0 nch W=4e-06 L=4e-06
ngw1_b6_sw gw1_b6_t gw1_e6_qb vdd vsrc pch W=2e-06 L=1e-06
rgw1_b6_rc gw1_b6_t gw1_b6 10000
cgw1_b6_c gw1_b6 0 1e-07
rgw1_b6_rl gw1_b6 0 2.2e+07
ngw1_b6_sh1p gw1_b6_n gw1_b6 vdd vsrc pch W=2.4e-06 L=5e-07
ngw1_b6_sh1n gw1_b6_n gw1_b6 0 0 nch W=1.2e-06 L=5e-07
ngw1_b6_sh2p gw1_b6_q gw1_b6_n vdd vsrc pch W=2.4e-06 L=5e-07
ngw1_b6_sh2n gw1_b6_q gw1_b6_n 0 0 nch W=1.2e-06 L=5e-07
cgw1_e7_cm gw1_e7_vm 0 1e-07
va_rgw1_e7_rm_n vrest rgw1_e7_rm_n 0
rgw1_e7_rm gw1_e7_vm rgw1_e7_rm_n 1e+06
ngw1_e7_bias0 gw1_e7_vm istep_n 0 0 nch W=4e-06 L=4e-06
ngw1_e7_bias1 gw1_e7_vm istep_n 0 0 nch W=4e-06 L=4e-06
ngw1_e7_bias2 gw1_e7_vm istep_n 0 0 nch W=4e-06 L=4e-06
ngw1_e7_bias3 gw1_e7_vm istep_n 0 0 nch W=4e-06 L=4e-06
ngw1_e7_bias4 gw1_e7_vm istep_n 0 0 nch W=4e-06 L=4e-06
ngw1_e7_bias5 gw1_e7_vm istep_n 0 0 nch W=4e-06 L=4e-06
ngw1_e7_bias6 gw1_e7_vm istep_n 0 0 nch W=4e-06 L=4e-06
rgw1_e7_kb vdd gw1_e7_knb 1e+06
ngw1_e7_kmb gw1_e7_knb gw1_e7_knb 0 0 nch W=4e-06 L=4e-06
ngw1_e7_kmt gw1_e7_ktail gw1_e7_knb 0 0 nch W=4e-06 L=4e-06
ngw1_e7_km1 gw1_e7_kd1 gw1_e7_vm gw1_e7_ktail 0 nch W=4e-06 L=4e-06
ngw1_e7_km2 gw1_e7_ko1 gw1_e7_h gw1_e7_ktail 0 nch W=4e-06 L=4e-06
ngw1_e7_km3 gw1_e7_kd1 gw1_e7_kd1 vdd vsrc pch W=4e-06 L=4e-06
ngw1_e7_km4 gw1_e7_ko1 gw1_e7_kd1 vdd vsrc pch W=4e-06 L=4e-06
ngw1_e7_kporclamp gw1_e7_ko1 por_hold 0 0 nch W=4e-06 L=1e-06
ngw1_e7_ki1p gw1_e7_qb gw1_e7_ko1 vdd vsrc pch W=2.4e-06 L=5e-07
ngw1_e7_ki1n gw1_e7_qb gw1_e7_ko1 0 0 nch W=1.2e-06 L=5e-07
ngw1_e7_ki2p gw1_e7_q gw1_e7_qb vdd vsrc pch W=2.4e-06 L=5e-07
ngw1_e7_ki2n gw1_e7_q gw1_e7_qb 0 0 nch W=1.2e-06 L=5e-07
rgw1_e7_hra gw1_e7_h vthe 1e+06
rgw1_e7_hrf gw1_e7_h gw1_e7_qb 1.9e+07
cgw1_e7_hc gw1_e7_h 0 2.1e-09
ngw1_e7_dis gw1_e7_vm gw1_e7_q gw1_e7_vmd 0 nch W=4e-06 L=1e-06
va_rgw1_e7_rdis_n vrest rgw1_e7_rdis_n 0
rgw1_e7_rdis gw1_e7_vmd rgw1_e7_rdis_n 220000
ngw1_e7_rp gw1_e7_rt gw1_e7_qb vdd vsrc pch W=2e-06 L=1e-06
rgw1_e7_rrc gw1_e7_rt gw1_e7_rec 10000
cgw1_e7_rc gw1_e7_rec 0 1e-07
rgw1_e7_rr gw1_e7_rec 0 8.2e+06
ngw1_e7_sh1 gw1_e7_vm gw1_e7_rec gw1_e7_vms 0 nch W=2e-06 L=1e-06
va_ngw1_e7_sh2_s vrest ngw1_e7_sh2_s 0
ngw1_e7_sh2 gw1_e7_vms gw1_e7_qb ngw1_e7_sh2_s 0 nch W=2e-06 L=1e-06
ngw1_e7_porh gw1_e7_h por_hold vthe 0 nch W=2e-06 L=1e-06
va_ngw1_e7_porm_s vrest ngw1_e7_porm_s 0
ngw1_e7_porm gw1_e7_vm por_hold ngw1_e7_porm_s 0 nch W=2e-06 L=1e-06
ngw1_e7_ip gw1_e7_vm s1_ya vdd vsrc pch W=4e-06 L=4e-06
ngw1_e7_in gw1_e7_vm s1_zb 0 0 nch W=4e-06 L=4e-06
ngw1_b7_sw gw1_b7_t gw1_e7_qb vdd vsrc pch W=2e-06 L=1e-06
rgw1_b7_rc gw1_b7_t gw1_b7 10000
cgw1_b7_c gw1_b7 0 1e-07
rgw1_b7_rl gw1_b7 0 2.2e+07
ngw1_b7_sh1p gw1_b7_n gw1_b7 vdd vsrc pch W=2.4e-06 L=5e-07
ngw1_b7_sh1n gw1_b7_n gw1_b7 0 0 nch W=1.2e-06 L=5e-07
ngw1_b7_sh2p gw1_b7_q gw1_b7_n vdd vsrc pch W=2.4e-06 L=5e-07
ngw1_b7_sh2n gw1_b7_q gw1_b7_n 0 0 nch W=1.2e-06 L=5e-07
cgw1_e8_cm gw1_e8_vm 0 1e-07
va_rgw1_e8_rm_n vrest rgw1_e8_rm_n 0
rgw1_e8_rm gw1_e8_vm rgw1_e8_rm_n 1e+06
ngw1_e8_bias0 gw1_e8_vm istep_n 0 0 nch W=4e-06 L=4e-06
ngw1_e8_bias1 gw1_e8_vm istep_n 0 0 nch W=4e-06 L=4e-06
ngw1_e8_bias2 gw1_e8_vm istep_n 0 0 nch W=4e-06 L=4e-06
ngw1_e8_bias3 gw1_e8_vm istep_n 0 0 nch W=4e-06 L=4e-06
ngw1_e8_bias4 gw1_e8_vm istep_n 0 0 nch W=4e-06 L=4e-06
ngw1_e8_bias5 gw1_e8_vm istep_n 0 0 nch W=4e-06 L=4e-06
ngw1_e8_bias6 gw1_e8_vm istep_n 0 0 nch W=4e-06 L=4e-06
ngw1_e8_bias7 gw1_e8_vm istep_n 0 0 nch W=4e-06 L=4e-06
rgw1_e8_kb vdd gw1_e8_knb 1e+06
ngw1_e8_kmb gw1_e8_knb gw1_e8_knb 0 0 nch W=4e-06 L=4e-06
ngw1_e8_kmt gw1_e8_ktail gw1_e8_knb 0 0 nch W=4e-06 L=4e-06
ngw1_e8_km1 gw1_e8_kd1 gw1_e8_vm gw1_e8_ktail 0 nch W=4e-06 L=4e-06
ngw1_e8_km2 gw1_e8_ko1 gw1_e8_h gw1_e8_ktail 0 nch W=4e-06 L=4e-06
ngw1_e8_km3 gw1_e8_kd1 gw1_e8_kd1 vdd vsrc pch W=4e-06 L=4e-06
ngw1_e8_km4 gw1_e8_ko1 gw1_e8_kd1 vdd vsrc pch W=4e-06 L=4e-06
ngw1_e8_kporclamp gw1_e8_ko1 por_hold 0 0 nch W=4e-06 L=1e-06
ngw1_e8_ki1p gw1_e8_qb gw1_e8_ko1 vdd vsrc pch W=2.4e-06 L=5e-07
ngw1_e8_ki1n gw1_e8_qb gw1_e8_ko1 0 0 nch W=1.2e-06 L=5e-07
ngw1_e8_ki2p gw1_e8_q gw1_e8_qb vdd vsrc pch W=2.4e-06 L=5e-07
ngw1_e8_ki2n gw1_e8_q gw1_e8_qb 0 0 nch W=1.2e-06 L=5e-07
rgw1_e8_hra gw1_e8_h vthe 1e+06
rgw1_e8_hrf gw1_e8_h gw1_e8_qb 1.9e+07
cgw1_e8_hc gw1_e8_h 0 2.1e-09
ngw1_e8_dis gw1_e8_vm gw1_e8_q gw1_e8_vmd 0 nch W=4e-06 L=1e-06
va_rgw1_e8_rdis_n vrest rgw1_e8_rdis_n 0
rgw1_e8_rdis gw1_e8_vmd rgw1_e8_rdis_n 220000
ngw1_e8_rp gw1_e8_rt gw1_e8_qb vdd vsrc pch W=2e-06 L=1e-06
rgw1_e8_rrc gw1_e8_rt gw1_e8_rec 10000
cgw1_e8_rc gw1_e8_rec 0 1e-07
rgw1_e8_rr gw1_e8_rec 0 8.2e+06
ngw1_e8_sh1 gw1_e8_vm gw1_e8_rec gw1_e8_vms 0 nch W=2e-06 L=1e-06
va_ngw1_e8_sh2_s vrest ngw1_e8_sh2_s 0
ngw1_e8_sh2 gw1_e8_vms gw1_e8_qb ngw1_e8_sh2_s 0 nch W=2e-06 L=1e-06
ngw1_e8_porh gw1_e8_h por_hold vthe 0 nch W=2e-06 L=1e-06
va_ngw1_e8_porm_s vrest ngw1_e8_porm_s 0
ngw1_e8_porm gw1_e8_vm por_hold ngw1_e8_porm_s 0 nch W=2e-06 L=1e-06
ngw1_e8_ip gw1_e8_vm s1_ya vdd vsrc pch W=4e-06 L=4e-06
ngw1_e8_in gw1_e8_vm s1_zb 0 0 nch W=4e-06 L=4e-06
ngw1_b8_sw gw1_b8_t gw1_e8_qb vdd vsrc pch W=2e-06 L=1e-06
rgw1_b8_rc gw1_b8_t gw1_b8 10000
cgw1_b8_c gw1_b8 0 1e-07
rgw1_b8_rl gw1_b8 0 2.2e+07
ngw1_b8_sh1p gw1_b8_n gw1_b8 vdd vsrc pch W=2.4e-06 L=5e-07
ngw1_b8_sh1n gw1_b8_n gw1_b8 0 0 nch W=1.2e-06 L=5e-07
ngw1_b8_sh2p gw1_b8_q gw1_b8_n vdd vsrc pch W=2.4e-06 L=5e-07
ngw1_b8_sh2n gw1_b8_q gw1_b8_n 0 0 nch W=1.2e-06 L=5e-07
cgw1_e9_cm gw1_e9_vm 0 1e-07
va_rgw1_e9_rm_n vrest rgw1_e9_rm_n 0
rgw1_e9_rm gw1_e9_vm rgw1_e9_rm_n 1e+06
ngw1_e9_bias0 gw1_e9_vm istep_n 0 0 nch W=4e-06 L=4e-06
ngw1_e9_bias1 gw1_e9_vm istep_n 0 0 nch W=4e-06 L=4e-06
ngw1_e9_bias2 gw1_e9_vm istep_n 0 0 nch W=4e-06 L=4e-06
ngw1_e9_bias3 gw1_e9_vm istep_n 0 0 nch W=4e-06 L=4e-06
ngw1_e9_bias4 gw1_e9_vm istep_n 0 0 nch W=4e-06 L=4e-06
ngw1_e9_bias5 gw1_e9_vm istep_n 0 0 nch W=4e-06 L=4e-06
ngw1_e9_bias6 gw1_e9_vm istep_n 0 0 nch W=4e-06 L=4e-06
ngw1_e9_bias7 gw1_e9_vm istep_n 0 0 nch W=4e-06 L=4e-06
ngw1_e9_bias8 gw1_e9_vm istep_n 0 0 nch W=4e-06 L=4e-06
rgw1_e9_kb vdd gw1_e9_knb 1e+06
ngw1_e9_kmb gw1_e9_knb gw1_e9_knb 0 0 nch W=4e-06 L=4e-06
ngw1_e9_kmt gw1_e9_ktail gw1_e9_knb 0 0 nch W=4e-06 L=4e-06
ngw1_e9_km1 gw1_e9_kd1 gw1_e9_vm gw1_e9_ktail 0 nch W=4e-06 L=4e-06
ngw1_e9_km2 gw1_e9_ko1 gw1_e9_h gw1_e9_ktail 0 nch W=4e-06 L=4e-06
ngw1_e9_km3 gw1_e9_kd1 gw1_e9_kd1 vdd vsrc pch W=4e-06 L=4e-06
ngw1_e9_km4 gw1_e9_ko1 gw1_e9_kd1 vdd vsrc pch W=4e-06 L=4e-06
ngw1_e9_kporclamp gw1_e9_ko1 por_hold 0 0 nch W=4e-06 L=1e-06
ngw1_e9_ki1p gw1_e9_qb gw1_e9_ko1 vdd vsrc pch W=2.4e-06 L=5e-07
ngw1_e9_ki1n gw1_e9_qb gw1_e9_ko1 0 0 nch W=1.2e-06 L=5e-07
ngw1_e9_ki2p gw1_e9_q gw1_e9_qb vdd vsrc pch W=2.4e-06 L=5e-07
ngw1_e9_ki2n gw1_e9_q gw1_e9_qb 0 0 nch W=1.2e-06 L=5e-07
rgw1_e9_hra gw1_e9_h vthe 1e+06
rgw1_e9_hrf gw1_e9_h gw1_e9_qb 1.9e+07
cgw1_e9_hc gw1_e9_h 0 2.1e-09
ngw1_e9_dis gw1_e9_vm gw1_e9_q gw1_e9_vmd 0 nch W=4e-06 L=1e-06
va_rgw1_e9_rdis_n vrest rgw1_e9_rdis_n 0
rgw1_e9_rdis gw1_e9_vmd rgw1_e9_rdis_n 220000
ngw1_e9_rp gw1_e9_rt gw1_e9_qb vdd vsrc pch W=2e-06 L=1e-06
rgw1_e9_rrc gw1_e9_rt gw1_e9_rec 10000
cgw1_e9_rc gw1_e9_rec 0 1e-07
rgw1_e9_rr gw1_e9_rec 0 8.2e+06
ngw1_e9_sh1 gw1_e9_vm gw1_e9_rec gw1_e9_vms 0 nch W=2e-06 L=1e-06
va_ngw1_e9_sh2_s vrest ngw1_e9_sh2_s 0
ngw1_e9_sh2 gw1_e9_vms gw1_e9_qb ngw1_e9_sh2_s 0 nch W=2e-06 L=1e-06
ngw1_e9_porh gw1_e9_h por_hold vthe 0 nch W=2e-06 L=1e-06
va_ngw1_e9_porm_s vrest ngw1_e9_porm_s 0
ngw1_e9_porm gw1_e9_vm por_hold ngw1_e9_porm_s 0 nch W=2e-06 L=1e-06
ngw1_e9_ip gw1_e9_vm s1_ya vdd vsrc pch W=4e-06 L=4e-06
ngw1_e9_in gw1_e9_vm s1_zb 0 0 nch W=4e-06 L=4e-06
ngw1_b9_sw gw1_b9_t gw1_e9_qb vdd vsrc pch W=2e-06 L=1e-06
rgw1_b9_rc gw1_b9_t gw1_b9 10000
cgw1_b9_c gw1_b9 0 1e-07
rgw1_b9_rl gw1_b9 0 2.2e+07
ngw1_b9_sh1p gw1_b9_n gw1_b9 vdd vsrc pch W=2.4e-06 L=5e-07
ngw1_b9_sh1n gw1_b9_n gw1_b9 0 0 nch W=1.2e-06 L=5e-07
ngw1_b9_sh2p gw1_b9_q gw1_b9_n vdd vsrc pch W=2.4e-06 L=5e-07
ngw1_b9_sh2n gw1_b9_q gw1_b9_n 0 0 nch W=1.2e-06 L=5e-07
cgw1_e10_cm gw1_e10_vm 0 1e-07
va_rgw1_e10_rm_n vrest rgw1_e10_rm_n 0
rgw1_e10_rm gw1_e10_vm rgw1_e10_rm_n 1e+06
ngw1_e10_bias0 gw1_e10_vm istep_n 0 0 nch W=4e-06 L=4e-06
ngw1_e10_bias1 gw1_e10_vm istep_n 0 0 nch W=4e-06 L=4e-06
ngw1_e10_bias2 gw1_e10_vm istep_n 0 0 nch W=4e-06 L=4e-06
ngw1_e10_bias3 gw1_e10_vm istep_n 0 0 nch W=4e-06 L=4e-06
ngw1_e10_bias4 gw1_e10_vm istep_n 0 0 nch W=4e-06 L=4e-06
ngw1_e10_bias5 gw1_e10_vm istep_n 0 0 nch W=4e-06 L=4e-06
ngw1_e10_bias6 gw1_e10_vm istep_n 0 0 nch W=4e-06 L=4e-06
ngw1_e10_bias7 gw1_e10_vm istep_n 0 0 nch W=4e-06 L=4e-06
ngw1_e10_bias8 gw1_e10_vm istep_n 0 0 nch W=4e-06 L=4e-06
ngw1_e10_bias9 gw1_e10_vm istep_n 0 0 nch W=4e-06 L=4e-06
rgw1_e10_kb vdd gw1_e10_knb 1e+06
ngw1_e10_kmb gw1_e10_knb gw1_e10_knb 0 0 nch W=4e-06 L=4e-06
ngw1_e10_kmt gw1_e10_ktail gw1_e10_knb 0 0 nch W=4e-06 L=4e-06
ngw1_e10_km1 gw1_e10_kd1 gw1_e10_vm gw1_e10_ktail 0 nch W=4e-06 L=4e-06
ngw1_e10_km2 gw1_e10_ko1 gw1_e10_h gw1_e10_ktail 0 nch W=4e-06 L=4e-06
ngw1_e10_km3 gw1_e10_kd1 gw1_e10_kd1 vdd vsrc pch W=4e-06 L=4e-06
ngw1_e10_km4 gw1_e10_ko1 gw1_e10_kd1 vdd vsrc pch W=4e-06 L=4e-06
ngw1_e10_kporclamp gw1_e10_ko1 por_hold 0 0 nch W=4e-06 L=1e-06
ngw1_e10_ki1p gw1_e10_qb gw1_e10_ko1 vdd vsrc pch W=2.4e-06 L=5e-07
ngw1_e10_ki1n gw1_e10_qb gw1_e10_ko1 0 0 nch W=1.2e-06 L=5e-07
ngw1_e10_ki2p gw1_e10_q gw1_e10_qb vdd vsrc pch W=2.4e-06 L=5e-07
ngw1_e10_ki2n gw1_e10_q gw1_e10_qb 0 0 nch W=1.2e-06 L=5e-07
rgw1_e10_hra gw1_e10_h vthe 1e+06
rgw1_e10_hrf gw1_e10_h gw1_e10_qb 1.9e+07
cgw1_e10_hc gw1_e10_h 0 2.1e-09
ngw1_e10_dis gw1_e10_vm gw1_e10_q gw1_e10_vmd 0 nch W=4e-06 L=1e-06
va_rgw1_e10_rdis_n vrest rgw1_e10_rdis_n 0
rgw1_e10_rdis gw1_e10_vmd rgw1_e10_rdis_n 220000
ngw1_e10_rp gw1_e10_rt gw1_e10_qb vdd vsrc pch W=2e-06 L=1e-06
rgw1_e10_rrc gw1_e10_rt gw1_e10_rec 10000
cgw1_e10_rc gw1_e10_rec 0 1e-07
rgw1_e10_rr gw1_e10_rec 0 8.2e+06
ngw1_e10_sh1 gw1_e10_vm gw1_e10_rec gw1_e10_vms 0 nch W=2e-06 L=1e-06
va_ngw1_e10_sh2_s vrest ngw1_e10_sh2_s 0
ngw1_e10_sh2 gw1_e10_vms gw1_e10_qb ngw1_e10_sh2_s 0 nch W=2e-06 L=1e-06
ngw1_e10_porh gw1_e10_h por_hold vthe 0 nch W=2e-06 L=1e-06
va_ngw1_e10_porm_s vrest ngw1_e10_porm_s 0
ngw1_e10_porm gw1_e10_vm por_hold ngw1_e10_porm_s 0 nch W=2e-06 L=1e-06
ngw1_e10_ip gw1_e10_vm s1_ya vdd vsrc pch W=4e-06 L=4e-06
ngw1_e10_in gw1_e10_vm s1_zb 0 0 nch W=4e-06 L=4e-06
ngw1_b10_sw gw1_b10_t gw1_e10_qb vdd vsrc pch W=2e-06 L=1e-06
rgw1_b10_rc gw1_b10_t gw1_b10 10000
cgw1_b10_c gw1_b10 0 1e-07
rgw1_b10_rl gw1_b10 0 2.2e+07
ngw1_b10_sh1p gw1_b10_n gw1_b10 vdd vsrc pch W=2.4e-06 L=5e-07
ngw1_b10_sh1n gw1_b10_n gw1_b10 0 0 nch W=1.2e-06 L=5e-07
ngw1_b10_sh2p gw1_b10_q gw1_b10_n vdd vsrc pch W=2.4e-06 L=5e-07
ngw1_b10_sh2n gw1_b10_q gw1_b10_n 0 0 nch W=1.2e-06 L=5e-07
ngw1_and_a0_npa gw1_and_a0_nb gw1_b1_q vdd vsrc pch W=2.4e-06 L=5e-07
ngw1_and_a0_npb gw1_and_a0_nb gw1_b2_q vdd vsrc pch W=2.4e-06 L=5e-07
ngw1_and_a0_nna gw1_and_a0_nb gw1_b1_q gw1_and_a0_nx 0 nch W=2.4e-06 L=5e-07
ngw1_and_a0_nnb gw1_and_a0_nx gw1_b2_q 0 0 nch W=2.4e-06 L=5e-07
ngw1_and_a0_ip gw1_and_g0 gw1_and_a0_nb vdd vsrc pch W=2.4e-06 L=5e-07
ngw1_and_a0_in gw1_and_g0 gw1_and_a0_nb 0 0 nch W=1.2e-06 L=5e-07
ngw1_and_a1_npa gw1_and_a1_nb gw1_b3_q vdd vsrc pch W=2.4e-06 L=5e-07
ngw1_and_a1_npb gw1_and_a1_nb gw1_b4_q vdd vsrc pch W=2.4e-06 L=5e-07
ngw1_and_a1_nna gw1_and_a1_nb gw1_b3_q gw1_and_a1_nx 0 nch W=2.4e-06 L=5e-07
ngw1_and_a1_nnb gw1_and_a1_nx gw1_b4_q 0 0 nch W=2.4e-06 L=5e-07
ngw1_and_a1_ip gw1_and_g1 gw1_and_a1_nb vdd vsrc pch W=2.4e-06 L=5e-07
ngw1_and_a1_in gw1_and_g1 gw1_and_a1_nb 0 0 nch W=1.2e-06 L=5e-07
ngw1_and_a2_npa gw1_and_a2_nb gw1_b5_q vdd vsrc pch W=2.4e-06 L=5e-07
ngw1_and_a2_npb gw1_and_a2_nb gw1_b6_q vdd vsrc pch W=2.4e-06 L=5e-07
ngw1_and_a2_nna gw1_and_a2_nb gw1_b5_q gw1_and_a2_nx 0 nch W=2.4e-06 L=5e-07
ngw1_and_a2_nnb gw1_and_a2_nx gw1_b6_q 0 0 nch W=2.4e-06 L=5e-07
ngw1_and_a2_ip gw1_and_g2 gw1_and_a2_nb vdd vsrc pch W=2.4e-06 L=5e-07
ngw1_and_a2_in gw1_and_g2 gw1_and_a2_nb 0 0 nch W=1.2e-06 L=5e-07
ngw1_and_a3_npa gw1_and_a3_nb gw1_b7_q vdd vsrc pch W=2.4e-06 L=5e-07
ngw1_and_a3_npb gw1_and_a3_nb gw1_b8_q vdd vsrc pch W=2.4e-06 L=5e-07
ngw1_and_a3_nna gw1_and_a3_nb gw1_b7_q gw1_and_a3_nx 0 nch W=2.4e-06 L=5e-07
ngw1_and_a3_nnb gw1_and_a3_nx gw1_b8_q 0 0 nch W=2.4e-06 L=5e-07
ngw1_and_a3_ip gw1_and_g3 gw1_and_a3_nb vdd vsrc pch W=2.4e-06 L=5e-07
ngw1_and_a3_in gw1_and_g3 gw1_and_a3_nb 0 0 nch W=1.2e-06 L=5e-07
ngw1_and_a4_npa gw1_and_a4_nb gw1_b9_q vdd vsrc pch W=2.4e-06 L=5e-07
ngw1_and_a4_npb gw1_and_a4_nb gw1_b10_q vdd vsrc pch W=2.4e-06 L=5e-07
ngw1_and_a4_nna gw1_and_a4_nb gw1_b9_q gw1_and_a4_nx 0 nch W=2.4e-06 L=5e-07
ngw1_and_a4_nnb gw1_and_a4_nx gw1_b10_q 0 0 nch W=2.4e-06 L=5e-07
ngw1_and_a4_ip gw1_and_g4 gw1_and_a4_nb vdd vsrc pch W=2.4e-06 L=5e-07
ngw1_and_a4_in gw1_and_g4 gw1_and_a4_nb 0 0 nch W=1.2e-06 L=5e-07
ngw1_and_a5_npa gw1_and_a5_nb gw1_and_g0 vdd vsrc pch W=2.4e-06 L=5e-07
ngw1_and_a5_npb gw1_and_a5_nb gw1_and_g1 vdd vsrc pch W=2.4e-06 L=5e-07
ngw1_and_a5_nna gw1_and_a5_nb gw1_and_g0 gw1_and_a5_nx 0 nch W=2.4e-06 L=5e-07
ngw1_and_a5_nnb gw1_and_a5_nx gw1_and_g1 0 0 nch W=2.4e-06 L=5e-07
ngw1_and_a5_ip gw1_and_g5 gw1_and_a5_nb vdd vsrc pch W=2.4e-06 L=5e-07
ngw1_and_a5_in gw1_and_g5 gw1_and_a5_nb 0 0 nch W=1.2e-06 L=5e-07
ngw1_and_a6_npa gw1_and_a6_nb gw1_and_g2 vdd vsrc pch W=2.4e-06 L=5e-07
ngw1_and_a6_npb gw1_and_a6_nb gw1_and_g3 vdd vsrc pch W=2.4e-06 L=5e-07
ngw1_and_a6_nna gw1_and_a6_nb gw1_and_g2 gw1_and_a6_nx 0 nch W=2.4e-06 L=5e-07
ngw1_and_a6_nnb gw1_and_a6_nx gw1_and_g3 0 0 nch W=2.4e-06 L=5e-07
ngw1_and_a6_ip gw1_and_g6 gw1_and_a6_nb vdd vsrc pch W=2.4e-06 L=5e-07
ngw1_and_a6_in gw1_and_g6 gw1_and_a6_nb 0 0 nch W=1.2e-06 L=5e-07
ngw1_and_a7_npa gw1_and_a7_nb gw1_and_g5 vdd vsrc pch W=2.4e-06 L=5e-07
ngw1_and_a7_npb gw1_and_a7_nb gw1_and_g6 vdd vsrc pch W=2.4e-06 L=5e-07
ngw1_and_a7_nna gw1_and_a7_nb gw1_and_g5 gw1_and_a7_nx 0 nch W=2.4e-06 L=5e-07
ngw1_and_a7_nnb gw1_and_a7_nx gw1_and_g6 0 0 nch W=2.4e-06 L=5e-07
ngw1_and_a7_ip gw1_and_g7 gw1_and_a7_nb vdd vsrc pch W=2.4e-06 L=5e-07
ngw1_and_a7_in gw1_and_g7 gw1_and_a7_nb 0 0 nch W=1.2e-06 L=5e-07
ngw1_and_a8_npa gw1_and_a8_nb gw1_and_g7 vdd vsrc pch W=2.4e-06 L=5e-07
ngw1_and_a8_npb gw1_and_a8_nb gw1_and_g4 vdd vsrc pch W=2.4e-06 L=5e-07
ngw1_and_a8_nna gw1_and_a8_nb gw1_and_g7 gw1_and_a8_nx 0 nch W=2.4e-06 L=5e-07
ngw1_and_a8_nnb gw1_and_a8_nx gw1_and_g4 0 0 nch W=2.4e-06 L=5e-07
ngw1_and_a8_ip gw1_and_g8 gw1_and_a8_nb vdd vsrc pch W=2.4e-06 L=5e-07
ngw1_and_a8_in gw1_and_g8 gw1_and_a8_nb 0 0 nch W=1.2e-06 L=5e-07
ngw1_gip gw1_gb gw1_and_g8 vdd vsrc pch W=2.4e-06 L=5e-07
ngw1_gin gw1_gb gw1_and_g8 0 0 nch W=1.2e-06 L=5e-07
cgw1_col_cm gw1_col_vm 0 1e-07
va_rgw1_col_rm_n vrest rgw1_col_rm_n 0
rgw1_col_rm gw1_col_vm rgw1_col_rm_n 1e+06
rgw1_col_kb vdd gw1_col_knb 1e+06
ngw1_col_kmb gw1_col_knb gw1_col_knb 0 0 nch W=4e-06 L=4e-06
ngw1_col_kmt gw1_col_ktail gw1_col_knb 0 0 nch W=4e-06 L=4e-06
ngw1_col_km1 gw1_col_kd1 gw1_col_vm gw1_col_ktail 0 nch W=4e-06 L=4e-06
ngw1_col_km2 gw1_col_ko1 gw1_col_h gw1_col_ktail 0 nch W=4e-06 L=4e-06
ngw1_col_km3 gw1_col_kd1 gw1_col_kd1 vdd vsrc pch W=4e-06 L=4e-06
ngw1_col_km4 gw1_col_ko1 gw1_col_kd1 vdd vsrc pch W=4e-06 L=4e-06
ngw1_col_kporclamp gw1_col_ko1 por_hold 0 0 nch W=4e-06 L=1e-06
ngw1_col_ki1p gw1_col_qb gw1_col_ko1 vdd vsrc pch W=2.4e-06 L=5e-07
ngw1_col_ki1n gw1_col_qb gw1_col_ko1 0 0 nch W=1.2e-06 L=5e-07
ngw1_col_ki2p gw1_col_q gw1_col_qb vdd vsrc pch W=2.4e-06 L=5e-07
ngw1_col_ki2n gw1_col_q gw1_col_qb 0 0 nch W=1.2e-06 L=5e-07
rgw1_col_hra gw1_col_h vthe 1e+06
rgw1_col_hrf gw1_col_h gw1_col_qb 1.9e+07
cgw1_col_hc gw1_col_h 0 2.1e-09
ngw1_col_dis gw1_col_vm gw1_col_q gw1_col_vmd 0 nch W=4e-06 L=1e-06
va_rgw1_col_rdis_n vrest rgw1_col_rdis_n 0
rgw1_col_rdis gw1_col_vmd rgw1_col_rdis_n 220000
ngw1_col_rp gw1_col_rt gw1_col_qb vdd vsrc pch W=2e-06 L=1e-06
rgw1_col_rrc gw1_col_rt gw1_col_rec 10000
cgw1_col_rc gw1_col_rec 0 1e-07
rgw1_col_rr gw1_col_rec 0 8.2e+06
ngw1_col_sh1 gw1_col_vm gw1_col_rec gw1_col_vms 0 nch W=2e-06 L=1e-06
va_ngw1_col_sh2_s vrest ngw1_col_sh2_s 0
ngw1_col_sh2 gw1_col_vms gw1_col_qb ngw1_col_sh2_s 0 nch W=2e-06 L=1e-06
ngw1_col_porh gw1_col_h por_hold vthe 0 nch W=2e-06 L=1e-06
va_ngw1_col_porm_s vrest ngw1_col_porm_s 0
ngw1_col_porm gw1_col_vm por_hold ngw1_col_porm_s 0 nch W=2e-06 L=1e-06
ngw1_cin_eni_p gw1_cin_ena gw1_gb vdd vsrc pch W=2.4e-06 L=5e-07
ngw1_cin_eni_n gw1_cin_ena gw1_gb 0 0 nch W=1.2e-06 L=5e-07
ngw1_cin_cp gw1_col_vm gw1_cin_cg vdd vsrc pch W=4e-06 L=4e-06
ngw1_cin_bias ilimp_n gw1_gb gw1_cin_cg vsrc pch W=1.2e-06 L=1e-06
ngw1_cin_off gw1_cin_cg gw1_cin_ena vdd vsrc pch W=2.4e-06 L=1e-06
ngw1_op_tsw gw1_op_tt gw1_col_qb vdd vsrc pch W=2e-06 L=1e-06
rgw1_op_trc gw1_op_tt gw1_op_at 10000
cgw1_op_tc gw1_op_at 0 1e-07
rgw1_op_trl gw1_op_at 0 2.2e+07
ngw1_op_sh1p gw1_op_an gw1_op_at vdd vsrc pch W=2.4e-06 L=5e-07
ngw1_op_sh1n gw1_op_an gw1_op_at 0 0 nch W=1.2e-06 L=5e-07
ngw1_op_sh2p gw1_op_aq gw1_op_an vdd vsrc pch W=2.4e-06 L=5e-07
ngw1_op_sh2n gw1_op_aq gw1_op_an 0 0 nch W=1.2e-06 L=5e-07
ngw1_op_abp gw1_op_aqb gw1_op_aq vdd vsrc pch W=2.4e-06 L=5e-07
ngw1_op_abn gw1_op_aqb gw1_op_aq 0 0 nch W=1.2e-06 L=5e-07
rgw1_op_dr gw1_op_aq gw1_op_ad 1e+06
cgw1_op_dc gw1_op_ad 0 3.3e-07
ngw1_op_d2p gw1_op_adn gw1_op_ad vdd vsrc pch W=2.4e-06 L=5e-07
ngw1_op_d2n gw1_op_adn gw1_op_ad 0 0 nch W=1.2e-06 L=5e-07
ngw1_op_gpa gw1_op_pb gw1_op_aq vdd vsrc pch W=2.4e-06 L=5e-07
ngw1_op_gpb gw1_op_pb gw1_op_adn vdd vsrc pch W=2.4e-06 L=5e-07
ngw1_op_gna gw1_op_pb gw1_op_aq gw1_op_gx 0 nch W=2.4e-06 L=5e-07
ngw1_op_gnb gw1_op_gx gw1_op_adn 0 0 nch W=2.4e-06 L=5e-07
ngw1_op_op gw1_op_p gw1_op_pb vdd vsrc pch W=2.4e-06 L=5e-07
ngw1_op_on gw1_op_p gw1_op_pb 0 0 nch W=1.2e-06 L=5e-07
cgc1_e1_cm gc1_e1_vm 0 1e-07
va_rgc1_e1_rm_n vrest rgc1_e1_rm_n 0
rgc1_e1_rm gc1_e1_vm rgc1_e1_rm_n 1e+06
ngc1_e1_bias0 gc1_e1_vm istep_n 0 0 nch W=4e-06 L=4e-06
rgc1_e1_kb vdd gc1_e1_knb 1e+06
ngc1_e1_kmb gc1_e1_knb gc1_e1_knb 0 0 nch W=4e-06 L=4e-06
ngc1_e1_kmt gc1_e1_ktail gc1_e1_knb 0 0 nch W=4e-06 L=4e-06
ngc1_e1_km1 gc1_e1_kd1 gc1_e1_vm gc1_e1_ktail 0 nch W=4e-06 L=4e-06
ngc1_e1_km2 gc1_e1_ko1 gc1_e1_h gc1_e1_ktail 0 nch W=4e-06 L=4e-06
ngc1_e1_km3 gc1_e1_kd1 gc1_e1_kd1 vdd vsrc pch W=4e-06 L=4e-06
ngc1_e1_km4 gc1_e1_ko1 gc1_e1_kd1 vdd vsrc pch W=4e-06 L=4e-06
ngc1_e1_kporclamp gc1_e1_ko1 por_hold 0 0 nch W=4e-06 L=1e-06
ngc1_e1_ki1p gc1_e1_qb gc1_e1_ko1 vdd vsrc pch W=2.4e-06 L=5e-07
ngc1_e1_ki1n gc1_e1_qb gc1_e1_ko1 0 0 nch W=1.2e-06 L=5e-07
ngc1_e1_ki2p gc1_e1_q gc1_e1_qb vdd vsrc pch W=2.4e-06 L=5e-07
ngc1_e1_ki2n gc1_e1_q gc1_e1_qb 0 0 nch W=1.2e-06 L=5e-07
rgc1_e1_hra gc1_e1_h vthe 1e+06
rgc1_e1_hrf gc1_e1_h gc1_e1_qb 1.9e+07
cgc1_e1_hc gc1_e1_h 0 2.1e-09
ngc1_e1_dis gc1_e1_vm gc1_e1_q gc1_e1_vmd 0 nch W=4e-06 L=1e-06
va_rgc1_e1_rdis_n vrest rgc1_e1_rdis_n 0
rgc1_e1_rdis gc1_e1_vmd rgc1_e1_rdis_n 220000
ngc1_e1_rp gc1_e1_rt gc1_e1_qb vdd vsrc pch W=2e-06 L=1e-06
rgc1_e1_rrc gc1_e1_rt gc1_e1_rec 10000
cgc1_e1_rc gc1_e1_rec 0 1e-07
rgc1_e1_rr gc1_e1_rec 0 8.2e+06
ngc1_e1_sh1 gc1_e1_vm gc1_e1_rec gc1_e1_vms 0 nch W=2e-06 L=1e-06
va_ngc1_e1_sh2_s vrest ngc1_e1_sh2_s 0
ngc1_e1_sh2 gc1_e1_vms gc1_e1_qb ngc1_e1_sh2_s 0 nch W=2e-06 L=1e-06
ngc1_e1_porh gc1_e1_h por_hold vthe 0 nch W=2e-06 L=1e-06
va_ngc1_e1_porm_s vrest ngc1_e1_porm_s 0
ngc1_e1_porm gc1_e1_vm por_hold ngc1_e1_porm_s 0 nch W=2e-06 L=1e-06
ngc1_e1_ip gc1_e1_vm s1_yb vdd vsrc pch W=4e-06 L=4e-06
ngc1_e1_in gc1_e1_vm s1_za 0 0 nch W=4e-06 L=4e-06
ngc1_b1_sw gc1_b1_t gc1_e1_qb vdd vsrc pch W=2e-06 L=1e-06
rgc1_b1_rc gc1_b1_t gc1_b1 10000
cgc1_b1_c gc1_b1 0 1e-07
rgc1_b1_rl gc1_b1 0 2.2e+07
ngc1_b1_sh1p gc1_b1_n gc1_b1 vdd vsrc pch W=2.4e-06 L=5e-07
ngc1_b1_sh1n gc1_b1_n gc1_b1 0 0 nch W=1.2e-06 L=5e-07
ngc1_b1_sh2p gc1_b1_q gc1_b1_n vdd vsrc pch W=2.4e-06 L=5e-07
ngc1_b1_sh2n gc1_b1_q gc1_b1_n 0 0 nch W=1.2e-06 L=5e-07
cgc1_e2_cm gc1_e2_vm 0 1e-07
va_rgc1_e2_rm_n vrest rgc1_e2_rm_n 0
rgc1_e2_rm gc1_e2_vm rgc1_e2_rm_n 1e+06
ngc1_e2_bias0 gc1_e2_vm istep_n 0 0 nch W=4e-06 L=4e-06
ngc1_e2_bias1 gc1_e2_vm istep_n 0 0 nch W=4e-06 L=4e-06
rgc1_e2_kb vdd gc1_e2_knb 1e+06
ngc1_e2_kmb gc1_e2_knb gc1_e2_knb 0 0 nch W=4e-06 L=4e-06
ngc1_e2_kmt gc1_e2_ktail gc1_e2_knb 0 0 nch W=4e-06 L=4e-06
ngc1_e2_km1 gc1_e2_kd1 gc1_e2_vm gc1_e2_ktail 0 nch W=4e-06 L=4e-06
ngc1_e2_km2 gc1_e2_ko1 gc1_e2_h gc1_e2_ktail 0 nch W=4e-06 L=4e-06
ngc1_e2_km3 gc1_e2_kd1 gc1_e2_kd1 vdd vsrc pch W=4e-06 L=4e-06
ngc1_e2_km4 gc1_e2_ko1 gc1_e2_kd1 vdd vsrc pch W=4e-06 L=4e-06
ngc1_e2_kporclamp gc1_e2_ko1 por_hold 0 0 nch W=4e-06 L=1e-06
ngc1_e2_ki1p gc1_e2_qb gc1_e2_ko1 vdd vsrc pch W=2.4e-06 L=5e-07
ngc1_e2_ki1n gc1_e2_qb gc1_e2_ko1 0 0 nch W=1.2e-06 L=5e-07
ngc1_e2_ki2p gc1_e2_q gc1_e2_qb vdd vsrc pch W=2.4e-06 L=5e-07
ngc1_e2_ki2n gc1_e2_q gc1_e2_qb 0 0 nch W=1.2e-06 L=5e-07
rgc1_e2_hra gc1_e2_h vthe 1e+06
rgc1_e2_hrf gc1_e2_h gc1_e2_qb 1.9e+07
cgc1_e2_hc gc1_e2_h 0 2.1e-09
ngc1_e2_dis gc1_e2_vm gc1_e2_q gc1_e2_vmd 0 nch W=4e-06 L=1e-06
va_rgc1_e2_rdis_n vrest rgc1_e2_rdis_n 0
rgc1_e2_rdis gc1_e2_vmd rgc1_e2_rdis_n 220000
ngc1_e2_rp gc1_e2_rt gc1_e2_qb vdd vsrc pch W=2e-06 L=1e-06
rgc1_e2_rrc gc1_e2_rt gc1_e2_rec 10000
cgc1_e2_rc gc1_e2_rec 0 1e-07
rgc1_e2_rr gc1_e2_rec 0 8.2e+06
ngc1_e2_sh1 gc1_e2_vm gc1_e2_rec gc1_e2_vms 0 nch W=2e-06 L=1e-06
va_ngc1_e2_sh2_s vrest ngc1_e2_sh2_s 0
ngc1_e2_sh2 gc1_e2_vms gc1_e2_qb ngc1_e2_sh2_s 0 nch W=2e-06 L=1e-06
ngc1_e2_porh gc1_e2_h por_hold vthe 0 nch W=2e-06 L=1e-06
va_ngc1_e2_porm_s vrest ngc1_e2_porm_s 0
ngc1_e2_porm gc1_e2_vm por_hold ngc1_e2_porm_s 0 nch W=2e-06 L=1e-06
ngc1_e2_ip gc1_e2_vm s1_yb vdd vsrc pch W=4e-06 L=4e-06
ngc1_e2_in gc1_e2_vm s1_za 0 0 nch W=4e-06 L=4e-06
ngc1_b2_sw gc1_b2_t gc1_e2_qb vdd vsrc pch W=2e-06 L=1e-06
rgc1_b2_rc gc1_b2_t gc1_b2 10000
cgc1_b2_c gc1_b2 0 1e-07
rgc1_b2_rl gc1_b2 0 2.2e+07
ngc1_b2_sh1p gc1_b2_n gc1_b2 vdd vsrc pch W=2.4e-06 L=5e-07
ngc1_b2_sh1n gc1_b2_n gc1_b2 0 0 nch W=1.2e-06 L=5e-07
ngc1_b2_sh2p gc1_b2_q gc1_b2_n vdd vsrc pch W=2.4e-06 L=5e-07
ngc1_b2_sh2n gc1_b2_q gc1_b2_n 0 0 nch W=1.2e-06 L=5e-07
cgc1_e3_cm gc1_e3_vm 0 1e-07
va_rgc1_e3_rm_n vrest rgc1_e3_rm_n 0
rgc1_e3_rm gc1_e3_vm rgc1_e3_rm_n 1e+06
ngc1_e3_bias0 gc1_e3_vm istep_n 0 0 nch W=4e-06 L=4e-06
ngc1_e3_bias1 gc1_e3_vm istep_n 0 0 nch W=4e-06 L=4e-06
ngc1_e3_bias2 gc1_e3_vm istep_n 0 0 nch W=4e-06 L=4e-06
rgc1_e3_kb vdd gc1_e3_knb 1e+06
ngc1_e3_kmb gc1_e3_knb gc1_e3_knb 0 0 nch W=4e-06 L=4e-06
ngc1_e3_kmt gc1_e3_ktail gc1_e3_knb 0 0 nch W=4e-06 L=4e-06
ngc1_e3_km1 gc1_e3_kd1 gc1_e3_vm gc1_e3_ktail 0 nch W=4e-06 L=4e-06
ngc1_e3_km2 gc1_e3_ko1 gc1_e3_h gc1_e3_ktail 0 nch W=4e-06 L=4e-06
ngc1_e3_km3 gc1_e3_kd1 gc1_e3_kd1 vdd vsrc pch W=4e-06 L=4e-06
ngc1_e3_km4 gc1_e3_ko1 gc1_e3_kd1 vdd vsrc pch W=4e-06 L=4e-06
ngc1_e3_kporclamp gc1_e3_ko1 por_hold 0 0 nch W=4e-06 L=1e-06
ngc1_e3_ki1p gc1_e3_qb gc1_e3_ko1 vdd vsrc pch W=2.4e-06 L=5e-07
ngc1_e3_ki1n gc1_e3_qb gc1_e3_ko1 0 0 nch W=1.2e-06 L=5e-07
ngc1_e3_ki2p gc1_e3_q gc1_e3_qb vdd vsrc pch W=2.4e-06 L=5e-07
ngc1_e3_ki2n gc1_e3_q gc1_e3_qb 0 0 nch W=1.2e-06 L=5e-07
rgc1_e3_hra gc1_e3_h vthe 1e+06
rgc1_e3_hrf gc1_e3_h gc1_e3_qb 1.9e+07
cgc1_e3_hc gc1_e3_h 0 2.1e-09
ngc1_e3_dis gc1_e3_vm gc1_e3_q gc1_e3_vmd 0 nch W=4e-06 L=1e-06
va_rgc1_e3_rdis_n vrest rgc1_e3_rdis_n 0
rgc1_e3_rdis gc1_e3_vmd rgc1_e3_rdis_n 220000
ngc1_e3_rp gc1_e3_rt gc1_e3_qb vdd vsrc pch W=2e-06 L=1e-06
rgc1_e3_rrc gc1_e3_rt gc1_e3_rec 10000
cgc1_e3_rc gc1_e3_rec 0 1e-07
rgc1_e3_rr gc1_e3_rec 0 8.2e+06
ngc1_e3_sh1 gc1_e3_vm gc1_e3_rec gc1_e3_vms 0 nch W=2e-06 L=1e-06
va_ngc1_e3_sh2_s vrest ngc1_e3_sh2_s 0
ngc1_e3_sh2 gc1_e3_vms gc1_e3_qb ngc1_e3_sh2_s 0 nch W=2e-06 L=1e-06
ngc1_e3_porh gc1_e3_h por_hold vthe 0 nch W=2e-06 L=1e-06
va_ngc1_e3_porm_s vrest ngc1_e3_porm_s 0
ngc1_e3_porm gc1_e3_vm por_hold ngc1_e3_porm_s 0 nch W=2e-06 L=1e-06
ngc1_e3_ip gc1_e3_vm s1_yb vdd vsrc pch W=4e-06 L=4e-06
ngc1_e3_in gc1_e3_vm s1_za 0 0 nch W=4e-06 L=4e-06
ngc1_b3_sw gc1_b3_t gc1_e3_qb vdd vsrc pch W=2e-06 L=1e-06
rgc1_b3_rc gc1_b3_t gc1_b3 10000
cgc1_b3_c gc1_b3 0 1e-07
rgc1_b3_rl gc1_b3 0 2.2e+07
ngc1_b3_sh1p gc1_b3_n gc1_b3 vdd vsrc pch W=2.4e-06 L=5e-07
ngc1_b3_sh1n gc1_b3_n gc1_b3 0 0 nch W=1.2e-06 L=5e-07
ngc1_b3_sh2p gc1_b3_q gc1_b3_n vdd vsrc pch W=2.4e-06 L=5e-07
ngc1_b3_sh2n gc1_b3_q gc1_b3_n 0 0 nch W=1.2e-06 L=5e-07
cgc1_e4_cm gc1_e4_vm 0 1e-07
va_rgc1_e4_rm_n vrest rgc1_e4_rm_n 0
rgc1_e4_rm gc1_e4_vm rgc1_e4_rm_n 1e+06
ngc1_e4_bias0 gc1_e4_vm istep_n 0 0 nch W=4e-06 L=4e-06
ngc1_e4_bias1 gc1_e4_vm istep_n 0 0 nch W=4e-06 L=4e-06
ngc1_e4_bias2 gc1_e4_vm istep_n 0 0 nch W=4e-06 L=4e-06
ngc1_e4_bias3 gc1_e4_vm istep_n 0 0 nch W=4e-06 L=4e-06
rgc1_e4_kb vdd gc1_e4_knb 1e+06
ngc1_e4_kmb gc1_e4_knb gc1_e4_knb 0 0 nch W=4e-06 L=4e-06
ngc1_e4_kmt gc1_e4_ktail gc1_e4_knb 0 0 nch W=4e-06 L=4e-06
ngc1_e4_km1 gc1_e4_kd1 gc1_e4_vm gc1_e4_ktail 0 nch W=4e-06 L=4e-06
ngc1_e4_km2 gc1_e4_ko1 gc1_e4_h gc1_e4_ktail 0 nch W=4e-06 L=4e-06
ngc1_e4_km3 gc1_e4_kd1 gc1_e4_kd1 vdd vsrc pch W=4e-06 L=4e-06
ngc1_e4_km4 gc1_e4_ko1 gc1_e4_kd1 vdd vsrc pch W=4e-06 L=4e-06
ngc1_e4_kporclamp gc1_e4_ko1 por_hold 0 0 nch W=4e-06 L=1e-06
ngc1_e4_ki1p gc1_e4_qb gc1_e4_ko1 vdd vsrc pch W=2.4e-06 L=5e-07
ngc1_e4_ki1n gc1_e4_qb gc1_e4_ko1 0 0 nch W=1.2e-06 L=5e-07
ngc1_e4_ki2p gc1_e4_q gc1_e4_qb vdd vsrc pch W=2.4e-06 L=5e-07
ngc1_e4_ki2n gc1_e4_q gc1_e4_qb 0 0 nch W=1.2e-06 L=5e-07
rgc1_e4_hra gc1_e4_h vthe 1e+06
rgc1_e4_hrf gc1_e4_h gc1_e4_qb 1.9e+07
cgc1_e4_hc gc1_e4_h 0 2.1e-09
ngc1_e4_dis gc1_e4_vm gc1_e4_q gc1_e4_vmd 0 nch W=4e-06 L=1e-06
va_rgc1_e4_rdis_n vrest rgc1_e4_rdis_n 0
rgc1_e4_rdis gc1_e4_vmd rgc1_e4_rdis_n 220000
ngc1_e4_rp gc1_e4_rt gc1_e4_qb vdd vsrc pch W=2e-06 L=1e-06
rgc1_e4_rrc gc1_e4_rt gc1_e4_rec 10000
cgc1_e4_rc gc1_e4_rec 0 1e-07
rgc1_e4_rr gc1_e4_rec 0 8.2e+06
ngc1_e4_sh1 gc1_e4_vm gc1_e4_rec gc1_e4_vms 0 nch W=2e-06 L=1e-06
va_ngc1_e4_sh2_s vrest ngc1_e4_sh2_s 0
ngc1_e4_sh2 gc1_e4_vms gc1_e4_qb ngc1_e4_sh2_s 0 nch W=2e-06 L=1e-06
ngc1_e4_porh gc1_e4_h por_hold vthe 0 nch W=2e-06 L=1e-06
va_ngc1_e4_porm_s vrest ngc1_e4_porm_s 0
ngc1_e4_porm gc1_e4_vm por_hold ngc1_e4_porm_s 0 nch W=2e-06 L=1e-06
ngc1_e4_ip gc1_e4_vm s1_yb vdd vsrc pch W=4e-06 L=4e-06
ngc1_e4_in gc1_e4_vm s1_za 0 0 nch W=4e-06 L=4e-06
ngc1_b4_sw gc1_b4_t gc1_e4_qb vdd vsrc pch W=2e-06 L=1e-06
rgc1_b4_rc gc1_b4_t gc1_b4 10000
cgc1_b4_c gc1_b4 0 1e-07
rgc1_b4_rl gc1_b4 0 2.2e+07
ngc1_b4_sh1p gc1_b4_n gc1_b4 vdd vsrc pch W=2.4e-06 L=5e-07
ngc1_b4_sh1n gc1_b4_n gc1_b4 0 0 nch W=1.2e-06 L=5e-07
ngc1_b4_sh2p gc1_b4_q gc1_b4_n vdd vsrc pch W=2.4e-06 L=5e-07
ngc1_b4_sh2n gc1_b4_q gc1_b4_n 0 0 nch W=1.2e-06 L=5e-07
cgc1_e5_cm gc1_e5_vm 0 1e-07
va_rgc1_e5_rm_n vrest rgc1_e5_rm_n 0
rgc1_e5_rm gc1_e5_vm rgc1_e5_rm_n 1e+06
ngc1_e5_bias0 gc1_e5_vm istep_n 0 0 nch W=4e-06 L=4e-06
ngc1_e5_bias1 gc1_e5_vm istep_n 0 0 nch W=4e-06 L=4e-06
ngc1_e5_bias2 gc1_e5_vm istep_n 0 0 nch W=4e-06 L=4e-06
ngc1_e5_bias3 gc1_e5_vm istep_n 0 0 nch W=4e-06 L=4e-06
ngc1_e5_bias4 gc1_e5_vm istep_n 0 0 nch W=4e-06 L=4e-06
rgc1_e5_kb vdd gc1_e5_knb 1e+06
ngc1_e5_kmb gc1_e5_knb gc1_e5_knb 0 0 nch W=4e-06 L=4e-06
ngc1_e5_kmt gc1_e5_ktail gc1_e5_knb 0 0 nch W=4e-06 L=4e-06
ngc1_e5_km1 gc1_e5_kd1 gc1_e5_vm gc1_e5_ktail 0 nch W=4e-06 L=4e-06
ngc1_e5_km2 gc1_e5_ko1 gc1_e5_h gc1_e5_ktail 0 nch W=4e-06 L=4e-06
ngc1_e5_km3 gc1_e5_kd1 gc1_e5_kd1 vdd vsrc pch W=4e-06 L=4e-06
ngc1_e5_km4 gc1_e5_ko1 gc1_e5_kd1 vdd vsrc pch W=4e-06 L=4e-06
ngc1_e5_kporclamp gc1_e5_ko1 por_hold 0 0 nch W=4e-06 L=1e-06
ngc1_e5_ki1p gc1_e5_qb gc1_e5_ko1 vdd vsrc pch W=2.4e-06 L=5e-07
ngc1_e5_ki1n gc1_e5_qb gc1_e5_ko1 0 0 nch W=1.2e-06 L=5e-07
ngc1_e5_ki2p gc1_e5_q gc1_e5_qb vdd vsrc pch W=2.4e-06 L=5e-07
ngc1_e5_ki2n gc1_e5_q gc1_e5_qb 0 0 nch W=1.2e-06 L=5e-07
rgc1_e5_hra gc1_e5_h vthe 1e+06
rgc1_e5_hrf gc1_e5_h gc1_e5_qb 1.9e+07
cgc1_e5_hc gc1_e5_h 0 2.1e-09
ngc1_e5_dis gc1_e5_vm gc1_e5_q gc1_e5_vmd 0 nch W=4e-06 L=1e-06
va_rgc1_e5_rdis_n vrest rgc1_e5_rdis_n 0
rgc1_e5_rdis gc1_e5_vmd rgc1_e5_rdis_n 220000
ngc1_e5_rp gc1_e5_rt gc1_e5_qb vdd vsrc pch W=2e-06 L=1e-06
rgc1_e5_rrc gc1_e5_rt gc1_e5_rec 10000
cgc1_e5_rc gc1_e5_rec 0 1e-07
rgc1_e5_rr gc1_e5_rec 0 8.2e+06
ngc1_e5_sh1 gc1_e5_vm gc1_e5_rec gc1_e5_vms 0 nch W=2e-06 L=1e-06
va_ngc1_e5_sh2_s vrest ngc1_e5_sh2_s 0
ngc1_e5_sh2 gc1_e5_vms gc1_e5_qb ngc1_e5_sh2_s 0 nch W=2e-06 L=1e-06
ngc1_e5_porh gc1_e5_h por_hold vthe 0 nch W=2e-06 L=1e-06
va_ngc1_e5_porm_s vrest ngc1_e5_porm_s 0
ngc1_e5_porm gc1_e5_vm por_hold ngc1_e5_porm_s 0 nch W=2e-06 L=1e-06
ngc1_e5_ip gc1_e5_vm s1_yb vdd vsrc pch W=4e-06 L=4e-06
ngc1_e5_in gc1_e5_vm s1_za 0 0 nch W=4e-06 L=4e-06
ngc1_b5_sw gc1_b5_t gc1_e5_qb vdd vsrc pch W=2e-06 L=1e-06
rgc1_b5_rc gc1_b5_t gc1_b5 10000
cgc1_b5_c gc1_b5 0 1e-07
rgc1_b5_rl gc1_b5 0 2.2e+07
ngc1_b5_sh1p gc1_b5_n gc1_b5 vdd vsrc pch W=2.4e-06 L=5e-07
ngc1_b5_sh1n gc1_b5_n gc1_b5 0 0 nch W=1.2e-06 L=5e-07
ngc1_b5_sh2p gc1_b5_q gc1_b5_n vdd vsrc pch W=2.4e-06 L=5e-07
ngc1_b5_sh2n gc1_b5_q gc1_b5_n 0 0 nch W=1.2e-06 L=5e-07
cgc1_e6_cm gc1_e6_vm 0 1e-07
va_rgc1_e6_rm_n vrest rgc1_e6_rm_n 0
rgc1_e6_rm gc1_e6_vm rgc1_e6_rm_n 1e+06
ngc1_e6_bias0 gc1_e6_vm istep_n 0 0 nch W=4e-06 L=4e-06
ngc1_e6_bias1 gc1_e6_vm istep_n 0 0 nch W=4e-06 L=4e-06
ngc1_e6_bias2 gc1_e6_vm istep_n 0 0 nch W=4e-06 L=4e-06
ngc1_e6_bias3 gc1_e6_vm istep_n 0 0 nch W=4e-06 L=4e-06
ngc1_e6_bias4 gc1_e6_vm istep_n 0 0 nch W=4e-06 L=4e-06
ngc1_e6_bias5 gc1_e6_vm istep_n 0 0 nch W=4e-06 L=4e-06
rgc1_e6_kb vdd gc1_e6_knb 1e+06
ngc1_e6_kmb gc1_e6_knb gc1_e6_knb 0 0 nch W=4e-06 L=4e-06
ngc1_e6_kmt gc1_e6_ktail gc1_e6_knb 0 0 nch W=4e-06 L=4e-06
ngc1_e6_km1 gc1_e6_kd1 gc1_e6_vm gc1_e6_ktail 0 nch W=4e-06 L=4e-06
ngc1_e6_km2 gc1_e6_ko1 gc1_e6_h gc1_e6_ktail 0 nch W=4e-06 L=4e-06
ngc1_e6_km3 gc1_e6_kd1 gc1_e6_kd1 vdd vsrc pch W=4e-06 L=4e-06
ngc1_e6_km4 gc1_e6_ko1 gc1_e6_kd1 vdd vsrc pch W=4e-06 L=4e-06
ngc1_e6_kporclamp gc1_e6_ko1 por_hold 0 0 nch W=4e-06 L=1e-06
ngc1_e6_ki1p gc1_e6_qb gc1_e6_ko1 vdd vsrc pch W=2.4e-06 L=5e-07
ngc1_e6_ki1n gc1_e6_qb gc1_e6_ko1 0 0 nch W=1.2e-06 L=5e-07
ngc1_e6_ki2p gc1_e6_q gc1_e6_qb vdd vsrc pch W=2.4e-06 L=5e-07
ngc1_e6_ki2n gc1_e6_q gc1_e6_qb 0 0 nch W=1.2e-06 L=5e-07
rgc1_e6_hra gc1_e6_h vthe 1e+06
rgc1_e6_hrf gc1_e6_h gc1_e6_qb 1.9e+07
cgc1_e6_hc gc1_e6_h 0 2.1e-09
ngc1_e6_dis gc1_e6_vm gc1_e6_q gc1_e6_vmd 0 nch W=4e-06 L=1e-06
va_rgc1_e6_rdis_n vrest rgc1_e6_rdis_n 0
rgc1_e6_rdis gc1_e6_vmd rgc1_e6_rdis_n 220000
ngc1_e6_rp gc1_e6_rt gc1_e6_qb vdd vsrc pch W=2e-06 L=1e-06
rgc1_e6_rrc gc1_e6_rt gc1_e6_rec 10000
cgc1_e6_rc gc1_e6_rec 0 1e-07
rgc1_e6_rr gc1_e6_rec 0 8.2e+06
ngc1_e6_sh1 gc1_e6_vm gc1_e6_rec gc1_e6_vms 0 nch W=2e-06 L=1e-06
va_ngc1_e6_sh2_s vrest ngc1_e6_sh2_s 0
ngc1_e6_sh2 gc1_e6_vms gc1_e6_qb ngc1_e6_sh2_s 0 nch W=2e-06 L=1e-06
ngc1_e6_porh gc1_e6_h por_hold vthe 0 nch W=2e-06 L=1e-06
va_ngc1_e6_porm_s vrest ngc1_e6_porm_s 0
ngc1_e6_porm gc1_e6_vm por_hold ngc1_e6_porm_s 0 nch W=2e-06 L=1e-06
ngc1_e6_ip gc1_e6_vm s1_yb vdd vsrc pch W=4e-06 L=4e-06
ngc1_e6_in gc1_e6_vm s1_za 0 0 nch W=4e-06 L=4e-06
ngc1_b6_sw gc1_b6_t gc1_e6_qb vdd vsrc pch W=2e-06 L=1e-06
rgc1_b6_rc gc1_b6_t gc1_b6 10000
cgc1_b6_c gc1_b6 0 1e-07
rgc1_b6_rl gc1_b6 0 2.2e+07
ngc1_b6_sh1p gc1_b6_n gc1_b6 vdd vsrc pch W=2.4e-06 L=5e-07
ngc1_b6_sh1n gc1_b6_n gc1_b6 0 0 nch W=1.2e-06 L=5e-07
ngc1_b6_sh2p gc1_b6_q gc1_b6_n vdd vsrc pch W=2.4e-06 L=5e-07
ngc1_b6_sh2n gc1_b6_q gc1_b6_n 0 0 nch W=1.2e-06 L=5e-07
cgc1_e7_cm gc1_e7_vm 0 1e-07
va_rgc1_e7_rm_n vrest rgc1_e7_rm_n 0
rgc1_e7_rm gc1_e7_vm rgc1_e7_rm_n 1e+06
ngc1_e7_bias0 gc1_e7_vm istep_n 0 0 nch W=4e-06 L=4e-06
ngc1_e7_bias1 gc1_e7_vm istep_n 0 0 nch W=4e-06 L=4e-06
ngc1_e7_bias2 gc1_e7_vm istep_n 0 0 nch W=4e-06 L=4e-06
ngc1_e7_bias3 gc1_e7_vm istep_n 0 0 nch W=4e-06 L=4e-06
ngc1_e7_bias4 gc1_e7_vm istep_n 0 0 nch W=4e-06 L=4e-06
ngc1_e7_bias5 gc1_e7_vm istep_n 0 0 nch W=4e-06 L=4e-06
ngc1_e7_bias6 gc1_e7_vm istep_n 0 0 nch W=4e-06 L=4e-06
rgc1_e7_kb vdd gc1_e7_knb 1e+06
ngc1_e7_kmb gc1_e7_knb gc1_e7_knb 0 0 nch W=4e-06 L=4e-06
ngc1_e7_kmt gc1_e7_ktail gc1_e7_knb 0 0 nch W=4e-06 L=4e-06
ngc1_e7_km1 gc1_e7_kd1 gc1_e7_vm gc1_e7_ktail 0 nch W=4e-06 L=4e-06
ngc1_e7_km2 gc1_e7_ko1 gc1_e7_h gc1_e7_ktail 0 nch W=4e-06 L=4e-06
ngc1_e7_km3 gc1_e7_kd1 gc1_e7_kd1 vdd vsrc pch W=4e-06 L=4e-06
ngc1_e7_km4 gc1_e7_ko1 gc1_e7_kd1 vdd vsrc pch W=4e-06 L=4e-06
ngc1_e7_kporclamp gc1_e7_ko1 por_hold 0 0 nch W=4e-06 L=1e-06
ngc1_e7_ki1p gc1_e7_qb gc1_e7_ko1 vdd vsrc pch W=2.4e-06 L=5e-07
ngc1_e7_ki1n gc1_e7_qb gc1_e7_ko1 0 0 nch W=1.2e-06 L=5e-07
ngc1_e7_ki2p gc1_e7_q gc1_e7_qb vdd vsrc pch W=2.4e-06 L=5e-07
ngc1_e7_ki2n gc1_e7_q gc1_e7_qb 0 0 nch W=1.2e-06 L=5e-07
rgc1_e7_hra gc1_e7_h vthe 1e+06
rgc1_e7_hrf gc1_e7_h gc1_e7_qb 1.9e+07
cgc1_e7_hc gc1_e7_h 0 2.1e-09
ngc1_e7_dis gc1_e7_vm gc1_e7_q gc1_e7_vmd 0 nch W=4e-06 L=1e-06
va_rgc1_e7_rdis_n vrest rgc1_e7_rdis_n 0
rgc1_e7_rdis gc1_e7_vmd rgc1_e7_rdis_n 220000
ngc1_e7_rp gc1_e7_rt gc1_e7_qb vdd vsrc pch W=2e-06 L=1e-06
rgc1_e7_rrc gc1_e7_rt gc1_e7_rec 10000
cgc1_e7_rc gc1_e7_rec 0 1e-07
rgc1_e7_rr gc1_e7_rec 0 8.2e+06
ngc1_e7_sh1 gc1_e7_vm gc1_e7_rec gc1_e7_vms 0 nch W=2e-06 L=1e-06
va_ngc1_e7_sh2_s vrest ngc1_e7_sh2_s 0
ngc1_e7_sh2 gc1_e7_vms gc1_e7_qb ngc1_e7_sh2_s 0 nch W=2e-06 L=1e-06
ngc1_e7_porh gc1_e7_h por_hold vthe 0 nch W=2e-06 L=1e-06
va_ngc1_e7_porm_s vrest ngc1_e7_porm_s 0
ngc1_e7_porm gc1_e7_vm por_hold ngc1_e7_porm_s 0 nch W=2e-06 L=1e-06
ngc1_e7_ip gc1_e7_vm s1_yb vdd vsrc pch W=4e-06 L=4e-06
ngc1_e7_in gc1_e7_vm s1_za 0 0 nch W=4e-06 L=4e-06
ngc1_b7_sw gc1_b7_t gc1_e7_qb vdd vsrc pch W=2e-06 L=1e-06
rgc1_b7_rc gc1_b7_t gc1_b7 10000
cgc1_b7_c gc1_b7 0 1e-07
rgc1_b7_rl gc1_b7 0 2.2e+07
ngc1_b7_sh1p gc1_b7_n gc1_b7 vdd vsrc pch W=2.4e-06 L=5e-07
ngc1_b7_sh1n gc1_b7_n gc1_b7 0 0 nch W=1.2e-06 L=5e-07
ngc1_b7_sh2p gc1_b7_q gc1_b7_n vdd vsrc pch W=2.4e-06 L=5e-07
ngc1_b7_sh2n gc1_b7_q gc1_b7_n 0 0 nch W=1.2e-06 L=5e-07
cgc1_e8_cm gc1_e8_vm 0 1e-07
va_rgc1_e8_rm_n vrest rgc1_e8_rm_n 0
rgc1_e8_rm gc1_e8_vm rgc1_e8_rm_n 1e+06
ngc1_e8_bias0 gc1_e8_vm istep_n 0 0 nch W=4e-06 L=4e-06
ngc1_e8_bias1 gc1_e8_vm istep_n 0 0 nch W=4e-06 L=4e-06
ngc1_e8_bias2 gc1_e8_vm istep_n 0 0 nch W=4e-06 L=4e-06
ngc1_e8_bias3 gc1_e8_vm istep_n 0 0 nch W=4e-06 L=4e-06
ngc1_e8_bias4 gc1_e8_vm istep_n 0 0 nch W=4e-06 L=4e-06
ngc1_e8_bias5 gc1_e8_vm istep_n 0 0 nch W=4e-06 L=4e-06
ngc1_e8_bias6 gc1_e8_vm istep_n 0 0 nch W=4e-06 L=4e-06
ngc1_e8_bias7 gc1_e8_vm istep_n 0 0 nch W=4e-06 L=4e-06
rgc1_e8_kb vdd gc1_e8_knb 1e+06
ngc1_e8_kmb gc1_e8_knb gc1_e8_knb 0 0 nch W=4e-06 L=4e-06
ngc1_e8_kmt gc1_e8_ktail gc1_e8_knb 0 0 nch W=4e-06 L=4e-06
ngc1_e8_km1 gc1_e8_kd1 gc1_e8_vm gc1_e8_ktail 0 nch W=4e-06 L=4e-06
ngc1_e8_km2 gc1_e8_ko1 gc1_e8_h gc1_e8_ktail 0 nch W=4e-06 L=4e-06
ngc1_e8_km3 gc1_e8_kd1 gc1_e8_kd1 vdd vsrc pch W=4e-06 L=4e-06
ngc1_e8_km4 gc1_e8_ko1 gc1_e8_kd1 vdd vsrc pch W=4e-06 L=4e-06
ngc1_e8_kporclamp gc1_e8_ko1 por_hold 0 0 nch W=4e-06 L=1e-06
ngc1_e8_ki1p gc1_e8_qb gc1_e8_ko1 vdd vsrc pch W=2.4e-06 L=5e-07
ngc1_e8_ki1n gc1_e8_qb gc1_e8_ko1 0 0 nch W=1.2e-06 L=5e-07
ngc1_e8_ki2p gc1_e8_q gc1_e8_qb vdd vsrc pch W=2.4e-06 L=5e-07
ngc1_e8_ki2n gc1_e8_q gc1_e8_qb 0 0 nch W=1.2e-06 L=5e-07
rgc1_e8_hra gc1_e8_h vthe 1e+06
rgc1_e8_hrf gc1_e8_h gc1_e8_qb 1.9e+07
cgc1_e8_hc gc1_e8_h 0 2.1e-09
ngc1_e8_dis gc1_e8_vm gc1_e8_q gc1_e8_vmd 0 nch W=4e-06 L=1e-06
va_rgc1_e8_rdis_n vrest rgc1_e8_rdis_n 0
rgc1_e8_rdis gc1_e8_vmd rgc1_e8_rdis_n 220000
ngc1_e8_rp gc1_e8_rt gc1_e8_qb vdd vsrc pch W=2e-06 L=1e-06
rgc1_e8_rrc gc1_e8_rt gc1_e8_rec 10000
cgc1_e8_rc gc1_e8_rec 0 1e-07
rgc1_e8_rr gc1_e8_rec 0 8.2e+06
ngc1_e8_sh1 gc1_e8_vm gc1_e8_rec gc1_e8_vms 0 nch W=2e-06 L=1e-06
va_ngc1_e8_sh2_s vrest ngc1_e8_sh2_s 0
ngc1_e8_sh2 gc1_e8_vms gc1_e8_qb ngc1_e8_sh2_s 0 nch W=2e-06 L=1e-06
ngc1_e8_porh gc1_e8_h por_hold vthe 0 nch W=2e-06 L=1e-06
va_ngc1_e8_porm_s vrest ngc1_e8_porm_s 0
ngc1_e8_porm gc1_e8_vm por_hold ngc1_e8_porm_s 0 nch W=2e-06 L=1e-06
ngc1_e8_ip gc1_e8_vm s1_yb vdd vsrc pch W=4e-06 L=4e-06
ngc1_e8_in gc1_e8_vm s1_za 0 0 nch W=4e-06 L=4e-06
ngc1_b8_sw gc1_b8_t gc1_e8_qb vdd vsrc pch W=2e-06 L=1e-06
rgc1_b8_rc gc1_b8_t gc1_b8 10000
cgc1_b8_c gc1_b8 0 1e-07
rgc1_b8_rl gc1_b8 0 2.2e+07
ngc1_b8_sh1p gc1_b8_n gc1_b8 vdd vsrc pch W=2.4e-06 L=5e-07
ngc1_b8_sh1n gc1_b8_n gc1_b8 0 0 nch W=1.2e-06 L=5e-07
ngc1_b8_sh2p gc1_b8_q gc1_b8_n vdd vsrc pch W=2.4e-06 L=5e-07
ngc1_b8_sh2n gc1_b8_q gc1_b8_n 0 0 nch W=1.2e-06 L=5e-07
cgc1_e9_cm gc1_e9_vm 0 1e-07
va_rgc1_e9_rm_n vrest rgc1_e9_rm_n 0
rgc1_e9_rm gc1_e9_vm rgc1_e9_rm_n 1e+06
ngc1_e9_bias0 gc1_e9_vm istep_n 0 0 nch W=4e-06 L=4e-06
ngc1_e9_bias1 gc1_e9_vm istep_n 0 0 nch W=4e-06 L=4e-06
ngc1_e9_bias2 gc1_e9_vm istep_n 0 0 nch W=4e-06 L=4e-06
ngc1_e9_bias3 gc1_e9_vm istep_n 0 0 nch W=4e-06 L=4e-06
ngc1_e9_bias4 gc1_e9_vm istep_n 0 0 nch W=4e-06 L=4e-06
ngc1_e9_bias5 gc1_e9_vm istep_n 0 0 nch W=4e-06 L=4e-06
ngc1_e9_bias6 gc1_e9_vm istep_n 0 0 nch W=4e-06 L=4e-06
ngc1_e9_bias7 gc1_e9_vm istep_n 0 0 nch W=4e-06 L=4e-06
ngc1_e9_bias8 gc1_e9_vm istep_n 0 0 nch W=4e-06 L=4e-06
rgc1_e9_kb vdd gc1_e9_knb 1e+06
ngc1_e9_kmb gc1_e9_knb gc1_e9_knb 0 0 nch W=4e-06 L=4e-06
ngc1_e9_kmt gc1_e9_ktail gc1_e9_knb 0 0 nch W=4e-06 L=4e-06
ngc1_e9_km1 gc1_e9_kd1 gc1_e9_vm gc1_e9_ktail 0 nch W=4e-06 L=4e-06
ngc1_e9_km2 gc1_e9_ko1 gc1_e9_h gc1_e9_ktail 0 nch W=4e-06 L=4e-06
ngc1_e9_km3 gc1_e9_kd1 gc1_e9_kd1 vdd vsrc pch W=4e-06 L=4e-06
ngc1_e9_km4 gc1_e9_ko1 gc1_e9_kd1 vdd vsrc pch W=4e-06 L=4e-06
ngc1_e9_kporclamp gc1_e9_ko1 por_hold 0 0 nch W=4e-06 L=1e-06
ngc1_e9_ki1p gc1_e9_qb gc1_e9_ko1 vdd vsrc pch W=2.4e-06 L=5e-07
ngc1_e9_ki1n gc1_e9_qb gc1_e9_ko1 0 0 nch W=1.2e-06 L=5e-07
ngc1_e9_ki2p gc1_e9_q gc1_e9_qb vdd vsrc pch W=2.4e-06 L=5e-07
ngc1_e9_ki2n gc1_e9_q gc1_e9_qb 0 0 nch W=1.2e-06 L=5e-07
rgc1_e9_hra gc1_e9_h vthe 1e+06
rgc1_e9_hrf gc1_e9_h gc1_e9_qb 1.9e+07
cgc1_e9_hc gc1_e9_h 0 2.1e-09
ngc1_e9_dis gc1_e9_vm gc1_e9_q gc1_e9_vmd 0 nch W=4e-06 L=1e-06
va_rgc1_e9_rdis_n vrest rgc1_e9_rdis_n 0
rgc1_e9_rdis gc1_e9_vmd rgc1_e9_rdis_n 220000
ngc1_e9_rp gc1_e9_rt gc1_e9_qb vdd vsrc pch W=2e-06 L=1e-06
rgc1_e9_rrc gc1_e9_rt gc1_e9_rec 10000
cgc1_e9_rc gc1_e9_rec 0 1e-07
rgc1_e9_rr gc1_e9_rec 0 8.2e+06
ngc1_e9_sh1 gc1_e9_vm gc1_e9_rec gc1_e9_vms 0 nch W=2e-06 L=1e-06
va_ngc1_e9_sh2_s vrest ngc1_e9_sh2_s 0
ngc1_e9_sh2 gc1_e9_vms gc1_e9_qb ngc1_e9_sh2_s 0 nch W=2e-06 L=1e-06
ngc1_e9_porh gc1_e9_h por_hold vthe 0 nch W=2e-06 L=1e-06
va_ngc1_e9_porm_s vrest ngc1_e9_porm_s 0
ngc1_e9_porm gc1_e9_vm por_hold ngc1_e9_porm_s 0 nch W=2e-06 L=1e-06
ngc1_e9_ip gc1_e9_vm s1_yb vdd vsrc pch W=4e-06 L=4e-06
ngc1_e9_in gc1_e9_vm s1_za 0 0 nch W=4e-06 L=4e-06
ngc1_b9_sw gc1_b9_t gc1_e9_qb vdd vsrc pch W=2e-06 L=1e-06
rgc1_b9_rc gc1_b9_t gc1_b9 10000
cgc1_b9_c gc1_b9 0 1e-07
rgc1_b9_rl gc1_b9 0 2.2e+07
ngc1_b9_sh1p gc1_b9_n gc1_b9 vdd vsrc pch W=2.4e-06 L=5e-07
ngc1_b9_sh1n gc1_b9_n gc1_b9 0 0 nch W=1.2e-06 L=5e-07
ngc1_b9_sh2p gc1_b9_q gc1_b9_n vdd vsrc pch W=2.4e-06 L=5e-07
ngc1_b9_sh2n gc1_b9_q gc1_b9_n 0 0 nch W=1.2e-06 L=5e-07
cgc1_e10_cm gc1_e10_vm 0 1e-07
va_rgc1_e10_rm_n vrest rgc1_e10_rm_n 0
rgc1_e10_rm gc1_e10_vm rgc1_e10_rm_n 1e+06
ngc1_e10_bias0 gc1_e10_vm istep_n 0 0 nch W=4e-06 L=4e-06
ngc1_e10_bias1 gc1_e10_vm istep_n 0 0 nch W=4e-06 L=4e-06
ngc1_e10_bias2 gc1_e10_vm istep_n 0 0 nch W=4e-06 L=4e-06
ngc1_e10_bias3 gc1_e10_vm istep_n 0 0 nch W=4e-06 L=4e-06
ngc1_e10_bias4 gc1_e10_vm istep_n 0 0 nch W=4e-06 L=4e-06
ngc1_e10_bias5 gc1_e10_vm istep_n 0 0 nch W=4e-06 L=4e-06
ngc1_e10_bias6 gc1_e10_vm istep_n 0 0 nch W=4e-06 L=4e-06
ngc1_e10_bias7 gc1_e10_vm istep_n 0 0 nch W=4e-06 L=4e-06
ngc1_e10_bias8 gc1_e10_vm istep_n 0 0 nch W=4e-06 L=4e-06
ngc1_e10_bias9 gc1_e10_vm istep_n 0 0 nch W=4e-06 L=4e-06
rgc1_e10_kb vdd gc1_e10_knb 1e+06
ngc1_e10_kmb gc1_e10_knb gc1_e10_knb 0 0 nch W=4e-06 L=4e-06
ngc1_e10_kmt gc1_e10_ktail gc1_e10_knb 0 0 nch W=4e-06 L=4e-06
ngc1_e10_km1 gc1_e10_kd1 gc1_e10_vm gc1_e10_ktail 0 nch W=4e-06 L=4e-06
ngc1_e10_km2 gc1_e10_ko1 gc1_e10_h gc1_e10_ktail 0 nch W=4e-06 L=4e-06
ngc1_e10_km3 gc1_e10_kd1 gc1_e10_kd1 vdd vsrc pch W=4e-06 L=4e-06
ngc1_e10_km4 gc1_e10_ko1 gc1_e10_kd1 vdd vsrc pch W=4e-06 L=4e-06
ngc1_e10_kporclamp gc1_e10_ko1 por_hold 0 0 nch W=4e-06 L=1e-06
ngc1_e10_ki1p gc1_e10_qb gc1_e10_ko1 vdd vsrc pch W=2.4e-06 L=5e-07
ngc1_e10_ki1n gc1_e10_qb gc1_e10_ko1 0 0 nch W=1.2e-06 L=5e-07
ngc1_e10_ki2p gc1_e10_q gc1_e10_qb vdd vsrc pch W=2.4e-06 L=5e-07
ngc1_e10_ki2n gc1_e10_q gc1_e10_qb 0 0 nch W=1.2e-06 L=5e-07
rgc1_e10_hra gc1_e10_h vthe 1e+06
rgc1_e10_hrf gc1_e10_h gc1_e10_qb 1.9e+07
cgc1_e10_hc gc1_e10_h 0 2.1e-09
ngc1_e10_dis gc1_e10_vm gc1_e10_q gc1_e10_vmd 0 nch W=4e-06 L=1e-06
va_rgc1_e10_rdis_n vrest rgc1_e10_rdis_n 0
rgc1_e10_rdis gc1_e10_vmd rgc1_e10_rdis_n 220000
ngc1_e10_rp gc1_e10_rt gc1_e10_qb vdd vsrc pch W=2e-06 L=1e-06
rgc1_e10_rrc gc1_e10_rt gc1_e10_rec 10000
cgc1_e10_rc gc1_e10_rec 0 1e-07
rgc1_e10_rr gc1_e10_rec 0 8.2e+06
ngc1_e10_sh1 gc1_e10_vm gc1_e10_rec gc1_e10_vms 0 nch W=2e-06 L=1e-06
va_ngc1_e10_sh2_s vrest ngc1_e10_sh2_s 0
ngc1_e10_sh2 gc1_e10_vms gc1_e10_qb ngc1_e10_sh2_s 0 nch W=2e-06 L=1e-06
ngc1_e10_porh gc1_e10_h por_hold vthe 0 nch W=2e-06 L=1e-06
va_ngc1_e10_porm_s vrest ngc1_e10_porm_s 0
ngc1_e10_porm gc1_e10_vm por_hold ngc1_e10_porm_s 0 nch W=2e-06 L=1e-06
ngc1_e10_ip gc1_e10_vm s1_yb vdd vsrc pch W=4e-06 L=4e-06
ngc1_e10_in gc1_e10_vm s1_za 0 0 nch W=4e-06 L=4e-06
ngc1_b10_sw gc1_b10_t gc1_e10_qb vdd vsrc pch W=2e-06 L=1e-06
rgc1_b10_rc gc1_b10_t gc1_b10 10000
cgc1_b10_c gc1_b10 0 1e-07
rgc1_b10_rl gc1_b10 0 2.2e+07
ngc1_b10_sh1p gc1_b10_n gc1_b10 vdd vsrc pch W=2.4e-06 L=5e-07
ngc1_b10_sh1n gc1_b10_n gc1_b10 0 0 nch W=1.2e-06 L=5e-07
ngc1_b10_sh2p gc1_b10_q gc1_b10_n vdd vsrc pch W=2.4e-06 L=5e-07
ngc1_b10_sh2n gc1_b10_q gc1_b10_n 0 0 nch W=1.2e-06 L=5e-07
ngc1_and_a0_npa gc1_and_a0_nb gc1_b1_q vdd vsrc pch W=2.4e-06 L=5e-07
ngc1_and_a0_npb gc1_and_a0_nb gc1_b2_q vdd vsrc pch W=2.4e-06 L=5e-07
ngc1_and_a0_nna gc1_and_a0_nb gc1_b1_q gc1_and_a0_nx 0 nch W=2.4e-06 L=5e-07
ngc1_and_a0_nnb gc1_and_a0_nx gc1_b2_q 0 0 nch W=2.4e-06 L=5e-07
ngc1_and_a0_ip gc1_and_g0 gc1_and_a0_nb vdd vsrc pch W=2.4e-06 L=5e-07
ngc1_and_a0_in gc1_and_g0 gc1_and_a0_nb 0 0 nch W=1.2e-06 L=5e-07
ngc1_and_a1_npa gc1_and_a1_nb gc1_b3_q vdd vsrc pch W=2.4e-06 L=5e-07
ngc1_and_a1_npb gc1_and_a1_nb gc1_b4_q vdd vsrc pch W=2.4e-06 L=5e-07
ngc1_and_a1_nna gc1_and_a1_nb gc1_b3_q gc1_and_a1_nx 0 nch W=2.4e-06 L=5e-07
ngc1_and_a1_nnb gc1_and_a1_nx gc1_b4_q 0 0 nch W=2.4e-06 L=5e-07
ngc1_and_a1_ip gc1_and_g1 gc1_and_a1_nb vdd vsrc pch W=2.4e-06 L=5e-07
ngc1_and_a1_in gc1_and_g1 gc1_and_a1_nb 0 0 nch W=1.2e-06 L=5e-07
ngc1_and_a2_npa gc1_and_a2_nb gc1_b5_q vdd vsrc pch W=2.4e-06 L=5e-07
ngc1_and_a2_npb gc1_and_a2_nb gc1_b6_q vdd vsrc pch W=2.4e-06 L=5e-07
ngc1_and_a2_nna gc1_and_a2_nb gc1_b5_q gc1_and_a2_nx 0 nch W=2.4e-06 L=5e-07
ngc1_and_a2_nnb gc1_and_a2_nx gc1_b6_q 0 0 nch W=2.4e-06 L=5e-07
ngc1_and_a2_ip gc1_and_g2 gc1_and_a2_nb vdd vsrc pch W=2.4e-06 L=5e-07
ngc1_and_a2_in gc1_and_g2 gc1_and_a2_nb 0 0 nch W=1.2e-06 L=5e-07
ngc1_and_a3_npa gc1_and_a3_nb gc1_b7_q vdd vsrc pch W=2.4e-06 L=5e-07
ngc1_and_a3_npb gc1_and_a3_nb gc1_b8_q vdd vsrc pch W=2.4e-06 L=5e-07
ngc1_and_a3_nna gc1_and_a3_nb gc1_b7_q gc1_and_a3_nx 0 nch W=2.4e-06 L=5e-07
ngc1_and_a3_nnb gc1_and_a3_nx gc1_b8_q 0 0 nch W=2.4e-06 L=5e-07
ngc1_and_a3_ip gc1_and_g3 gc1_and_a3_nb vdd vsrc pch W=2.4e-06 L=5e-07
ngc1_and_a3_in gc1_and_g3 gc1_and_a3_nb 0 0 nch W=1.2e-06 L=5e-07
ngc1_and_a4_npa gc1_and_a4_nb gc1_b9_q vdd vsrc pch W=2.4e-06 L=5e-07
ngc1_and_a4_npb gc1_and_a4_nb gc1_b10_q vdd vsrc pch W=2.4e-06 L=5e-07
ngc1_and_a4_nna gc1_and_a4_nb gc1_b9_q gc1_and_a4_nx 0 nch W=2.4e-06 L=5e-07
ngc1_and_a4_nnb gc1_and_a4_nx gc1_b10_q 0 0 nch W=2.4e-06 L=5e-07
ngc1_and_a4_ip gc1_and_g4 gc1_and_a4_nb vdd vsrc pch W=2.4e-06 L=5e-07
ngc1_and_a4_in gc1_and_g4 gc1_and_a4_nb 0 0 nch W=1.2e-06 L=5e-07
ngc1_and_a5_npa gc1_and_a5_nb gc1_and_g0 vdd vsrc pch W=2.4e-06 L=5e-07
ngc1_and_a5_npb gc1_and_a5_nb gc1_and_g1 vdd vsrc pch W=2.4e-06 L=5e-07
ngc1_and_a5_nna gc1_and_a5_nb gc1_and_g0 gc1_and_a5_nx 0 nch W=2.4e-06 L=5e-07
ngc1_and_a5_nnb gc1_and_a5_nx gc1_and_g1 0 0 nch W=2.4e-06 L=5e-07
ngc1_and_a5_ip gc1_and_g5 gc1_and_a5_nb vdd vsrc pch W=2.4e-06 L=5e-07
ngc1_and_a5_in gc1_and_g5 gc1_and_a5_nb 0 0 nch W=1.2e-06 L=5e-07
ngc1_and_a6_npa gc1_and_a6_nb gc1_and_g2 vdd vsrc pch W=2.4e-06 L=5e-07
ngc1_and_a6_npb gc1_and_a6_nb gc1_and_g3 vdd vsrc pch W=2.4e-06 L=5e-07
ngc1_and_a6_nna gc1_and_a6_nb gc1_and_g2 gc1_and_a6_nx 0 nch W=2.4e-06 L=5e-07
ngc1_and_a6_nnb gc1_and_a6_nx gc1_and_g3 0 0 nch W=2.4e-06 L=5e-07
ngc1_and_a6_ip gc1_and_g6 gc1_and_a6_nb vdd vsrc pch W=2.4e-06 L=5e-07
ngc1_and_a6_in gc1_and_g6 gc1_and_a6_nb 0 0 nch W=1.2e-06 L=5e-07
ngc1_and_a7_npa gc1_and_a7_nb gc1_and_g5 vdd vsrc pch W=2.4e-06 L=5e-07
ngc1_and_a7_npb gc1_and_a7_nb gc1_and_g6 vdd vsrc pch W=2.4e-06 L=5e-07
ngc1_and_a7_nna gc1_and_a7_nb gc1_and_g5 gc1_and_a7_nx 0 nch W=2.4e-06 L=5e-07
ngc1_and_a7_nnb gc1_and_a7_nx gc1_and_g6 0 0 nch W=2.4e-06 L=5e-07
ngc1_and_a7_ip gc1_and_g7 gc1_and_a7_nb vdd vsrc pch W=2.4e-06 L=5e-07
ngc1_and_a7_in gc1_and_g7 gc1_and_a7_nb 0 0 nch W=1.2e-06 L=5e-07
ngc1_and_a8_npa gc1_and_a8_nb gc1_and_g7 vdd vsrc pch W=2.4e-06 L=5e-07
ngc1_and_a8_npb gc1_and_a8_nb gc1_and_g4 vdd vsrc pch W=2.4e-06 L=5e-07
ngc1_and_a8_nna gc1_and_a8_nb gc1_and_g7 gc1_and_a8_nx 0 nch W=2.4e-06 L=5e-07
ngc1_and_a8_nnb gc1_and_a8_nx gc1_and_g4 0 0 nch W=2.4e-06 L=5e-07
ngc1_and_a8_ip gc1_and_g8 gc1_and_a8_nb vdd vsrc pch W=2.4e-06 L=5e-07
ngc1_and_a8_in gc1_and_g8 gc1_and_a8_nb 0 0 nch W=1.2e-06 L=5e-07
ngc1_gip gc1_gb gc1_and_g8 vdd vsrc pch W=2.4e-06 L=5e-07
ngc1_gin gc1_gb gc1_and_g8 0 0 nch W=1.2e-06 L=5e-07
cgc1_col_cm gc1_col_vm 0 1e-07
va_rgc1_col_rm_n vrest rgc1_col_rm_n 0
rgc1_col_rm gc1_col_vm rgc1_col_rm_n 1e+06
rgc1_col_kb vdd gc1_col_knb 1e+06
ngc1_col_kmb gc1_col_knb gc1_col_knb 0 0 nch W=4e-06 L=4e-06
ngc1_col_kmt gc1_col_ktail gc1_col_knb 0 0 nch W=4e-06 L=4e-06
ngc1_col_km1 gc1_col_kd1 gc1_col_vm gc1_col_ktail 0 nch W=4e-06 L=4e-06
ngc1_col_km2 gc1_col_ko1 gc1_col_h gc1_col_ktail 0 nch W=4e-06 L=4e-06
ngc1_col_km3 gc1_col_kd1 gc1_col_kd1 vdd vsrc pch W=4e-06 L=4e-06
ngc1_col_km4 gc1_col_ko1 gc1_col_kd1 vdd vsrc pch W=4e-06 L=4e-06
ngc1_col_kporclamp gc1_col_ko1 por_hold 0 0 nch W=4e-06 L=1e-06
ngc1_col_ki1p gc1_col_qb gc1_col_ko1 vdd vsrc pch W=2.4e-06 L=5e-07
ngc1_col_ki1n gc1_col_qb gc1_col_ko1 0 0 nch W=1.2e-06 L=5e-07
ngc1_col_ki2p gc1_col_q gc1_col_qb vdd vsrc pch W=2.4e-06 L=5e-07
ngc1_col_ki2n gc1_col_q gc1_col_qb 0 0 nch W=1.2e-06 L=5e-07
rgc1_col_hra gc1_col_h vthe 1e+06
rgc1_col_hrf gc1_col_h gc1_col_qb 1.9e+07
cgc1_col_hc gc1_col_h 0 2.1e-09
ngc1_col_dis gc1_col_vm gc1_col_q gc1_col_vmd 0 nch W=4e-06 L=1e-06
va_rgc1_col_rdis_n vrest rgc1_col_rdis_n 0
rgc1_col_rdis gc1_col_vmd rgc1_col_rdis_n 220000
ngc1_col_rp gc1_col_rt gc1_col_qb vdd vsrc pch W=2e-06 L=1e-06
rgc1_col_rrc gc1_col_rt gc1_col_rec 10000
cgc1_col_rc gc1_col_rec 0 1e-07
rgc1_col_rr gc1_col_rec 0 8.2e+06
ngc1_col_sh1 gc1_col_vm gc1_col_rec gc1_col_vms 0 nch W=2e-06 L=1e-06
va_ngc1_col_sh2_s vrest ngc1_col_sh2_s 0
ngc1_col_sh2 gc1_col_vms gc1_col_qb ngc1_col_sh2_s 0 nch W=2e-06 L=1e-06
ngc1_col_porh gc1_col_h por_hold vthe 0 nch W=2e-06 L=1e-06
va_ngc1_col_porm_s vrest ngc1_col_porm_s 0
ngc1_col_porm gc1_col_vm por_hold ngc1_col_porm_s 0 nch W=2e-06 L=1e-06
ngc1_cin_eni_p gc1_cin_ena gc1_gb vdd vsrc pch W=2.4e-06 L=5e-07
ngc1_cin_eni_n gc1_cin_ena gc1_gb 0 0 nch W=1.2e-06 L=5e-07
ngc1_cin_cp gc1_col_vm gc1_cin_cg vdd vsrc pch W=4e-06 L=4e-06
ngc1_cin_bias ilimp_n gc1_gb gc1_cin_cg vsrc pch W=1.2e-06 L=1e-06
ngc1_cin_off gc1_cin_cg gc1_cin_ena vdd vsrc pch W=2.4e-06 L=1e-06
ngc1_op_tsw gc1_op_tt gc1_col_qb vdd vsrc pch W=2e-06 L=1e-06
rgc1_op_trc gc1_op_tt gc1_op_at 10000
cgc1_op_tc gc1_op_at 0 1e-07
rgc1_op_trl gc1_op_at 0 2.2e+07
ngc1_op_sh1p gc1_op_an gc1_op_at vdd vsrc pch W=2.4e-06 L=5e-07
ngc1_op_sh1n gc1_op_an gc1_op_at 0 0 nch W=1.2e-06 L=5e-07
ngc1_op_sh2p gc1_op_aq gc1_op_an vdd vsrc pch W=2.4e-06 L=5e-07
ngc1_op_sh2n gc1_op_aq gc1_op_an 0 0 nch W=1.2e-06 L=5e-07
ngc1_op_abp gc1_op_aqb gc1_op_aq vdd vsrc pch W=2.4e-06 L=5e-07
ngc1_op_abn gc1_op_aqb gc1_op_aq 0 0 nch W=1.2e-06 L=5e-07
rgc1_op_dr gc1_op_aq gc1_op_ad 1e+06
cgc1_op_dc gc1_op_ad 0 3.3e-07
ngc1_op_d2p gc1_op_adn gc1_op_ad vdd vsrc pch W=2.4e-06 L=5e-07
ngc1_op_d2n gc1_op_adn gc1_op_ad 0 0 nch W=1.2e-06 L=5e-07
ngc1_op_gpa gc1_op_pb gc1_op_aq vdd vsrc pch W=2.4e-06 L=5e-07
ngc1_op_gpb gc1_op_pb gc1_op_adn vdd vsrc pch W=2.4e-06 L=5e-07
ngc1_op_gna gc1_op_pb gc1_op_aq gc1_op_gx 0 nch W=2.4e-06 L=5e-07
ngc1_op_gnb gc1_op_gx gc1_op_adn 0 0 nch W=2.4e-06 L=5e-07
ngc1_op_op gc1_op_p gc1_op_pb vdd vsrc pch W=2.4e-06 L=5e-07
ngc1_op_on gc1_op_p gc1_op_pb 0 0 nch W=1.2e-06 L=5e-07
cgw2_e1_cm gw2_e1_vm 0 1e-07
va_rgw2_e1_rm_n vrest rgw2_e1_rm_n 0
rgw2_e1_rm gw2_e1_vm rgw2_e1_rm_n 1e+06
ngw2_e1_bias0 gw2_e1_vm istep_n 0 0 nch W=4e-06 L=4e-06
rgw2_e1_kb vdd gw2_e1_knb 1e+06
ngw2_e1_kmb gw2_e1_knb gw2_e1_knb 0 0 nch W=4e-06 L=4e-06
ngw2_e1_kmt gw2_e1_ktail gw2_e1_knb 0 0 nch W=4e-06 L=4e-06
ngw2_e1_km1 gw2_e1_kd1 gw2_e1_vm gw2_e1_ktail 0 nch W=4e-06 L=4e-06
ngw2_e1_km2 gw2_e1_ko1 gw2_e1_h gw2_e1_ktail 0 nch W=4e-06 L=4e-06
ngw2_e1_km3 gw2_e1_kd1 gw2_e1_kd1 vdd vsrc pch W=4e-06 L=4e-06
ngw2_e1_km4 gw2_e1_ko1 gw2_e1_kd1 vdd vsrc pch W=4e-06 L=4e-06
ngw2_e1_kporclamp gw2_e1_ko1 por_hold 0 0 nch W=4e-06 L=1e-06
ngw2_e1_ki1p gw2_e1_qb gw2_e1_ko1 vdd vsrc pch W=2.4e-06 L=5e-07
ngw2_e1_ki1n gw2_e1_qb gw2_e1_ko1 0 0 nch W=1.2e-06 L=5e-07
ngw2_e1_ki2p gw2_e1_q gw2_e1_qb vdd vsrc pch W=2.4e-06 L=5e-07
ngw2_e1_ki2n gw2_e1_q gw2_e1_qb 0 0 nch W=1.2e-06 L=5e-07
rgw2_e1_hra gw2_e1_h vthe 1e+06
rgw2_e1_hrf gw2_e1_h gw2_e1_qb 1.9e+07
cgw2_e1_hc gw2_e1_h 0 2.1e-09
ngw2_e1_dis gw2_e1_vm gw2_e1_q gw2_e1_vmd 0 nch W=4e-06 L=1e-06
va_rgw2_e1_rdis_n vrest rgw2_e1_rdis_n 0
rgw2_e1_rdis gw2_e1_vmd rgw2_e1_rdis_n 220000
ngw2_e1_rp gw2_e1_rt gw2_e1_qb vdd vsrc pch W=2e-06 L=1e-06
rgw2_e1_rrc gw2_e1_rt gw2_e1_rec 10000
cgw2_e1_rc gw2_e1_rec 0 1e-07
rgw2_e1_rr gw2_e1_rec 0 8.2e+06
ngw2_e1_sh1 gw2_e1_vm gw2_e1_rec gw2_e1_vms 0 nch W=2e-06 L=1e-06
va_ngw2_e1_sh2_s vrest ngw2_e1_sh2_s 0
ngw2_e1_sh2 gw2_e1_vms gw2_e1_qb ngw2_e1_sh2_s 0 nch W=2e-06 L=1e-06
ngw2_e1_porh gw2_e1_h por_hold vthe 0 nch W=2e-06 L=1e-06
va_ngw2_e1_porm_s vrest ngw2_e1_porm_s 0
ngw2_e1_porm gw2_e1_vm por_hold ngw2_e1_porm_s 0 nch W=2e-06 L=1e-06
ngw2_e1_ip gw2_e1_vm s2_ya vdd vsrc pch W=4e-06 L=4e-06
ngw2_e1_in gw2_e1_vm s2_zb 0 0 nch W=4e-06 L=4e-06
ngw2_b1_sw gw2_b1_t gw2_e1_qb vdd vsrc pch W=2e-06 L=1e-06
rgw2_b1_rc gw2_b1_t gw2_b1 10000
cgw2_b1_c gw2_b1 0 1e-07
rgw2_b1_rl gw2_b1 0 2.2e+07
ngw2_b1_sh1p gw2_b1_n gw2_b1 vdd vsrc pch W=2.4e-06 L=5e-07
ngw2_b1_sh1n gw2_b1_n gw2_b1 0 0 nch W=1.2e-06 L=5e-07
ngw2_b1_sh2p gw2_b1_q gw2_b1_n vdd vsrc pch W=2.4e-06 L=5e-07
ngw2_b1_sh2n gw2_b1_q gw2_b1_n 0 0 nch W=1.2e-06 L=5e-07
cgw2_e2_cm gw2_e2_vm 0 1e-07
va_rgw2_e2_rm_n vrest rgw2_e2_rm_n 0
rgw2_e2_rm gw2_e2_vm rgw2_e2_rm_n 1e+06
ngw2_e2_bias0 gw2_e2_vm istep_n 0 0 nch W=4e-06 L=4e-06
ngw2_e2_bias1 gw2_e2_vm istep_n 0 0 nch W=4e-06 L=4e-06
rgw2_e2_kb vdd gw2_e2_knb 1e+06
ngw2_e2_kmb gw2_e2_knb gw2_e2_knb 0 0 nch W=4e-06 L=4e-06
ngw2_e2_kmt gw2_e2_ktail gw2_e2_knb 0 0 nch W=4e-06 L=4e-06
ngw2_e2_km1 gw2_e2_kd1 gw2_e2_vm gw2_e2_ktail 0 nch W=4e-06 L=4e-06
ngw2_e2_km2 gw2_e2_ko1 gw2_e2_h gw2_e2_ktail 0 nch W=4e-06 L=4e-06
ngw2_e2_km3 gw2_e2_kd1 gw2_e2_kd1 vdd vsrc pch W=4e-06 L=4e-06
ngw2_e2_km4 gw2_e2_ko1 gw2_e2_kd1 vdd vsrc pch W=4e-06 L=4e-06
ngw2_e2_kporclamp gw2_e2_ko1 por_hold 0 0 nch W=4e-06 L=1e-06
ngw2_e2_ki1p gw2_e2_qb gw2_e2_ko1 vdd vsrc pch W=2.4e-06 L=5e-07
ngw2_e2_ki1n gw2_e2_qb gw2_e2_ko1 0 0 nch W=1.2e-06 L=5e-07
ngw2_e2_ki2p gw2_e2_q gw2_e2_qb vdd vsrc pch W=2.4e-06 L=5e-07
ngw2_e2_ki2n gw2_e2_q gw2_e2_qb 0 0 nch W=1.2e-06 L=5e-07
rgw2_e2_hra gw2_e2_h vthe 1e+06
rgw2_e2_hrf gw2_e2_h gw2_e2_qb 1.9e+07
cgw2_e2_hc gw2_e2_h 0 2.1e-09
ngw2_e2_dis gw2_e2_vm gw2_e2_q gw2_e2_vmd 0 nch W=4e-06 L=1e-06
va_rgw2_e2_rdis_n vrest rgw2_e2_rdis_n 0
rgw2_e2_rdis gw2_e2_vmd rgw2_e2_rdis_n 220000
ngw2_e2_rp gw2_e2_rt gw2_e2_qb vdd vsrc pch W=2e-06 L=1e-06
rgw2_e2_rrc gw2_e2_rt gw2_e2_rec 10000
cgw2_e2_rc gw2_e2_rec 0 1e-07
rgw2_e2_rr gw2_e2_rec 0 8.2e+06
ngw2_e2_sh1 gw2_e2_vm gw2_e2_rec gw2_e2_vms 0 nch W=2e-06 L=1e-06
va_ngw2_e2_sh2_s vrest ngw2_e2_sh2_s 0
ngw2_e2_sh2 gw2_e2_vms gw2_e2_qb ngw2_e2_sh2_s 0 nch W=2e-06 L=1e-06
ngw2_e2_porh gw2_e2_h por_hold vthe 0 nch W=2e-06 L=1e-06
va_ngw2_e2_porm_s vrest ngw2_e2_porm_s 0
ngw2_e2_porm gw2_e2_vm por_hold ngw2_e2_porm_s 0 nch W=2e-06 L=1e-06
ngw2_e2_ip gw2_e2_vm s2_ya vdd vsrc pch W=4e-06 L=4e-06
ngw2_e2_in gw2_e2_vm s2_zb 0 0 nch W=4e-06 L=4e-06
ngw2_b2_sw gw2_b2_t gw2_e2_qb vdd vsrc pch W=2e-06 L=1e-06
rgw2_b2_rc gw2_b2_t gw2_b2 10000
cgw2_b2_c gw2_b2 0 1e-07
rgw2_b2_rl gw2_b2 0 2.2e+07
ngw2_b2_sh1p gw2_b2_n gw2_b2 vdd vsrc pch W=2.4e-06 L=5e-07
ngw2_b2_sh1n gw2_b2_n gw2_b2 0 0 nch W=1.2e-06 L=5e-07
ngw2_b2_sh2p gw2_b2_q gw2_b2_n vdd vsrc pch W=2.4e-06 L=5e-07
ngw2_b2_sh2n gw2_b2_q gw2_b2_n 0 0 nch W=1.2e-06 L=5e-07
cgw2_e3_cm gw2_e3_vm 0 1e-07
va_rgw2_e3_rm_n vrest rgw2_e3_rm_n 0
rgw2_e3_rm gw2_e3_vm rgw2_e3_rm_n 1e+06
ngw2_e3_bias0 gw2_e3_vm istep_n 0 0 nch W=4e-06 L=4e-06
ngw2_e3_bias1 gw2_e3_vm istep_n 0 0 nch W=4e-06 L=4e-06
ngw2_e3_bias2 gw2_e3_vm istep_n 0 0 nch W=4e-06 L=4e-06
rgw2_e3_kb vdd gw2_e3_knb 1e+06
ngw2_e3_kmb gw2_e3_knb gw2_e3_knb 0 0 nch W=4e-06 L=4e-06
ngw2_e3_kmt gw2_e3_ktail gw2_e3_knb 0 0 nch W=4e-06 L=4e-06
ngw2_e3_km1 gw2_e3_kd1 gw2_e3_vm gw2_e3_ktail 0 nch W=4e-06 L=4e-06
ngw2_e3_km2 gw2_e3_ko1 gw2_e3_h gw2_e3_ktail 0 nch W=4e-06 L=4e-06
ngw2_e3_km3 gw2_e3_kd1 gw2_e3_kd1 vdd vsrc pch W=4e-06 L=4e-06
ngw2_e3_km4 gw2_e3_ko1 gw2_e3_kd1 vdd vsrc pch W=4e-06 L=4e-06
ngw2_e3_kporclamp gw2_e3_ko1 por_hold 0 0 nch W=4e-06 L=1e-06
ngw2_e3_ki1p gw2_e3_qb gw2_e3_ko1 vdd vsrc pch W=2.4e-06 L=5e-07
ngw2_e3_ki1n gw2_e3_qb gw2_e3_ko1 0 0 nch W=1.2e-06 L=5e-07
ngw2_e3_ki2p gw2_e3_q gw2_e3_qb vdd vsrc pch W=2.4e-06 L=5e-07
ngw2_e3_ki2n gw2_e3_q gw2_e3_qb 0 0 nch W=1.2e-06 L=5e-07
rgw2_e3_hra gw2_e3_h vthe 1e+06
rgw2_e3_hrf gw2_e3_h gw2_e3_qb 1.9e+07
cgw2_e3_hc gw2_e3_h 0 2.1e-09
ngw2_e3_dis gw2_e3_vm gw2_e3_q gw2_e3_vmd 0 nch W=4e-06 L=1e-06
va_rgw2_e3_rdis_n vrest rgw2_e3_rdis_n 0
rgw2_e3_rdis gw2_e3_vmd rgw2_e3_rdis_n 220000
ngw2_e3_rp gw2_e3_rt gw2_e3_qb vdd vsrc pch W=2e-06 L=1e-06
rgw2_e3_rrc gw2_e3_rt gw2_e3_rec 10000
cgw2_e3_rc gw2_e3_rec 0 1e-07
rgw2_e3_rr gw2_e3_rec 0 8.2e+06
ngw2_e3_sh1 gw2_e3_vm gw2_e3_rec gw2_e3_vms 0 nch W=2e-06 L=1e-06
va_ngw2_e3_sh2_s vrest ngw2_e3_sh2_s 0
ngw2_e3_sh2 gw2_e3_vms gw2_e3_qb ngw2_e3_sh2_s 0 nch W=2e-06 L=1e-06
ngw2_e3_porh gw2_e3_h por_hold vthe 0 nch W=2e-06 L=1e-06
va_ngw2_e3_porm_s vrest ngw2_e3_porm_s 0
ngw2_e3_porm gw2_e3_vm por_hold ngw2_e3_porm_s 0 nch W=2e-06 L=1e-06
ngw2_e3_ip gw2_e3_vm s2_ya vdd vsrc pch W=4e-06 L=4e-06
ngw2_e3_in gw2_e3_vm s2_zb 0 0 nch W=4e-06 L=4e-06
ngw2_b3_sw gw2_b3_t gw2_e3_qb vdd vsrc pch W=2e-06 L=1e-06
rgw2_b3_rc gw2_b3_t gw2_b3 10000
cgw2_b3_c gw2_b3 0 1e-07
rgw2_b3_rl gw2_b3 0 2.2e+07
ngw2_b3_sh1p gw2_b3_n gw2_b3 vdd vsrc pch W=2.4e-06 L=5e-07
ngw2_b3_sh1n gw2_b3_n gw2_b3 0 0 nch W=1.2e-06 L=5e-07
ngw2_b3_sh2p gw2_b3_q gw2_b3_n vdd vsrc pch W=2.4e-06 L=5e-07
ngw2_b3_sh2n gw2_b3_q gw2_b3_n 0 0 nch W=1.2e-06 L=5e-07
cgw2_e4_cm gw2_e4_vm 0 1e-07
va_rgw2_e4_rm_n vrest rgw2_e4_rm_n 0
rgw2_e4_rm gw2_e4_vm rgw2_e4_rm_n 1e+06
ngw2_e4_bias0 gw2_e4_vm istep_n 0 0 nch W=4e-06 L=4e-06
ngw2_e4_bias1 gw2_e4_vm istep_n 0 0 nch W=4e-06 L=4e-06
ngw2_e4_bias2 gw2_e4_vm istep_n 0 0 nch W=4e-06 L=4e-06
ngw2_e4_bias3 gw2_e4_vm istep_n 0 0 nch W=4e-06 L=4e-06
rgw2_e4_kb vdd gw2_e4_knb 1e+06
ngw2_e4_kmb gw2_e4_knb gw2_e4_knb 0 0 nch W=4e-06 L=4e-06
ngw2_e4_kmt gw2_e4_ktail gw2_e4_knb 0 0 nch W=4e-06 L=4e-06
ngw2_e4_km1 gw2_e4_kd1 gw2_e4_vm gw2_e4_ktail 0 nch W=4e-06 L=4e-06
ngw2_e4_km2 gw2_e4_ko1 gw2_e4_h gw2_e4_ktail 0 nch W=4e-06 L=4e-06
ngw2_e4_km3 gw2_e4_kd1 gw2_e4_kd1 vdd vsrc pch W=4e-06 L=4e-06
ngw2_e4_km4 gw2_e4_ko1 gw2_e4_kd1 vdd vsrc pch W=4e-06 L=4e-06
ngw2_e4_kporclamp gw2_e4_ko1 por_hold 0 0 nch W=4e-06 L=1e-06
ngw2_e4_ki1p gw2_e4_qb gw2_e4_ko1 vdd vsrc pch W=2.4e-06 L=5e-07
ngw2_e4_ki1n gw2_e4_qb gw2_e4_ko1 0 0 nch W=1.2e-06 L=5e-07
ngw2_e4_ki2p gw2_e4_q gw2_e4_qb vdd vsrc pch W=2.4e-06 L=5e-07
ngw2_e4_ki2n gw2_e4_q gw2_e4_qb 0 0 nch W=1.2e-06 L=5e-07
rgw2_e4_hra gw2_e4_h vthe 1e+06
rgw2_e4_hrf gw2_e4_h gw2_e4_qb 1.9e+07
cgw2_e4_hc gw2_e4_h 0 2.1e-09
ngw2_e4_dis gw2_e4_vm gw2_e4_q gw2_e4_vmd 0 nch W=4e-06 L=1e-06
va_rgw2_e4_rdis_n vrest rgw2_e4_rdis_n 0
rgw2_e4_rdis gw2_e4_vmd rgw2_e4_rdis_n 220000
ngw2_e4_rp gw2_e4_rt gw2_e4_qb vdd vsrc pch W=2e-06 L=1e-06
rgw2_e4_rrc gw2_e4_rt gw2_e4_rec 10000
cgw2_e4_rc gw2_e4_rec 0 1e-07
rgw2_e4_rr gw2_e4_rec 0 8.2e+06
ngw2_e4_sh1 gw2_e4_vm gw2_e4_rec gw2_e4_vms 0 nch W=2e-06 L=1e-06
va_ngw2_e4_sh2_s vrest ngw2_e4_sh2_s 0
ngw2_e4_sh2 gw2_e4_vms gw2_e4_qb ngw2_e4_sh2_s 0 nch W=2e-06 L=1e-06
ngw2_e4_porh gw2_e4_h por_hold vthe 0 nch W=2e-06 L=1e-06
va_ngw2_e4_porm_s vrest ngw2_e4_porm_s 0
ngw2_e4_porm gw2_e4_vm por_hold ngw2_e4_porm_s 0 nch W=2e-06 L=1e-06
ngw2_e4_ip gw2_e4_vm s2_ya vdd vsrc pch W=4e-06 L=4e-06
ngw2_e4_in gw2_e4_vm s2_zb 0 0 nch W=4e-06 L=4e-06
ngw2_b4_sw gw2_b4_t gw2_e4_qb vdd vsrc pch W=2e-06 L=1e-06
rgw2_b4_rc gw2_b4_t gw2_b4 10000
cgw2_b4_c gw2_b4 0 1e-07
rgw2_b4_rl gw2_b4 0 2.2e+07
ngw2_b4_sh1p gw2_b4_n gw2_b4 vdd vsrc pch W=2.4e-06 L=5e-07
ngw2_b4_sh1n gw2_b4_n gw2_b4 0 0 nch W=1.2e-06 L=5e-07
ngw2_b4_sh2p gw2_b4_q gw2_b4_n vdd vsrc pch W=2.4e-06 L=5e-07
ngw2_b4_sh2n gw2_b4_q gw2_b4_n 0 0 nch W=1.2e-06 L=5e-07
cgw2_e5_cm gw2_e5_vm 0 1e-07
va_rgw2_e5_rm_n vrest rgw2_e5_rm_n 0
rgw2_e5_rm gw2_e5_vm rgw2_e5_rm_n 1e+06
ngw2_e5_bias0 gw2_e5_vm istep_n 0 0 nch W=4e-06 L=4e-06
ngw2_e5_bias1 gw2_e5_vm istep_n 0 0 nch W=4e-06 L=4e-06
ngw2_e5_bias2 gw2_e5_vm istep_n 0 0 nch W=4e-06 L=4e-06
ngw2_e5_bias3 gw2_e5_vm istep_n 0 0 nch W=4e-06 L=4e-06
ngw2_e5_bias4 gw2_e5_vm istep_n 0 0 nch W=4e-06 L=4e-06
rgw2_e5_kb vdd gw2_e5_knb 1e+06
ngw2_e5_kmb gw2_e5_knb gw2_e5_knb 0 0 nch W=4e-06 L=4e-06
ngw2_e5_kmt gw2_e5_ktail gw2_e5_knb 0 0 nch W=4e-06 L=4e-06
ngw2_e5_km1 gw2_e5_kd1 gw2_e5_vm gw2_e5_ktail 0 nch W=4e-06 L=4e-06
ngw2_e5_km2 gw2_e5_ko1 gw2_e5_h gw2_e5_ktail 0 nch W=4e-06 L=4e-06
ngw2_e5_km3 gw2_e5_kd1 gw2_e5_kd1 vdd vsrc pch W=4e-06 L=4e-06
ngw2_e5_km4 gw2_e5_ko1 gw2_e5_kd1 vdd vsrc pch W=4e-06 L=4e-06
ngw2_e5_kporclamp gw2_e5_ko1 por_hold 0 0 nch W=4e-06 L=1e-06
ngw2_e5_ki1p gw2_e5_qb gw2_e5_ko1 vdd vsrc pch W=2.4e-06 L=5e-07
ngw2_e5_ki1n gw2_e5_qb gw2_e5_ko1 0 0 nch W=1.2e-06 L=5e-07
ngw2_e5_ki2p gw2_e5_q gw2_e5_qb vdd vsrc pch W=2.4e-06 L=5e-07
ngw2_e5_ki2n gw2_e5_q gw2_e5_qb 0 0 nch W=1.2e-06 L=5e-07
rgw2_e5_hra gw2_e5_h vthe 1e+06
rgw2_e5_hrf gw2_e5_h gw2_e5_qb 1.9e+07
cgw2_e5_hc gw2_e5_h 0 2.1e-09
ngw2_e5_dis gw2_e5_vm gw2_e5_q gw2_e5_vmd 0 nch W=4e-06 L=1e-06
va_rgw2_e5_rdis_n vrest rgw2_e5_rdis_n 0
rgw2_e5_rdis gw2_e5_vmd rgw2_e5_rdis_n 220000
ngw2_e5_rp gw2_e5_rt gw2_e5_qb vdd vsrc pch W=2e-06 L=1e-06
rgw2_e5_rrc gw2_e5_rt gw2_e5_rec 10000
cgw2_e5_rc gw2_e5_rec 0 1e-07
rgw2_e5_rr gw2_e5_rec 0 8.2e+06
ngw2_e5_sh1 gw2_e5_vm gw2_e5_rec gw2_e5_vms 0 nch W=2e-06 L=1e-06
va_ngw2_e5_sh2_s vrest ngw2_e5_sh2_s 0
ngw2_e5_sh2 gw2_e5_vms gw2_e5_qb ngw2_e5_sh2_s 0 nch W=2e-06 L=1e-06
ngw2_e5_porh gw2_e5_h por_hold vthe 0 nch W=2e-06 L=1e-06
va_ngw2_e5_porm_s vrest ngw2_e5_porm_s 0
ngw2_e5_porm gw2_e5_vm por_hold ngw2_e5_porm_s 0 nch W=2e-06 L=1e-06
ngw2_e5_ip gw2_e5_vm s2_ya vdd vsrc pch W=4e-06 L=4e-06
ngw2_e5_in gw2_e5_vm s2_zb 0 0 nch W=4e-06 L=4e-06
ngw2_b5_sw gw2_b5_t gw2_e5_qb vdd vsrc pch W=2e-06 L=1e-06
rgw2_b5_rc gw2_b5_t gw2_b5 10000
cgw2_b5_c gw2_b5 0 1e-07
rgw2_b5_rl gw2_b5 0 2.2e+07
ngw2_b5_sh1p gw2_b5_n gw2_b5 vdd vsrc pch W=2.4e-06 L=5e-07
ngw2_b5_sh1n gw2_b5_n gw2_b5 0 0 nch W=1.2e-06 L=5e-07
ngw2_b5_sh2p gw2_b5_q gw2_b5_n vdd vsrc pch W=2.4e-06 L=5e-07
ngw2_b5_sh2n gw2_b5_q gw2_b5_n 0 0 nch W=1.2e-06 L=5e-07
cgw2_e6_cm gw2_e6_vm 0 1e-07
va_rgw2_e6_rm_n vrest rgw2_e6_rm_n 0
rgw2_e6_rm gw2_e6_vm rgw2_e6_rm_n 1e+06
ngw2_e6_bias0 gw2_e6_vm istep_n 0 0 nch W=4e-06 L=4e-06
ngw2_e6_bias1 gw2_e6_vm istep_n 0 0 nch W=4e-06 L=4e-06
ngw2_e6_bias2 gw2_e6_vm istep_n 0 0 nch W=4e-06 L=4e-06
ngw2_e6_bias3 gw2_e6_vm istep_n 0 0 nch W=4e-06 L=4e-06
ngw2_e6_bias4 gw2_e6_vm istep_n 0 0 nch W=4e-06 L=4e-06
ngw2_e6_bias5 gw2_e6_vm istep_n 0 0 nch W=4e-06 L=4e-06
rgw2_e6_kb vdd gw2_e6_knb 1e+06
ngw2_e6_kmb gw2_e6_knb gw2_e6_knb 0 0 nch W=4e-06 L=4e-06
ngw2_e6_kmt gw2_e6_ktail gw2_e6_knb 0 0 nch W=4e-06 L=4e-06
ngw2_e6_km1 gw2_e6_kd1 gw2_e6_vm gw2_e6_ktail 0 nch W=4e-06 L=4e-06
ngw2_e6_km2 gw2_e6_ko1 gw2_e6_h gw2_e6_ktail 0 nch W=4e-06 L=4e-06
ngw2_e6_km3 gw2_e6_kd1 gw2_e6_kd1 vdd vsrc pch W=4e-06 L=4e-06
ngw2_e6_km4 gw2_e6_ko1 gw2_e6_kd1 vdd vsrc pch W=4e-06 L=4e-06
ngw2_e6_kporclamp gw2_e6_ko1 por_hold 0 0 nch W=4e-06 L=1e-06
ngw2_e6_ki1p gw2_e6_qb gw2_e6_ko1 vdd vsrc pch W=2.4e-06 L=5e-07
ngw2_e6_ki1n gw2_e6_qb gw2_e6_ko1 0 0 nch W=1.2e-06 L=5e-07
ngw2_e6_ki2p gw2_e6_q gw2_e6_qb vdd vsrc pch W=2.4e-06 L=5e-07
ngw2_e6_ki2n gw2_e6_q gw2_e6_qb 0 0 nch W=1.2e-06 L=5e-07
rgw2_e6_hra gw2_e6_h vthe 1e+06
rgw2_e6_hrf gw2_e6_h gw2_e6_qb 1.9e+07
cgw2_e6_hc gw2_e6_h 0 2.1e-09
ngw2_e6_dis gw2_e6_vm gw2_e6_q gw2_e6_vmd 0 nch W=4e-06 L=1e-06
va_rgw2_e6_rdis_n vrest rgw2_e6_rdis_n 0
rgw2_e6_rdis gw2_e6_vmd rgw2_e6_rdis_n 220000
ngw2_e6_rp gw2_e6_rt gw2_e6_qb vdd vsrc pch W=2e-06 L=1e-06
rgw2_e6_rrc gw2_e6_rt gw2_e6_rec 10000
cgw2_e6_rc gw2_e6_rec 0 1e-07
rgw2_e6_rr gw2_e6_rec 0 8.2e+06
ngw2_e6_sh1 gw2_e6_vm gw2_e6_rec gw2_e6_vms 0 nch W=2e-06 L=1e-06
va_ngw2_e6_sh2_s vrest ngw2_e6_sh2_s 0
ngw2_e6_sh2 gw2_e6_vms gw2_e6_qb ngw2_e6_sh2_s 0 nch W=2e-06 L=1e-06
ngw2_e6_porh gw2_e6_h por_hold vthe 0 nch W=2e-06 L=1e-06
va_ngw2_e6_porm_s vrest ngw2_e6_porm_s 0
ngw2_e6_porm gw2_e6_vm por_hold ngw2_e6_porm_s 0 nch W=2e-06 L=1e-06
ngw2_e6_ip gw2_e6_vm s2_ya vdd vsrc pch W=4e-06 L=4e-06
ngw2_e6_in gw2_e6_vm s2_zb 0 0 nch W=4e-06 L=4e-06
ngw2_b6_sw gw2_b6_t gw2_e6_qb vdd vsrc pch W=2e-06 L=1e-06
rgw2_b6_rc gw2_b6_t gw2_b6 10000
cgw2_b6_c gw2_b6 0 1e-07
rgw2_b6_rl gw2_b6 0 2.2e+07
ngw2_b6_sh1p gw2_b6_n gw2_b6 vdd vsrc pch W=2.4e-06 L=5e-07
ngw2_b6_sh1n gw2_b6_n gw2_b6 0 0 nch W=1.2e-06 L=5e-07
ngw2_b6_sh2p gw2_b6_q gw2_b6_n vdd vsrc pch W=2.4e-06 L=5e-07
ngw2_b6_sh2n gw2_b6_q gw2_b6_n 0 0 nch W=1.2e-06 L=5e-07
cgw2_e7_cm gw2_e7_vm 0 1e-07
va_rgw2_e7_rm_n vrest rgw2_e7_rm_n 0
rgw2_e7_rm gw2_e7_vm rgw2_e7_rm_n 1e+06
ngw2_e7_bias0 gw2_e7_vm istep_n 0 0 nch W=4e-06 L=4e-06
ngw2_e7_bias1 gw2_e7_vm istep_n 0 0 nch W=4e-06 L=4e-06
ngw2_e7_bias2 gw2_e7_vm istep_n 0 0 nch W=4e-06 L=4e-06
ngw2_e7_bias3 gw2_e7_vm istep_n 0 0 nch W=4e-06 L=4e-06
ngw2_e7_bias4 gw2_e7_vm istep_n 0 0 nch W=4e-06 L=4e-06
ngw2_e7_bias5 gw2_e7_vm istep_n 0 0 nch W=4e-06 L=4e-06
ngw2_e7_bias6 gw2_e7_vm istep_n 0 0 nch W=4e-06 L=4e-06
rgw2_e7_kb vdd gw2_e7_knb 1e+06
ngw2_e7_kmb gw2_e7_knb gw2_e7_knb 0 0 nch W=4e-06 L=4e-06
ngw2_e7_kmt gw2_e7_ktail gw2_e7_knb 0 0 nch W=4e-06 L=4e-06
ngw2_e7_km1 gw2_e7_kd1 gw2_e7_vm gw2_e7_ktail 0 nch W=4e-06 L=4e-06
ngw2_e7_km2 gw2_e7_ko1 gw2_e7_h gw2_e7_ktail 0 nch W=4e-06 L=4e-06
ngw2_e7_km3 gw2_e7_kd1 gw2_e7_kd1 vdd vsrc pch W=4e-06 L=4e-06
ngw2_e7_km4 gw2_e7_ko1 gw2_e7_kd1 vdd vsrc pch W=4e-06 L=4e-06
ngw2_e7_kporclamp gw2_e7_ko1 por_hold 0 0 nch W=4e-06 L=1e-06
ngw2_e7_ki1p gw2_e7_qb gw2_e7_ko1 vdd vsrc pch W=2.4e-06 L=5e-07
ngw2_e7_ki1n gw2_e7_qb gw2_e7_ko1 0 0 nch W=1.2e-06 L=5e-07
ngw2_e7_ki2p gw2_e7_q gw2_e7_qb vdd vsrc pch W=2.4e-06 L=5e-07
ngw2_e7_ki2n gw2_e7_q gw2_e7_qb 0 0 nch W=1.2e-06 L=5e-07
rgw2_e7_hra gw2_e7_h vthe 1e+06
rgw2_e7_hrf gw2_e7_h gw2_e7_qb 1.9e+07
cgw2_e7_hc gw2_e7_h 0 2.1e-09
ngw2_e7_dis gw2_e7_vm gw2_e7_q gw2_e7_vmd 0 nch W=4e-06 L=1e-06
va_rgw2_e7_rdis_n vrest rgw2_e7_rdis_n 0
rgw2_e7_rdis gw2_e7_vmd rgw2_e7_rdis_n 220000
ngw2_e7_rp gw2_e7_rt gw2_e7_qb vdd vsrc pch W=2e-06 L=1e-06
rgw2_e7_rrc gw2_e7_rt gw2_e7_rec 10000
cgw2_e7_rc gw2_e7_rec 0 1e-07
rgw2_e7_rr gw2_e7_rec 0 8.2e+06
ngw2_e7_sh1 gw2_e7_vm gw2_e7_rec gw2_e7_vms 0 nch W=2e-06 L=1e-06
va_ngw2_e7_sh2_s vrest ngw2_e7_sh2_s 0
ngw2_e7_sh2 gw2_e7_vms gw2_e7_qb ngw2_e7_sh2_s 0 nch W=2e-06 L=1e-06
ngw2_e7_porh gw2_e7_h por_hold vthe 0 nch W=2e-06 L=1e-06
va_ngw2_e7_porm_s vrest ngw2_e7_porm_s 0
ngw2_e7_porm gw2_e7_vm por_hold ngw2_e7_porm_s 0 nch W=2e-06 L=1e-06
ngw2_e7_ip gw2_e7_vm s2_ya vdd vsrc pch W=4e-06 L=4e-06
ngw2_e7_in gw2_e7_vm s2_zb 0 0 nch W=4e-06 L=4e-06
ngw2_b7_sw gw2_b7_t gw2_e7_qb vdd vsrc pch W=2e-06 L=1e-06
rgw2_b7_rc gw2_b7_t gw2_b7 10000
cgw2_b7_c gw2_b7 0 1e-07
rgw2_b7_rl gw2_b7 0 2.2e+07
ngw2_b7_sh1p gw2_b7_n gw2_b7 vdd vsrc pch W=2.4e-06 L=5e-07
ngw2_b7_sh1n gw2_b7_n gw2_b7 0 0 nch W=1.2e-06 L=5e-07
ngw2_b7_sh2p gw2_b7_q gw2_b7_n vdd vsrc pch W=2.4e-06 L=5e-07
ngw2_b7_sh2n gw2_b7_q gw2_b7_n 0 0 nch W=1.2e-06 L=5e-07
cgw2_e8_cm gw2_e8_vm 0 1e-07
va_rgw2_e8_rm_n vrest rgw2_e8_rm_n 0
rgw2_e8_rm gw2_e8_vm rgw2_e8_rm_n 1e+06
ngw2_e8_bias0 gw2_e8_vm istep_n 0 0 nch W=4e-06 L=4e-06
ngw2_e8_bias1 gw2_e8_vm istep_n 0 0 nch W=4e-06 L=4e-06
ngw2_e8_bias2 gw2_e8_vm istep_n 0 0 nch W=4e-06 L=4e-06
ngw2_e8_bias3 gw2_e8_vm istep_n 0 0 nch W=4e-06 L=4e-06
ngw2_e8_bias4 gw2_e8_vm istep_n 0 0 nch W=4e-06 L=4e-06
ngw2_e8_bias5 gw2_e8_vm istep_n 0 0 nch W=4e-06 L=4e-06
ngw2_e8_bias6 gw2_e8_vm istep_n 0 0 nch W=4e-06 L=4e-06
ngw2_e8_bias7 gw2_e8_vm istep_n 0 0 nch W=4e-06 L=4e-06
rgw2_e8_kb vdd gw2_e8_knb 1e+06
ngw2_e8_kmb gw2_e8_knb gw2_e8_knb 0 0 nch W=4e-06 L=4e-06
ngw2_e8_kmt gw2_e8_ktail gw2_e8_knb 0 0 nch W=4e-06 L=4e-06
ngw2_e8_km1 gw2_e8_kd1 gw2_e8_vm gw2_e8_ktail 0 nch W=4e-06 L=4e-06
ngw2_e8_km2 gw2_e8_ko1 gw2_e8_h gw2_e8_ktail 0 nch W=4e-06 L=4e-06
ngw2_e8_km3 gw2_e8_kd1 gw2_e8_kd1 vdd vsrc pch W=4e-06 L=4e-06
ngw2_e8_km4 gw2_e8_ko1 gw2_e8_kd1 vdd vsrc pch W=4e-06 L=4e-06
ngw2_e8_kporclamp gw2_e8_ko1 por_hold 0 0 nch W=4e-06 L=1e-06
ngw2_e8_ki1p gw2_e8_qb gw2_e8_ko1 vdd vsrc pch W=2.4e-06 L=5e-07
ngw2_e8_ki1n gw2_e8_qb gw2_e8_ko1 0 0 nch W=1.2e-06 L=5e-07
ngw2_e8_ki2p gw2_e8_q gw2_e8_qb vdd vsrc pch W=2.4e-06 L=5e-07
ngw2_e8_ki2n gw2_e8_q gw2_e8_qb 0 0 nch W=1.2e-06 L=5e-07
rgw2_e8_hra gw2_e8_h vthe 1e+06
rgw2_e8_hrf gw2_e8_h gw2_e8_qb 1.9e+07
cgw2_e8_hc gw2_e8_h 0 2.1e-09
ngw2_e8_dis gw2_e8_vm gw2_e8_q gw2_e8_vmd 0 nch W=4e-06 L=1e-06
va_rgw2_e8_rdis_n vrest rgw2_e8_rdis_n 0
rgw2_e8_rdis gw2_e8_vmd rgw2_e8_rdis_n 220000
ngw2_e8_rp gw2_e8_rt gw2_e8_qb vdd vsrc pch W=2e-06 L=1e-06
rgw2_e8_rrc gw2_e8_rt gw2_e8_rec 10000
cgw2_e8_rc gw2_e8_rec 0 1e-07
rgw2_e8_rr gw2_e8_rec 0 8.2e+06
ngw2_e8_sh1 gw2_e8_vm gw2_e8_rec gw2_e8_vms 0 nch W=2e-06 L=1e-06
va_ngw2_e8_sh2_s vrest ngw2_e8_sh2_s 0
ngw2_e8_sh2 gw2_e8_vms gw2_e8_qb ngw2_e8_sh2_s 0 nch W=2e-06 L=1e-06
ngw2_e8_porh gw2_e8_h por_hold vthe 0 nch W=2e-06 L=1e-06
va_ngw2_e8_porm_s vrest ngw2_e8_porm_s 0
ngw2_e8_porm gw2_e8_vm por_hold ngw2_e8_porm_s 0 nch W=2e-06 L=1e-06
ngw2_e8_ip gw2_e8_vm s2_ya vdd vsrc pch W=4e-06 L=4e-06
ngw2_e8_in gw2_e8_vm s2_zb 0 0 nch W=4e-06 L=4e-06
ngw2_b8_sw gw2_b8_t gw2_e8_qb vdd vsrc pch W=2e-06 L=1e-06
rgw2_b8_rc gw2_b8_t gw2_b8 10000
cgw2_b8_c gw2_b8 0 1e-07
rgw2_b8_rl gw2_b8 0 2.2e+07
ngw2_b8_sh1p gw2_b8_n gw2_b8 vdd vsrc pch W=2.4e-06 L=5e-07
ngw2_b8_sh1n gw2_b8_n gw2_b8 0 0 nch W=1.2e-06 L=5e-07
ngw2_b8_sh2p gw2_b8_q gw2_b8_n vdd vsrc pch W=2.4e-06 L=5e-07
ngw2_b8_sh2n gw2_b8_q gw2_b8_n 0 0 nch W=1.2e-06 L=5e-07
cgw2_e9_cm gw2_e9_vm 0 1e-07
va_rgw2_e9_rm_n vrest rgw2_e9_rm_n 0
rgw2_e9_rm gw2_e9_vm rgw2_e9_rm_n 1e+06
ngw2_e9_bias0 gw2_e9_vm istep_n 0 0 nch W=4e-06 L=4e-06
ngw2_e9_bias1 gw2_e9_vm istep_n 0 0 nch W=4e-06 L=4e-06
ngw2_e9_bias2 gw2_e9_vm istep_n 0 0 nch W=4e-06 L=4e-06
ngw2_e9_bias3 gw2_e9_vm istep_n 0 0 nch W=4e-06 L=4e-06
ngw2_e9_bias4 gw2_e9_vm istep_n 0 0 nch W=4e-06 L=4e-06
ngw2_e9_bias5 gw2_e9_vm istep_n 0 0 nch W=4e-06 L=4e-06
ngw2_e9_bias6 gw2_e9_vm istep_n 0 0 nch W=4e-06 L=4e-06
ngw2_e9_bias7 gw2_e9_vm istep_n 0 0 nch W=4e-06 L=4e-06
ngw2_e9_bias8 gw2_e9_vm istep_n 0 0 nch W=4e-06 L=4e-06
rgw2_e9_kb vdd gw2_e9_knb 1e+06
ngw2_e9_kmb gw2_e9_knb gw2_e9_knb 0 0 nch W=4e-06 L=4e-06
ngw2_e9_kmt gw2_e9_ktail gw2_e9_knb 0 0 nch W=4e-06 L=4e-06
ngw2_e9_km1 gw2_e9_kd1 gw2_e9_vm gw2_e9_ktail 0 nch W=4e-06 L=4e-06
ngw2_e9_km2 gw2_e9_ko1 gw2_e9_h gw2_e9_ktail 0 nch W=4e-06 L=4e-06
ngw2_e9_km3 gw2_e9_kd1 gw2_e9_kd1 vdd vsrc pch W=4e-06 L=4e-06
ngw2_e9_km4 gw2_e9_ko1 gw2_e9_kd1 vdd vsrc pch W=4e-06 L=4e-06
ngw2_e9_kporclamp gw2_e9_ko1 por_hold 0 0 nch W=4e-06 L=1e-06
ngw2_e9_ki1p gw2_e9_qb gw2_e9_ko1 vdd vsrc pch W=2.4e-06 L=5e-07
ngw2_e9_ki1n gw2_e9_qb gw2_e9_ko1 0 0 nch W=1.2e-06 L=5e-07
ngw2_e9_ki2p gw2_e9_q gw2_e9_qb vdd vsrc pch W=2.4e-06 L=5e-07
ngw2_e9_ki2n gw2_e9_q gw2_e9_qb 0 0 nch W=1.2e-06 L=5e-07
rgw2_e9_hra gw2_e9_h vthe 1e+06
rgw2_e9_hrf gw2_e9_h gw2_e9_qb 1.9e+07
cgw2_e9_hc gw2_e9_h 0 2.1e-09
ngw2_e9_dis gw2_e9_vm gw2_e9_q gw2_e9_vmd 0 nch W=4e-06 L=1e-06
va_rgw2_e9_rdis_n vrest rgw2_e9_rdis_n 0
rgw2_e9_rdis gw2_e9_vmd rgw2_e9_rdis_n 220000
ngw2_e9_rp gw2_e9_rt gw2_e9_qb vdd vsrc pch W=2e-06 L=1e-06
rgw2_e9_rrc gw2_e9_rt gw2_e9_rec 10000
cgw2_e9_rc gw2_e9_rec 0 1e-07
rgw2_e9_rr gw2_e9_rec 0 8.2e+06
ngw2_e9_sh1 gw2_e9_vm gw2_e9_rec gw2_e9_vms 0 nch W=2e-06 L=1e-06
va_ngw2_e9_sh2_s vrest ngw2_e9_sh2_s 0
ngw2_e9_sh2 gw2_e9_vms gw2_e9_qb ngw2_e9_sh2_s 0 nch W=2e-06 L=1e-06
ngw2_e9_porh gw2_e9_h por_hold vthe 0 nch W=2e-06 L=1e-06
va_ngw2_e9_porm_s vrest ngw2_e9_porm_s 0
ngw2_e9_porm gw2_e9_vm por_hold ngw2_e9_porm_s 0 nch W=2e-06 L=1e-06
ngw2_e9_ip gw2_e9_vm s2_ya vdd vsrc pch W=4e-06 L=4e-06
ngw2_e9_in gw2_e9_vm s2_zb 0 0 nch W=4e-06 L=4e-06
ngw2_b9_sw gw2_b9_t gw2_e9_qb vdd vsrc pch W=2e-06 L=1e-06
rgw2_b9_rc gw2_b9_t gw2_b9 10000
cgw2_b9_c gw2_b9 0 1e-07
rgw2_b9_rl gw2_b9 0 2.2e+07
ngw2_b9_sh1p gw2_b9_n gw2_b9 vdd vsrc pch W=2.4e-06 L=5e-07
ngw2_b9_sh1n gw2_b9_n gw2_b9 0 0 nch W=1.2e-06 L=5e-07
ngw2_b9_sh2p gw2_b9_q gw2_b9_n vdd vsrc pch W=2.4e-06 L=5e-07
ngw2_b9_sh2n gw2_b9_q gw2_b9_n 0 0 nch W=1.2e-06 L=5e-07
cgw2_e10_cm gw2_e10_vm 0 1e-07
va_rgw2_e10_rm_n vrest rgw2_e10_rm_n 0
rgw2_e10_rm gw2_e10_vm rgw2_e10_rm_n 1e+06
ngw2_e10_bias0 gw2_e10_vm istep_n 0 0 nch W=4e-06 L=4e-06
ngw2_e10_bias1 gw2_e10_vm istep_n 0 0 nch W=4e-06 L=4e-06
ngw2_e10_bias2 gw2_e10_vm istep_n 0 0 nch W=4e-06 L=4e-06
ngw2_e10_bias3 gw2_e10_vm istep_n 0 0 nch W=4e-06 L=4e-06
ngw2_e10_bias4 gw2_e10_vm istep_n 0 0 nch W=4e-06 L=4e-06
ngw2_e10_bias5 gw2_e10_vm istep_n 0 0 nch W=4e-06 L=4e-06
ngw2_e10_bias6 gw2_e10_vm istep_n 0 0 nch W=4e-06 L=4e-06
ngw2_e10_bias7 gw2_e10_vm istep_n 0 0 nch W=4e-06 L=4e-06
ngw2_e10_bias8 gw2_e10_vm istep_n 0 0 nch W=4e-06 L=4e-06
ngw2_e10_bias9 gw2_e10_vm istep_n 0 0 nch W=4e-06 L=4e-06
rgw2_e10_kb vdd gw2_e10_knb 1e+06
ngw2_e10_kmb gw2_e10_knb gw2_e10_knb 0 0 nch W=4e-06 L=4e-06
ngw2_e10_kmt gw2_e10_ktail gw2_e10_knb 0 0 nch W=4e-06 L=4e-06
ngw2_e10_km1 gw2_e10_kd1 gw2_e10_vm gw2_e10_ktail 0 nch W=4e-06 L=4e-06
ngw2_e10_km2 gw2_e10_ko1 gw2_e10_h gw2_e10_ktail 0 nch W=4e-06 L=4e-06
ngw2_e10_km3 gw2_e10_kd1 gw2_e10_kd1 vdd vsrc pch W=4e-06 L=4e-06
ngw2_e10_km4 gw2_e10_ko1 gw2_e10_kd1 vdd vsrc pch W=4e-06 L=4e-06
ngw2_e10_kporclamp gw2_e10_ko1 por_hold 0 0 nch W=4e-06 L=1e-06
ngw2_e10_ki1p gw2_e10_qb gw2_e10_ko1 vdd vsrc pch W=2.4e-06 L=5e-07
ngw2_e10_ki1n gw2_e10_qb gw2_e10_ko1 0 0 nch W=1.2e-06 L=5e-07
ngw2_e10_ki2p gw2_e10_q gw2_e10_qb vdd vsrc pch W=2.4e-06 L=5e-07
ngw2_e10_ki2n gw2_e10_q gw2_e10_qb 0 0 nch W=1.2e-06 L=5e-07
rgw2_e10_hra gw2_e10_h vthe 1e+06
rgw2_e10_hrf gw2_e10_h gw2_e10_qb 1.9e+07
cgw2_e10_hc gw2_e10_h 0 2.1e-09
ngw2_e10_dis gw2_e10_vm gw2_e10_q gw2_e10_vmd 0 nch W=4e-06 L=1e-06
va_rgw2_e10_rdis_n vrest rgw2_e10_rdis_n 0
rgw2_e10_rdis gw2_e10_vmd rgw2_e10_rdis_n 220000
ngw2_e10_rp gw2_e10_rt gw2_e10_qb vdd vsrc pch W=2e-06 L=1e-06
rgw2_e10_rrc gw2_e10_rt gw2_e10_rec 10000
cgw2_e10_rc gw2_e10_rec 0 1e-07
rgw2_e10_rr gw2_e10_rec 0 8.2e+06
ngw2_e10_sh1 gw2_e10_vm gw2_e10_rec gw2_e10_vms 0 nch W=2e-06 L=1e-06
va_ngw2_e10_sh2_s vrest ngw2_e10_sh2_s 0
ngw2_e10_sh2 gw2_e10_vms gw2_e10_qb ngw2_e10_sh2_s 0 nch W=2e-06 L=1e-06
ngw2_e10_porh gw2_e10_h por_hold vthe 0 nch W=2e-06 L=1e-06
va_ngw2_e10_porm_s vrest ngw2_e10_porm_s 0
ngw2_e10_porm gw2_e10_vm por_hold ngw2_e10_porm_s 0 nch W=2e-06 L=1e-06
ngw2_e10_ip gw2_e10_vm s2_ya vdd vsrc pch W=4e-06 L=4e-06
ngw2_e10_in gw2_e10_vm s2_zb 0 0 nch W=4e-06 L=4e-06
ngw2_b10_sw gw2_b10_t gw2_e10_qb vdd vsrc pch W=2e-06 L=1e-06
rgw2_b10_rc gw2_b10_t gw2_b10 10000
cgw2_b10_c gw2_b10 0 1e-07
rgw2_b10_rl gw2_b10 0 2.2e+07
ngw2_b10_sh1p gw2_b10_n gw2_b10 vdd vsrc pch W=2.4e-06 L=5e-07
ngw2_b10_sh1n gw2_b10_n gw2_b10 0 0 nch W=1.2e-06 L=5e-07
ngw2_b10_sh2p gw2_b10_q gw2_b10_n vdd vsrc pch W=2.4e-06 L=5e-07
ngw2_b10_sh2n gw2_b10_q gw2_b10_n 0 0 nch W=1.2e-06 L=5e-07
ngw2_and_a0_npa gw2_and_a0_nb gw2_b1_q vdd vsrc pch W=2.4e-06 L=5e-07
ngw2_and_a0_npb gw2_and_a0_nb gw2_b2_q vdd vsrc pch W=2.4e-06 L=5e-07
ngw2_and_a0_nna gw2_and_a0_nb gw2_b1_q gw2_and_a0_nx 0 nch W=2.4e-06 L=5e-07
ngw2_and_a0_nnb gw2_and_a0_nx gw2_b2_q 0 0 nch W=2.4e-06 L=5e-07
ngw2_and_a0_ip gw2_and_g0 gw2_and_a0_nb vdd vsrc pch W=2.4e-06 L=5e-07
ngw2_and_a0_in gw2_and_g0 gw2_and_a0_nb 0 0 nch W=1.2e-06 L=5e-07
ngw2_and_a1_npa gw2_and_a1_nb gw2_b3_q vdd vsrc pch W=2.4e-06 L=5e-07
ngw2_and_a1_npb gw2_and_a1_nb gw2_b4_q vdd vsrc pch W=2.4e-06 L=5e-07
ngw2_and_a1_nna gw2_and_a1_nb gw2_b3_q gw2_and_a1_nx 0 nch W=2.4e-06 L=5e-07
ngw2_and_a1_nnb gw2_and_a1_nx gw2_b4_q 0 0 nch W=2.4e-06 L=5e-07
ngw2_and_a1_ip gw2_and_g1 gw2_and_a1_nb vdd vsrc pch W=2.4e-06 L=5e-07
ngw2_and_a1_in gw2_and_g1 gw2_and_a1_nb 0 0 nch W=1.2e-06 L=5e-07
ngw2_and_a2_npa gw2_and_a2_nb gw2_b5_q vdd vsrc pch W=2.4e-06 L=5e-07
ngw2_and_a2_npb gw2_and_a2_nb gw2_b6_q vdd vsrc pch W=2.4e-06 L=5e-07
ngw2_and_a2_nna gw2_and_a2_nb gw2_b5_q gw2_and_a2_nx 0 nch W=2.4e-06 L=5e-07
ngw2_and_a2_nnb gw2_and_a2_nx gw2_b6_q 0 0 nch W=2.4e-06 L=5e-07
ngw2_and_a2_ip gw2_and_g2 gw2_and_a2_nb vdd vsrc pch W=2.4e-06 L=5e-07
ngw2_and_a2_in gw2_and_g2 gw2_and_a2_nb 0 0 nch W=1.2e-06 L=5e-07
ngw2_and_a3_npa gw2_and_a3_nb gw2_b7_q vdd vsrc pch W=2.4e-06 L=5e-07
ngw2_and_a3_npb gw2_and_a3_nb gw2_b8_q vdd vsrc pch W=2.4e-06 L=5e-07
ngw2_and_a3_nna gw2_and_a3_nb gw2_b7_q gw2_and_a3_nx 0 nch W=2.4e-06 L=5e-07
ngw2_and_a3_nnb gw2_and_a3_nx gw2_b8_q 0 0 nch W=2.4e-06 L=5e-07
ngw2_and_a3_ip gw2_and_g3 gw2_and_a3_nb vdd vsrc pch W=2.4e-06 L=5e-07
ngw2_and_a3_in gw2_and_g3 gw2_and_a3_nb 0 0 nch W=1.2e-06 L=5e-07
ngw2_and_a4_npa gw2_and_a4_nb gw2_b9_q vdd vsrc pch W=2.4e-06 L=5e-07
ngw2_and_a4_npb gw2_and_a4_nb gw2_b10_q vdd vsrc pch W=2.4e-06 L=5e-07
ngw2_and_a4_nna gw2_and_a4_nb gw2_b9_q gw2_and_a4_nx 0 nch W=2.4e-06 L=5e-07
ngw2_and_a4_nnb gw2_and_a4_nx gw2_b10_q 0 0 nch W=2.4e-06 L=5e-07
ngw2_and_a4_ip gw2_and_g4 gw2_and_a4_nb vdd vsrc pch W=2.4e-06 L=5e-07
ngw2_and_a4_in gw2_and_g4 gw2_and_a4_nb 0 0 nch W=1.2e-06 L=5e-07
ngw2_and_a5_npa gw2_and_a5_nb gw2_and_g0 vdd vsrc pch W=2.4e-06 L=5e-07
ngw2_and_a5_npb gw2_and_a5_nb gw2_and_g1 vdd vsrc pch W=2.4e-06 L=5e-07
ngw2_and_a5_nna gw2_and_a5_nb gw2_and_g0 gw2_and_a5_nx 0 nch W=2.4e-06 L=5e-07
ngw2_and_a5_nnb gw2_and_a5_nx gw2_and_g1 0 0 nch W=2.4e-06 L=5e-07
ngw2_and_a5_ip gw2_and_g5 gw2_and_a5_nb vdd vsrc pch W=2.4e-06 L=5e-07
ngw2_and_a5_in gw2_and_g5 gw2_and_a5_nb 0 0 nch W=1.2e-06 L=5e-07
ngw2_and_a6_npa gw2_and_a6_nb gw2_and_g2 vdd vsrc pch W=2.4e-06 L=5e-07
ngw2_and_a6_npb gw2_and_a6_nb gw2_and_g3 vdd vsrc pch W=2.4e-06 L=5e-07
ngw2_and_a6_nna gw2_and_a6_nb gw2_and_g2 gw2_and_a6_nx 0 nch W=2.4e-06 L=5e-07
ngw2_and_a6_nnb gw2_and_a6_nx gw2_and_g3 0 0 nch W=2.4e-06 L=5e-07
ngw2_and_a6_ip gw2_and_g6 gw2_and_a6_nb vdd vsrc pch W=2.4e-06 L=5e-07
ngw2_and_a6_in gw2_and_g6 gw2_and_a6_nb 0 0 nch W=1.2e-06 L=5e-07
ngw2_and_a7_npa gw2_and_a7_nb gw2_and_g5 vdd vsrc pch W=2.4e-06 L=5e-07
ngw2_and_a7_npb gw2_and_a7_nb gw2_and_g6 vdd vsrc pch W=2.4e-06 L=5e-07
ngw2_and_a7_nna gw2_and_a7_nb gw2_and_g5 gw2_and_a7_nx 0 nch W=2.4e-06 L=5e-07
ngw2_and_a7_nnb gw2_and_a7_nx gw2_and_g6 0 0 nch W=2.4e-06 L=5e-07
ngw2_and_a7_ip gw2_and_g7 gw2_and_a7_nb vdd vsrc pch W=2.4e-06 L=5e-07
ngw2_and_a7_in gw2_and_g7 gw2_and_a7_nb 0 0 nch W=1.2e-06 L=5e-07
ngw2_and_a8_npa gw2_and_a8_nb gw2_and_g7 vdd vsrc pch W=2.4e-06 L=5e-07
ngw2_and_a8_npb gw2_and_a8_nb gw2_and_g4 vdd vsrc pch W=2.4e-06 L=5e-07
ngw2_and_a8_nna gw2_and_a8_nb gw2_and_g7 gw2_and_a8_nx 0 nch W=2.4e-06 L=5e-07
ngw2_and_a8_nnb gw2_and_a8_nx gw2_and_g4 0 0 nch W=2.4e-06 L=5e-07
ngw2_and_a8_ip gw2_and_g8 gw2_and_a8_nb vdd vsrc pch W=2.4e-06 L=5e-07
ngw2_and_a8_in gw2_and_g8 gw2_and_a8_nb 0 0 nch W=1.2e-06 L=5e-07
ngw2_gip gw2_gb gw2_and_g8 vdd vsrc pch W=2.4e-06 L=5e-07
ngw2_gin gw2_gb gw2_and_g8 0 0 nch W=1.2e-06 L=5e-07
cgw2_col_cm gw2_col_vm 0 1e-07
va_rgw2_col_rm_n vrest rgw2_col_rm_n 0
rgw2_col_rm gw2_col_vm rgw2_col_rm_n 1e+06
rgw2_col_kb vdd gw2_col_knb 1e+06
ngw2_col_kmb gw2_col_knb gw2_col_knb 0 0 nch W=4e-06 L=4e-06
ngw2_col_kmt gw2_col_ktail gw2_col_knb 0 0 nch W=4e-06 L=4e-06
ngw2_col_km1 gw2_col_kd1 gw2_col_vm gw2_col_ktail 0 nch W=4e-06 L=4e-06
ngw2_col_km2 gw2_col_ko1 gw2_col_h gw2_col_ktail 0 nch W=4e-06 L=4e-06
ngw2_col_km3 gw2_col_kd1 gw2_col_kd1 vdd vsrc pch W=4e-06 L=4e-06
ngw2_col_km4 gw2_col_ko1 gw2_col_kd1 vdd vsrc pch W=4e-06 L=4e-06
ngw2_col_kporclamp gw2_col_ko1 por_hold 0 0 nch W=4e-06 L=1e-06
ngw2_col_ki1p gw2_col_qb gw2_col_ko1 vdd vsrc pch W=2.4e-06 L=5e-07
ngw2_col_ki1n gw2_col_qb gw2_col_ko1 0 0 nch W=1.2e-06 L=5e-07
ngw2_col_ki2p gw2_col_q gw2_col_qb vdd vsrc pch W=2.4e-06 L=5e-07
ngw2_col_ki2n gw2_col_q gw2_col_qb 0 0 nch W=1.2e-06 L=5e-07
rgw2_col_hra gw2_col_h vthe 1e+06
rgw2_col_hrf gw2_col_h gw2_col_qb 1.9e+07
cgw2_col_hc gw2_col_h 0 2.1e-09
ngw2_col_dis gw2_col_vm gw2_col_q gw2_col_vmd 0 nch W=4e-06 L=1e-06
va_rgw2_col_rdis_n vrest rgw2_col_rdis_n 0
rgw2_col_rdis gw2_col_vmd rgw2_col_rdis_n 220000
ngw2_col_rp gw2_col_rt gw2_col_qb vdd vsrc pch W=2e-06 L=1e-06
rgw2_col_rrc gw2_col_rt gw2_col_rec 10000
cgw2_col_rc gw2_col_rec 0 1e-07
rgw2_col_rr gw2_col_rec 0 8.2e+06
ngw2_col_sh1 gw2_col_vm gw2_col_rec gw2_col_vms 0 nch W=2e-06 L=1e-06
va_ngw2_col_sh2_s vrest ngw2_col_sh2_s 0
ngw2_col_sh2 gw2_col_vms gw2_col_qb ngw2_col_sh2_s 0 nch W=2e-06 L=1e-06
ngw2_col_porh gw2_col_h por_hold vthe 0 nch W=2e-06 L=1e-06
va_ngw2_col_porm_s vrest ngw2_col_porm_s 0
ngw2_col_porm gw2_col_vm por_hold ngw2_col_porm_s 0 nch W=2e-06 L=1e-06
ngw2_cin_eni_p gw2_cin_ena gw2_gb vdd vsrc pch W=2.4e-06 L=5e-07
ngw2_cin_eni_n gw2_cin_ena gw2_gb 0 0 nch W=1.2e-06 L=5e-07
ngw2_cin_cp gw2_col_vm gw2_cin_cg vdd vsrc pch W=4e-06 L=4e-06
ngw2_cin_bias ilimp_n gw2_gb gw2_cin_cg vsrc pch W=1.2e-06 L=1e-06
ngw2_cin_off gw2_cin_cg gw2_cin_ena vdd vsrc pch W=2.4e-06 L=1e-06
ngw2_op_tsw gw2_op_tt gw2_col_qb vdd vsrc pch W=2e-06 L=1e-06
rgw2_op_trc gw2_op_tt gw2_op_at 10000
cgw2_op_tc gw2_op_at 0 1e-07
rgw2_op_trl gw2_op_at 0 2.2e+07
ngw2_op_sh1p gw2_op_an gw2_op_at vdd vsrc pch W=2.4e-06 L=5e-07
ngw2_op_sh1n gw2_op_an gw2_op_at 0 0 nch W=1.2e-06 L=5e-07
ngw2_op_sh2p gw2_op_aq gw2_op_an vdd vsrc pch W=2.4e-06 L=5e-07
ngw2_op_sh2n gw2_op_aq gw2_op_an 0 0 nch W=1.2e-06 L=5e-07
ngw2_op_abp gw2_op_aqb gw2_op_aq vdd vsrc pch W=2.4e-06 L=5e-07
ngw2_op_abn gw2_op_aqb gw2_op_aq 0 0 nch W=1.2e-06 L=5e-07
rgw2_op_dr gw2_op_aq gw2_op_ad 1e+06
cgw2_op_dc gw2_op_ad 0 3.3e-07
ngw2_op_d2p gw2_op_adn gw2_op_ad vdd vsrc pch W=2.4e-06 L=5e-07
ngw2_op_d2n gw2_op_adn gw2_op_ad 0 0 nch W=1.2e-06 L=5e-07
ngw2_op_gpa gw2_op_pb gw2_op_aq vdd vsrc pch W=2.4e-06 L=5e-07
ngw2_op_gpb gw2_op_pb gw2_op_adn vdd vsrc pch W=2.4e-06 L=5e-07
ngw2_op_gna gw2_op_pb gw2_op_aq gw2_op_gx 0 nch W=2.4e-06 L=5e-07
ngw2_op_gnb gw2_op_gx gw2_op_adn 0 0 nch W=2.4e-06 L=5e-07
ngw2_op_op gw2_op_p gw2_op_pb vdd vsrc pch W=2.4e-06 L=5e-07
ngw2_op_on gw2_op_p gw2_op_pb 0 0 nch W=1.2e-06 L=5e-07
cgc2_e1_cm gc2_e1_vm 0 1e-07
va_rgc2_e1_rm_n vrest rgc2_e1_rm_n 0
rgc2_e1_rm gc2_e1_vm rgc2_e1_rm_n 1e+06
ngc2_e1_bias0 gc2_e1_vm istep_n 0 0 nch W=4e-06 L=4e-06
rgc2_e1_kb vdd gc2_e1_knb 1e+06
ngc2_e1_kmb gc2_e1_knb gc2_e1_knb 0 0 nch W=4e-06 L=4e-06
ngc2_e1_kmt gc2_e1_ktail gc2_e1_knb 0 0 nch W=4e-06 L=4e-06
ngc2_e1_km1 gc2_e1_kd1 gc2_e1_vm gc2_e1_ktail 0 nch W=4e-06 L=4e-06
ngc2_e1_km2 gc2_e1_ko1 gc2_e1_h gc2_e1_ktail 0 nch W=4e-06 L=4e-06
ngc2_e1_km3 gc2_e1_kd1 gc2_e1_kd1 vdd vsrc pch W=4e-06 L=4e-06
ngc2_e1_km4 gc2_e1_ko1 gc2_e1_kd1 vdd vsrc pch W=4e-06 L=4e-06
ngc2_e1_kporclamp gc2_e1_ko1 por_hold 0 0 nch W=4e-06 L=1e-06
ngc2_e1_ki1p gc2_e1_qb gc2_e1_ko1 vdd vsrc pch W=2.4e-06 L=5e-07
ngc2_e1_ki1n gc2_e1_qb gc2_e1_ko1 0 0 nch W=1.2e-06 L=5e-07
ngc2_e1_ki2p gc2_e1_q gc2_e1_qb vdd vsrc pch W=2.4e-06 L=5e-07
ngc2_e1_ki2n gc2_e1_q gc2_e1_qb 0 0 nch W=1.2e-06 L=5e-07
rgc2_e1_hra gc2_e1_h vthe 1e+06
rgc2_e1_hrf gc2_e1_h gc2_e1_qb 1.9e+07
cgc2_e1_hc gc2_e1_h 0 2.1e-09
ngc2_e1_dis gc2_e1_vm gc2_e1_q gc2_e1_vmd 0 nch W=4e-06 L=1e-06
va_rgc2_e1_rdis_n vrest rgc2_e1_rdis_n 0
rgc2_e1_rdis gc2_e1_vmd rgc2_e1_rdis_n 220000
ngc2_e1_rp gc2_e1_rt gc2_e1_qb vdd vsrc pch W=2e-06 L=1e-06
rgc2_e1_rrc gc2_e1_rt gc2_e1_rec 10000
cgc2_e1_rc gc2_e1_rec 0 1e-07
rgc2_e1_rr gc2_e1_rec 0 8.2e+06
ngc2_e1_sh1 gc2_e1_vm gc2_e1_rec gc2_e1_vms 0 nch W=2e-06 L=1e-06
va_ngc2_e1_sh2_s vrest ngc2_e1_sh2_s 0
ngc2_e1_sh2 gc2_e1_vms gc2_e1_qb ngc2_e1_sh2_s 0 nch W=2e-06 L=1e-06
ngc2_e1_porh gc2_e1_h por_hold vthe 0 nch W=2e-06 L=1e-06
va_ngc2_e1_porm_s vrest ngc2_e1_porm_s 0
ngc2_e1_porm gc2_e1_vm por_hold ngc2_e1_porm_s 0 nch W=2e-06 L=1e-06
ngc2_e1_ip gc2_e1_vm s2_yb vdd vsrc pch W=4e-06 L=4e-06
ngc2_e1_in gc2_e1_vm s2_za 0 0 nch W=4e-06 L=4e-06
ngc2_b1_sw gc2_b1_t gc2_e1_qb vdd vsrc pch W=2e-06 L=1e-06
rgc2_b1_rc gc2_b1_t gc2_b1 10000
cgc2_b1_c gc2_b1 0 1e-07
rgc2_b1_rl gc2_b1 0 2.2e+07
ngc2_b1_sh1p gc2_b1_n gc2_b1 vdd vsrc pch W=2.4e-06 L=5e-07
ngc2_b1_sh1n gc2_b1_n gc2_b1 0 0 nch W=1.2e-06 L=5e-07
ngc2_b1_sh2p gc2_b1_q gc2_b1_n vdd vsrc pch W=2.4e-06 L=5e-07
ngc2_b1_sh2n gc2_b1_q gc2_b1_n 0 0 nch W=1.2e-06 L=5e-07
cgc2_e2_cm gc2_e2_vm 0 1e-07
va_rgc2_e2_rm_n vrest rgc2_e2_rm_n 0
rgc2_e2_rm gc2_e2_vm rgc2_e2_rm_n 1e+06
ngc2_e2_bias0 gc2_e2_vm istep_n 0 0 nch W=4e-06 L=4e-06
ngc2_e2_bias1 gc2_e2_vm istep_n 0 0 nch W=4e-06 L=4e-06
rgc2_e2_kb vdd gc2_e2_knb 1e+06
ngc2_e2_kmb gc2_e2_knb gc2_e2_knb 0 0 nch W=4e-06 L=4e-06
ngc2_e2_kmt gc2_e2_ktail gc2_e2_knb 0 0 nch W=4e-06 L=4e-06
ngc2_e2_km1 gc2_e2_kd1 gc2_e2_vm gc2_e2_ktail 0 nch W=4e-06 L=4e-06
ngc2_e2_km2 gc2_e2_ko1 gc2_e2_h gc2_e2_ktail 0 nch W=4e-06 L=4e-06
ngc2_e2_km3 gc2_e2_kd1 gc2_e2_kd1 vdd vsrc pch W=4e-06 L=4e-06
ngc2_e2_km4 gc2_e2_ko1 gc2_e2_kd1 vdd vsrc pch W=4e-06 L=4e-06
ngc2_e2_kporclamp gc2_e2_ko1 por_hold 0 0 nch W=4e-06 L=1e-06
ngc2_e2_ki1p gc2_e2_qb gc2_e2_ko1 vdd vsrc pch W=2.4e-06 L=5e-07
ngc2_e2_ki1n gc2_e2_qb gc2_e2_ko1 0 0 nch W=1.2e-06 L=5e-07
ngc2_e2_ki2p gc2_e2_q gc2_e2_qb vdd vsrc pch W=2.4e-06 L=5e-07
ngc2_e2_ki2n gc2_e2_q gc2_e2_qb 0 0 nch W=1.2e-06 L=5e-07
rgc2_e2_hra gc2_e2_h vthe 1e+06
rgc2_e2_hrf gc2_e2_h gc2_e2_qb 1.9e+07
cgc2_e2_hc gc2_e2_h 0 2.1e-09
ngc2_e2_dis gc2_e2_vm gc2_e2_q gc2_e2_vmd 0 nch W=4e-06 L=1e-06
va_rgc2_e2_rdis_n vrest rgc2_e2_rdis_n 0
rgc2_e2_rdis gc2_e2_vmd rgc2_e2_rdis_n 220000
ngc2_e2_rp gc2_e2_rt gc2_e2_qb vdd vsrc pch W=2e-06 L=1e-06
rgc2_e2_rrc gc2_e2_rt gc2_e2_rec 10000
cgc2_e2_rc gc2_e2_rec 0 1e-07
rgc2_e2_rr gc2_e2_rec 0 8.2e+06
ngc2_e2_sh1 gc2_e2_vm gc2_e2_rec gc2_e2_vms 0 nch W=2e-06 L=1e-06
va_ngc2_e2_sh2_s vrest ngc2_e2_sh2_s 0
ngc2_e2_sh2 gc2_e2_vms gc2_e2_qb ngc2_e2_sh2_s 0 nch W=2e-06 L=1e-06
ngc2_e2_porh gc2_e2_h por_hold vthe 0 nch W=2e-06 L=1e-06
va_ngc2_e2_porm_s vrest ngc2_e2_porm_s 0
ngc2_e2_porm gc2_e2_vm por_hold ngc2_e2_porm_s 0 nch W=2e-06 L=1e-06
ngc2_e2_ip gc2_e2_vm s2_yb vdd vsrc pch W=4e-06 L=4e-06
ngc2_e2_in gc2_e2_vm s2_za 0 0 nch W=4e-06 L=4e-06
ngc2_b2_sw gc2_b2_t gc2_e2_qb vdd vsrc pch W=2e-06 L=1e-06
rgc2_b2_rc gc2_b2_t gc2_b2 10000
cgc2_b2_c gc2_b2 0 1e-07
rgc2_b2_rl gc2_b2 0 2.2e+07
ngc2_b2_sh1p gc2_b2_n gc2_b2 vdd vsrc pch W=2.4e-06 L=5e-07
ngc2_b2_sh1n gc2_b2_n gc2_b2 0 0 nch W=1.2e-06 L=5e-07
ngc2_b2_sh2p gc2_b2_q gc2_b2_n vdd vsrc pch W=2.4e-06 L=5e-07
ngc2_b2_sh2n gc2_b2_q gc2_b2_n 0 0 nch W=1.2e-06 L=5e-07
cgc2_e3_cm gc2_e3_vm 0 1e-07
va_rgc2_e3_rm_n vrest rgc2_e3_rm_n 0
rgc2_e3_rm gc2_e3_vm rgc2_e3_rm_n 1e+06
ngc2_e3_bias0 gc2_e3_vm istep_n 0 0 nch W=4e-06 L=4e-06
ngc2_e3_bias1 gc2_e3_vm istep_n 0 0 nch W=4e-06 L=4e-06
ngc2_e3_bias2 gc2_e3_vm istep_n 0 0 nch W=4e-06 L=4e-06
rgc2_e3_kb vdd gc2_e3_knb 1e+06
ngc2_e3_kmb gc2_e3_knb gc2_e3_knb 0 0 nch W=4e-06 L=4e-06
ngc2_e3_kmt gc2_e3_ktail gc2_e3_knb 0 0 nch W=4e-06 L=4e-06
ngc2_e3_km1 gc2_e3_kd1 gc2_e3_vm gc2_e3_ktail 0 nch W=4e-06 L=4e-06
ngc2_e3_km2 gc2_e3_ko1 gc2_e3_h gc2_e3_ktail 0 nch W=4e-06 L=4e-06
ngc2_e3_km3 gc2_e3_kd1 gc2_e3_kd1 vdd vsrc pch W=4e-06 L=4e-06
ngc2_e3_km4 gc2_e3_ko1 gc2_e3_kd1 vdd vsrc pch W=4e-06 L=4e-06
ngc2_e3_kporclamp gc2_e3_ko1 por_hold 0 0 nch W=4e-06 L=1e-06
ngc2_e3_ki1p gc2_e3_qb gc2_e3_ko1 vdd vsrc pch W=2.4e-06 L=5e-07
ngc2_e3_ki1n gc2_e3_qb gc2_e3_ko1 0 0 nch W=1.2e-06 L=5e-07
ngc2_e3_ki2p gc2_e3_q gc2_e3_qb vdd vsrc pch W=2.4e-06 L=5e-07
ngc2_e3_ki2n gc2_e3_q gc2_e3_qb 0 0 nch W=1.2e-06 L=5e-07
rgc2_e3_hra gc2_e3_h vthe 1e+06
rgc2_e3_hrf gc2_e3_h gc2_e3_qb 1.9e+07
cgc2_e3_hc gc2_e3_h 0 2.1e-09
ngc2_e3_dis gc2_e3_vm gc2_e3_q gc2_e3_vmd 0 nch W=4e-06 L=1e-06
va_rgc2_e3_rdis_n vrest rgc2_e3_rdis_n 0
rgc2_e3_rdis gc2_e3_vmd rgc2_e3_rdis_n 220000
ngc2_e3_rp gc2_e3_rt gc2_e3_qb vdd vsrc pch W=2e-06 L=1e-06
rgc2_e3_rrc gc2_e3_rt gc2_e3_rec 10000
cgc2_e3_rc gc2_e3_rec 0 1e-07
rgc2_e3_rr gc2_e3_rec 0 8.2e+06
ngc2_e3_sh1 gc2_e3_vm gc2_e3_rec gc2_e3_vms 0 nch W=2e-06 L=1e-06
va_ngc2_e3_sh2_s vrest ngc2_e3_sh2_s 0
ngc2_e3_sh2 gc2_e3_vms gc2_e3_qb ngc2_e3_sh2_s 0 nch W=2e-06 L=1e-06
ngc2_e3_porh gc2_e3_h por_hold vthe 0 nch W=2e-06 L=1e-06
va_ngc2_e3_porm_s vrest ngc2_e3_porm_s 0
ngc2_e3_porm gc2_e3_vm por_hold ngc2_e3_porm_s 0 nch W=2e-06 L=1e-06
ngc2_e3_ip gc2_e3_vm s2_yb vdd vsrc pch W=4e-06 L=4e-06
ngc2_e3_in gc2_e3_vm s2_za 0 0 nch W=4e-06 L=4e-06
ngc2_b3_sw gc2_b3_t gc2_e3_qb vdd vsrc pch W=2e-06 L=1e-06
rgc2_b3_rc gc2_b3_t gc2_b3 10000
cgc2_b3_c gc2_b3 0 1e-07
rgc2_b3_rl gc2_b3 0 2.2e+07
ngc2_b3_sh1p gc2_b3_n gc2_b3 vdd vsrc pch W=2.4e-06 L=5e-07
ngc2_b3_sh1n gc2_b3_n gc2_b3 0 0 nch W=1.2e-06 L=5e-07
ngc2_b3_sh2p gc2_b3_q gc2_b3_n vdd vsrc pch W=2.4e-06 L=5e-07
ngc2_b3_sh2n gc2_b3_q gc2_b3_n 0 0 nch W=1.2e-06 L=5e-07
cgc2_e4_cm gc2_e4_vm 0 1e-07
va_rgc2_e4_rm_n vrest rgc2_e4_rm_n 0
rgc2_e4_rm gc2_e4_vm rgc2_e4_rm_n 1e+06
ngc2_e4_bias0 gc2_e4_vm istep_n 0 0 nch W=4e-06 L=4e-06
ngc2_e4_bias1 gc2_e4_vm istep_n 0 0 nch W=4e-06 L=4e-06
ngc2_e4_bias2 gc2_e4_vm istep_n 0 0 nch W=4e-06 L=4e-06
ngc2_e4_bias3 gc2_e4_vm istep_n 0 0 nch W=4e-06 L=4e-06
rgc2_e4_kb vdd gc2_e4_knb 1e+06
ngc2_e4_kmb gc2_e4_knb gc2_e4_knb 0 0 nch W=4e-06 L=4e-06
ngc2_e4_kmt gc2_e4_ktail gc2_e4_knb 0 0 nch W=4e-06 L=4e-06
ngc2_e4_km1 gc2_e4_kd1 gc2_e4_vm gc2_e4_ktail 0 nch W=4e-06 L=4e-06
ngc2_e4_km2 gc2_e4_ko1 gc2_e4_h gc2_e4_ktail 0 nch W=4e-06 L=4e-06
ngc2_e4_km3 gc2_e4_kd1 gc2_e4_kd1 vdd vsrc pch W=4e-06 L=4e-06
ngc2_e4_km4 gc2_e4_ko1 gc2_e4_kd1 vdd vsrc pch W=4e-06 L=4e-06
ngc2_e4_kporclamp gc2_e4_ko1 por_hold 0 0 nch W=4e-06 L=1e-06
ngc2_e4_ki1p gc2_e4_qb gc2_e4_ko1 vdd vsrc pch W=2.4e-06 L=5e-07
ngc2_e4_ki1n gc2_e4_qb gc2_e4_ko1 0 0 nch W=1.2e-06 L=5e-07
ngc2_e4_ki2p gc2_e4_q gc2_e4_qb vdd vsrc pch W=2.4e-06 L=5e-07
ngc2_e4_ki2n gc2_e4_q gc2_e4_qb 0 0 nch W=1.2e-06 L=5e-07
rgc2_e4_hra gc2_e4_h vthe 1e+06
rgc2_e4_hrf gc2_e4_h gc2_e4_qb 1.9e+07
cgc2_e4_hc gc2_e4_h 0 2.1e-09
ngc2_e4_dis gc2_e4_vm gc2_e4_q gc2_e4_vmd 0 nch W=4e-06 L=1e-06
va_rgc2_e4_rdis_n vrest rgc2_e4_rdis_n 0
rgc2_e4_rdis gc2_e4_vmd rgc2_e4_rdis_n 220000
ngc2_e4_rp gc2_e4_rt gc2_e4_qb vdd vsrc pch W=2e-06 L=1e-06
rgc2_e4_rrc gc2_e4_rt gc2_e4_rec 10000
cgc2_e4_rc gc2_e4_rec 0 1e-07
rgc2_e4_rr gc2_e4_rec 0 8.2e+06
ngc2_e4_sh1 gc2_e4_vm gc2_e4_rec gc2_e4_vms 0 nch W=2e-06 L=1e-06
va_ngc2_e4_sh2_s vrest ngc2_e4_sh2_s 0
ngc2_e4_sh2 gc2_e4_vms gc2_e4_qb ngc2_e4_sh2_s 0 nch W=2e-06 L=1e-06
ngc2_e4_porh gc2_e4_h por_hold vthe 0 nch W=2e-06 L=1e-06
va_ngc2_e4_porm_s vrest ngc2_e4_porm_s 0
ngc2_e4_porm gc2_e4_vm por_hold ngc2_e4_porm_s 0 nch W=2e-06 L=1e-06
ngc2_e4_ip gc2_e4_vm s2_yb vdd vsrc pch W=4e-06 L=4e-06
ngc2_e4_in gc2_e4_vm s2_za 0 0 nch W=4e-06 L=4e-06
ngc2_b4_sw gc2_b4_t gc2_e4_qb vdd vsrc pch W=2e-06 L=1e-06
rgc2_b4_rc gc2_b4_t gc2_b4 10000
cgc2_b4_c gc2_b4 0 1e-07
rgc2_b4_rl gc2_b4 0 2.2e+07
ngc2_b4_sh1p gc2_b4_n gc2_b4 vdd vsrc pch W=2.4e-06 L=5e-07
ngc2_b4_sh1n gc2_b4_n gc2_b4 0 0 nch W=1.2e-06 L=5e-07
ngc2_b4_sh2p gc2_b4_q gc2_b4_n vdd vsrc pch W=2.4e-06 L=5e-07
ngc2_b4_sh2n gc2_b4_q gc2_b4_n 0 0 nch W=1.2e-06 L=5e-07
cgc2_e5_cm gc2_e5_vm 0 1e-07
va_rgc2_e5_rm_n vrest rgc2_e5_rm_n 0
rgc2_e5_rm gc2_e5_vm rgc2_e5_rm_n 1e+06
ngc2_e5_bias0 gc2_e5_vm istep_n 0 0 nch W=4e-06 L=4e-06
ngc2_e5_bias1 gc2_e5_vm istep_n 0 0 nch W=4e-06 L=4e-06
ngc2_e5_bias2 gc2_e5_vm istep_n 0 0 nch W=4e-06 L=4e-06
ngc2_e5_bias3 gc2_e5_vm istep_n 0 0 nch W=4e-06 L=4e-06
ngc2_e5_bias4 gc2_e5_vm istep_n 0 0 nch W=4e-06 L=4e-06
rgc2_e5_kb vdd gc2_e5_knb 1e+06
ngc2_e5_kmb gc2_e5_knb gc2_e5_knb 0 0 nch W=4e-06 L=4e-06
ngc2_e5_kmt gc2_e5_ktail gc2_e5_knb 0 0 nch W=4e-06 L=4e-06
ngc2_e5_km1 gc2_e5_kd1 gc2_e5_vm gc2_e5_ktail 0 nch W=4e-06 L=4e-06
ngc2_e5_km2 gc2_e5_ko1 gc2_e5_h gc2_e5_ktail 0 nch W=4e-06 L=4e-06
ngc2_e5_km3 gc2_e5_kd1 gc2_e5_kd1 vdd vsrc pch W=4e-06 L=4e-06
ngc2_e5_km4 gc2_e5_ko1 gc2_e5_kd1 vdd vsrc pch W=4e-06 L=4e-06
ngc2_e5_kporclamp gc2_e5_ko1 por_hold 0 0 nch W=4e-06 L=1e-06
ngc2_e5_ki1p gc2_e5_qb gc2_e5_ko1 vdd vsrc pch W=2.4e-06 L=5e-07
ngc2_e5_ki1n gc2_e5_qb gc2_e5_ko1 0 0 nch W=1.2e-06 L=5e-07
ngc2_e5_ki2p gc2_e5_q gc2_e5_qb vdd vsrc pch W=2.4e-06 L=5e-07
ngc2_e5_ki2n gc2_e5_q gc2_e5_qb 0 0 nch W=1.2e-06 L=5e-07
rgc2_e5_hra gc2_e5_h vthe 1e+06
rgc2_e5_hrf gc2_e5_h gc2_e5_qb 1.9e+07
cgc2_e5_hc gc2_e5_h 0 2.1e-09
ngc2_e5_dis gc2_e5_vm gc2_e5_q gc2_e5_vmd 0 nch W=4e-06 L=1e-06
va_rgc2_e5_rdis_n vrest rgc2_e5_rdis_n 0
rgc2_e5_rdis gc2_e5_vmd rgc2_e5_rdis_n 220000
ngc2_e5_rp gc2_e5_rt gc2_e5_qb vdd vsrc pch W=2e-06 L=1e-06
rgc2_e5_rrc gc2_e5_rt gc2_e5_rec 10000
cgc2_e5_rc gc2_e5_rec 0 1e-07
rgc2_e5_rr gc2_e5_rec 0 8.2e+06
ngc2_e5_sh1 gc2_e5_vm gc2_e5_rec gc2_e5_vms 0 nch W=2e-06 L=1e-06
va_ngc2_e5_sh2_s vrest ngc2_e5_sh2_s 0
ngc2_e5_sh2 gc2_e5_vms gc2_e5_qb ngc2_e5_sh2_s 0 nch W=2e-06 L=1e-06
ngc2_e5_porh gc2_e5_h por_hold vthe 0 nch W=2e-06 L=1e-06
va_ngc2_e5_porm_s vrest ngc2_e5_porm_s 0
ngc2_e5_porm gc2_e5_vm por_hold ngc2_e5_porm_s 0 nch W=2e-06 L=1e-06
ngc2_e5_ip gc2_e5_vm s2_yb vdd vsrc pch W=4e-06 L=4e-06
ngc2_e5_in gc2_e5_vm s2_za 0 0 nch W=4e-06 L=4e-06
ngc2_b5_sw gc2_b5_t gc2_e5_qb vdd vsrc pch W=2e-06 L=1e-06
rgc2_b5_rc gc2_b5_t gc2_b5 10000
cgc2_b5_c gc2_b5 0 1e-07
rgc2_b5_rl gc2_b5 0 2.2e+07
ngc2_b5_sh1p gc2_b5_n gc2_b5 vdd vsrc pch W=2.4e-06 L=5e-07
ngc2_b5_sh1n gc2_b5_n gc2_b5 0 0 nch W=1.2e-06 L=5e-07
ngc2_b5_sh2p gc2_b5_q gc2_b5_n vdd vsrc pch W=2.4e-06 L=5e-07
ngc2_b5_sh2n gc2_b5_q gc2_b5_n 0 0 nch W=1.2e-06 L=5e-07
cgc2_e6_cm gc2_e6_vm 0 1e-07
va_rgc2_e6_rm_n vrest rgc2_e6_rm_n 0
rgc2_e6_rm gc2_e6_vm rgc2_e6_rm_n 1e+06
ngc2_e6_bias0 gc2_e6_vm istep_n 0 0 nch W=4e-06 L=4e-06
ngc2_e6_bias1 gc2_e6_vm istep_n 0 0 nch W=4e-06 L=4e-06
ngc2_e6_bias2 gc2_e6_vm istep_n 0 0 nch W=4e-06 L=4e-06
ngc2_e6_bias3 gc2_e6_vm istep_n 0 0 nch W=4e-06 L=4e-06
ngc2_e6_bias4 gc2_e6_vm istep_n 0 0 nch W=4e-06 L=4e-06
ngc2_e6_bias5 gc2_e6_vm istep_n 0 0 nch W=4e-06 L=4e-06
rgc2_e6_kb vdd gc2_e6_knb 1e+06
ngc2_e6_kmb gc2_e6_knb gc2_e6_knb 0 0 nch W=4e-06 L=4e-06
ngc2_e6_kmt gc2_e6_ktail gc2_e6_knb 0 0 nch W=4e-06 L=4e-06
ngc2_e6_km1 gc2_e6_kd1 gc2_e6_vm gc2_e6_ktail 0 nch W=4e-06 L=4e-06
ngc2_e6_km2 gc2_e6_ko1 gc2_e6_h gc2_e6_ktail 0 nch W=4e-06 L=4e-06
ngc2_e6_km3 gc2_e6_kd1 gc2_e6_kd1 vdd vsrc pch W=4e-06 L=4e-06
ngc2_e6_km4 gc2_e6_ko1 gc2_e6_kd1 vdd vsrc pch W=4e-06 L=4e-06
ngc2_e6_kporclamp gc2_e6_ko1 por_hold 0 0 nch W=4e-06 L=1e-06
ngc2_e6_ki1p gc2_e6_qb gc2_e6_ko1 vdd vsrc pch W=2.4e-06 L=5e-07
ngc2_e6_ki1n gc2_e6_qb gc2_e6_ko1 0 0 nch W=1.2e-06 L=5e-07
ngc2_e6_ki2p gc2_e6_q gc2_e6_qb vdd vsrc pch W=2.4e-06 L=5e-07
ngc2_e6_ki2n gc2_e6_q gc2_e6_qb 0 0 nch W=1.2e-06 L=5e-07
rgc2_e6_hra gc2_e6_h vthe 1e+06
rgc2_e6_hrf gc2_e6_h gc2_e6_qb 1.9e+07
cgc2_e6_hc gc2_e6_h 0 2.1e-09
ngc2_e6_dis gc2_e6_vm gc2_e6_q gc2_e6_vmd 0 nch W=4e-06 L=1e-06
va_rgc2_e6_rdis_n vrest rgc2_e6_rdis_n 0
rgc2_e6_rdis gc2_e6_vmd rgc2_e6_rdis_n 220000
ngc2_e6_rp gc2_e6_rt gc2_e6_qb vdd vsrc pch W=2e-06 L=1e-06
rgc2_e6_rrc gc2_e6_rt gc2_e6_rec 10000
cgc2_e6_rc gc2_e6_rec 0 1e-07
rgc2_e6_rr gc2_e6_rec 0 8.2e+06
ngc2_e6_sh1 gc2_e6_vm gc2_e6_rec gc2_e6_vms 0 nch W=2e-06 L=1e-06
va_ngc2_e6_sh2_s vrest ngc2_e6_sh2_s 0
ngc2_e6_sh2 gc2_e6_vms gc2_e6_qb ngc2_e6_sh2_s 0 nch W=2e-06 L=1e-06
ngc2_e6_porh gc2_e6_h por_hold vthe 0 nch W=2e-06 L=1e-06
va_ngc2_e6_porm_s vrest ngc2_e6_porm_s 0
ngc2_e6_porm gc2_e6_vm por_hold ngc2_e6_porm_s 0 nch W=2e-06 L=1e-06
ngc2_e6_ip gc2_e6_vm s2_yb vdd vsrc pch W=4e-06 L=4e-06
ngc2_e6_in gc2_e6_vm s2_za 0 0 nch W=4e-06 L=4e-06
ngc2_b6_sw gc2_b6_t gc2_e6_qb vdd vsrc pch W=2e-06 L=1e-06
rgc2_b6_rc gc2_b6_t gc2_b6 10000
cgc2_b6_c gc2_b6 0 1e-07
rgc2_b6_rl gc2_b6 0 2.2e+07
ngc2_b6_sh1p gc2_b6_n gc2_b6 vdd vsrc pch W=2.4e-06 L=5e-07
ngc2_b6_sh1n gc2_b6_n gc2_b6 0 0 nch W=1.2e-06 L=5e-07
ngc2_b6_sh2p gc2_b6_q gc2_b6_n vdd vsrc pch W=2.4e-06 L=5e-07
ngc2_b6_sh2n gc2_b6_q gc2_b6_n 0 0 nch W=1.2e-06 L=5e-07
cgc2_e7_cm gc2_e7_vm 0 1e-07
va_rgc2_e7_rm_n vrest rgc2_e7_rm_n 0
rgc2_e7_rm gc2_e7_vm rgc2_e7_rm_n 1e+06
ngc2_e7_bias0 gc2_e7_vm istep_n 0 0 nch W=4e-06 L=4e-06
ngc2_e7_bias1 gc2_e7_vm istep_n 0 0 nch W=4e-06 L=4e-06
ngc2_e7_bias2 gc2_e7_vm istep_n 0 0 nch W=4e-06 L=4e-06
ngc2_e7_bias3 gc2_e7_vm istep_n 0 0 nch W=4e-06 L=4e-06
ngc2_e7_bias4 gc2_e7_vm istep_n 0 0 nch W=4e-06 L=4e-06
ngc2_e7_bias5 gc2_e7_vm istep_n 0 0 nch W=4e-06 L=4e-06
ngc2_e7_bias6 gc2_e7_vm istep_n 0 0 nch W=4e-06 L=4e-06
rgc2_e7_kb vdd gc2_e7_knb 1e+06
ngc2_e7_kmb gc2_e7_knb gc2_e7_knb 0 0 nch W=4e-06 L=4e-06
ngc2_e7_kmt gc2_e7_ktail gc2_e7_knb 0 0 nch W=4e-06 L=4e-06
ngc2_e7_km1 gc2_e7_kd1 gc2_e7_vm gc2_e7_ktail 0 nch W=4e-06 L=4e-06
ngc2_e7_km2 gc2_e7_ko1 gc2_e7_h gc2_e7_ktail 0 nch W=4e-06 L=4e-06
ngc2_e7_km3 gc2_e7_kd1 gc2_e7_kd1 vdd vsrc pch W=4e-06 L=4e-06
ngc2_e7_km4 gc2_e7_ko1 gc2_e7_kd1 vdd vsrc pch W=4e-06 L=4e-06
ngc2_e7_kporclamp gc2_e7_ko1 por_hold 0 0 nch W=4e-06 L=1e-06
ngc2_e7_ki1p gc2_e7_qb gc2_e7_ko1 vdd vsrc pch W=2.4e-06 L=5e-07
ngc2_e7_ki1n gc2_e7_qb gc2_e7_ko1 0 0 nch W=1.2e-06 L=5e-07
ngc2_e7_ki2p gc2_e7_q gc2_e7_qb vdd vsrc pch W=2.4e-06 L=5e-07
ngc2_e7_ki2n gc2_e7_q gc2_e7_qb 0 0 nch W=1.2e-06 L=5e-07
rgc2_e7_hra gc2_e7_h vthe 1e+06
rgc2_e7_hrf gc2_e7_h gc2_e7_qb 1.9e+07
cgc2_e7_hc gc2_e7_h 0 2.1e-09
ngc2_e7_dis gc2_e7_vm gc2_e7_q gc2_e7_vmd 0 nch W=4e-06 L=1e-06
va_rgc2_e7_rdis_n vrest rgc2_e7_rdis_n 0
rgc2_e7_rdis gc2_e7_vmd rgc2_e7_rdis_n 220000
ngc2_e7_rp gc2_e7_rt gc2_e7_qb vdd vsrc pch W=2e-06 L=1e-06
rgc2_e7_rrc gc2_e7_rt gc2_e7_rec 10000
cgc2_e7_rc gc2_e7_rec 0 1e-07
rgc2_e7_rr gc2_e7_rec 0 8.2e+06
ngc2_e7_sh1 gc2_e7_vm gc2_e7_rec gc2_e7_vms 0 nch W=2e-06 L=1e-06
va_ngc2_e7_sh2_s vrest ngc2_e7_sh2_s 0
ngc2_e7_sh2 gc2_e7_vms gc2_e7_qb ngc2_e7_sh2_s 0 nch W=2e-06 L=1e-06
ngc2_e7_porh gc2_e7_h por_hold vthe 0 nch W=2e-06 L=1e-06
va_ngc2_e7_porm_s vrest ngc2_e7_porm_s 0
ngc2_e7_porm gc2_e7_vm por_hold ngc2_e7_porm_s 0 nch W=2e-06 L=1e-06
ngc2_e7_ip gc2_e7_vm s2_yb vdd vsrc pch W=4e-06 L=4e-06
ngc2_e7_in gc2_e7_vm s2_za 0 0 nch W=4e-06 L=4e-06
ngc2_b7_sw gc2_b7_t gc2_e7_qb vdd vsrc pch W=2e-06 L=1e-06
rgc2_b7_rc gc2_b7_t gc2_b7 10000
cgc2_b7_c gc2_b7 0 1e-07
rgc2_b7_rl gc2_b7 0 2.2e+07
ngc2_b7_sh1p gc2_b7_n gc2_b7 vdd vsrc pch W=2.4e-06 L=5e-07
ngc2_b7_sh1n gc2_b7_n gc2_b7 0 0 nch W=1.2e-06 L=5e-07
ngc2_b7_sh2p gc2_b7_q gc2_b7_n vdd vsrc pch W=2.4e-06 L=5e-07
ngc2_b7_sh2n gc2_b7_q gc2_b7_n 0 0 nch W=1.2e-06 L=5e-07
cgc2_e8_cm gc2_e8_vm 0 1e-07
va_rgc2_e8_rm_n vrest rgc2_e8_rm_n 0
rgc2_e8_rm gc2_e8_vm rgc2_e8_rm_n 1e+06
ngc2_e8_bias0 gc2_e8_vm istep_n 0 0 nch W=4e-06 L=4e-06
ngc2_e8_bias1 gc2_e8_vm istep_n 0 0 nch W=4e-06 L=4e-06
ngc2_e8_bias2 gc2_e8_vm istep_n 0 0 nch W=4e-06 L=4e-06
ngc2_e8_bias3 gc2_e8_vm istep_n 0 0 nch W=4e-06 L=4e-06
ngc2_e8_bias4 gc2_e8_vm istep_n 0 0 nch W=4e-06 L=4e-06
ngc2_e8_bias5 gc2_e8_vm istep_n 0 0 nch W=4e-06 L=4e-06
ngc2_e8_bias6 gc2_e8_vm istep_n 0 0 nch W=4e-06 L=4e-06
ngc2_e8_bias7 gc2_e8_vm istep_n 0 0 nch W=4e-06 L=4e-06
rgc2_e8_kb vdd gc2_e8_knb 1e+06
ngc2_e8_kmb gc2_e8_knb gc2_e8_knb 0 0 nch W=4e-06 L=4e-06
ngc2_e8_kmt gc2_e8_ktail gc2_e8_knb 0 0 nch W=4e-06 L=4e-06
ngc2_e8_km1 gc2_e8_kd1 gc2_e8_vm gc2_e8_ktail 0 nch W=4e-06 L=4e-06
ngc2_e8_km2 gc2_e8_ko1 gc2_e8_h gc2_e8_ktail 0 nch W=4e-06 L=4e-06
ngc2_e8_km3 gc2_e8_kd1 gc2_e8_kd1 vdd vsrc pch W=4e-06 L=4e-06
ngc2_e8_km4 gc2_e8_ko1 gc2_e8_kd1 vdd vsrc pch W=4e-06 L=4e-06
ngc2_e8_kporclamp gc2_e8_ko1 por_hold 0 0 nch W=4e-06 L=1e-06
ngc2_e8_ki1p gc2_e8_qb gc2_e8_ko1 vdd vsrc pch W=2.4e-06 L=5e-07
ngc2_e8_ki1n gc2_e8_qb gc2_e8_ko1 0 0 nch W=1.2e-06 L=5e-07
ngc2_e8_ki2p gc2_e8_q gc2_e8_qb vdd vsrc pch W=2.4e-06 L=5e-07
ngc2_e8_ki2n gc2_e8_q gc2_e8_qb 0 0 nch W=1.2e-06 L=5e-07
rgc2_e8_hra gc2_e8_h vthe 1e+06
rgc2_e8_hrf gc2_e8_h gc2_e8_qb 1.9e+07
cgc2_e8_hc gc2_e8_h 0 2.1e-09
ngc2_e8_dis gc2_e8_vm gc2_e8_q gc2_e8_vmd 0 nch W=4e-06 L=1e-06
va_rgc2_e8_rdis_n vrest rgc2_e8_rdis_n 0
rgc2_e8_rdis gc2_e8_vmd rgc2_e8_rdis_n 220000
ngc2_e8_rp gc2_e8_rt gc2_e8_qb vdd vsrc pch W=2e-06 L=1e-06
rgc2_e8_rrc gc2_e8_rt gc2_e8_rec 10000
cgc2_e8_rc gc2_e8_rec 0 1e-07
rgc2_e8_rr gc2_e8_rec 0 8.2e+06
ngc2_e8_sh1 gc2_e8_vm gc2_e8_rec gc2_e8_vms 0 nch W=2e-06 L=1e-06
va_ngc2_e8_sh2_s vrest ngc2_e8_sh2_s 0
ngc2_e8_sh2 gc2_e8_vms gc2_e8_qb ngc2_e8_sh2_s 0 nch W=2e-06 L=1e-06
ngc2_e8_porh gc2_e8_h por_hold vthe 0 nch W=2e-06 L=1e-06
va_ngc2_e8_porm_s vrest ngc2_e8_porm_s 0
ngc2_e8_porm gc2_e8_vm por_hold ngc2_e8_porm_s 0 nch W=2e-06 L=1e-06
ngc2_e8_ip gc2_e8_vm s2_yb vdd vsrc pch W=4e-06 L=4e-06
ngc2_e8_in gc2_e8_vm s2_za 0 0 nch W=4e-06 L=4e-06
ngc2_b8_sw gc2_b8_t gc2_e8_qb vdd vsrc pch W=2e-06 L=1e-06
rgc2_b8_rc gc2_b8_t gc2_b8 10000
cgc2_b8_c gc2_b8 0 1e-07
rgc2_b8_rl gc2_b8 0 2.2e+07
ngc2_b8_sh1p gc2_b8_n gc2_b8 vdd vsrc pch W=2.4e-06 L=5e-07
ngc2_b8_sh1n gc2_b8_n gc2_b8 0 0 nch W=1.2e-06 L=5e-07
ngc2_b8_sh2p gc2_b8_q gc2_b8_n vdd vsrc pch W=2.4e-06 L=5e-07
ngc2_b8_sh2n gc2_b8_q gc2_b8_n 0 0 nch W=1.2e-06 L=5e-07
cgc2_e9_cm gc2_e9_vm 0 1e-07
va_rgc2_e9_rm_n vrest rgc2_e9_rm_n 0
rgc2_e9_rm gc2_e9_vm rgc2_e9_rm_n 1e+06
ngc2_e9_bias0 gc2_e9_vm istep_n 0 0 nch W=4e-06 L=4e-06
ngc2_e9_bias1 gc2_e9_vm istep_n 0 0 nch W=4e-06 L=4e-06
ngc2_e9_bias2 gc2_e9_vm istep_n 0 0 nch W=4e-06 L=4e-06
ngc2_e9_bias3 gc2_e9_vm istep_n 0 0 nch W=4e-06 L=4e-06
ngc2_e9_bias4 gc2_e9_vm istep_n 0 0 nch W=4e-06 L=4e-06
ngc2_e9_bias5 gc2_e9_vm istep_n 0 0 nch W=4e-06 L=4e-06
ngc2_e9_bias6 gc2_e9_vm istep_n 0 0 nch W=4e-06 L=4e-06
ngc2_e9_bias7 gc2_e9_vm istep_n 0 0 nch W=4e-06 L=4e-06
ngc2_e9_bias8 gc2_e9_vm istep_n 0 0 nch W=4e-06 L=4e-06
rgc2_e9_kb vdd gc2_e9_knb 1e+06
ngc2_e9_kmb gc2_e9_knb gc2_e9_knb 0 0 nch W=4e-06 L=4e-06
ngc2_e9_kmt gc2_e9_ktail gc2_e9_knb 0 0 nch W=4e-06 L=4e-06
ngc2_e9_km1 gc2_e9_kd1 gc2_e9_vm gc2_e9_ktail 0 nch W=4e-06 L=4e-06
ngc2_e9_km2 gc2_e9_ko1 gc2_e9_h gc2_e9_ktail 0 nch W=4e-06 L=4e-06
ngc2_e9_km3 gc2_e9_kd1 gc2_e9_kd1 vdd vsrc pch W=4e-06 L=4e-06
ngc2_e9_km4 gc2_e9_ko1 gc2_e9_kd1 vdd vsrc pch W=4e-06 L=4e-06
ngc2_e9_kporclamp gc2_e9_ko1 por_hold 0 0 nch W=4e-06 L=1e-06
ngc2_e9_ki1p gc2_e9_qb gc2_e9_ko1 vdd vsrc pch W=2.4e-06 L=5e-07
ngc2_e9_ki1n gc2_e9_qb gc2_e9_ko1 0 0 nch W=1.2e-06 L=5e-07
ngc2_e9_ki2p gc2_e9_q gc2_e9_qb vdd vsrc pch W=2.4e-06 L=5e-07
ngc2_e9_ki2n gc2_e9_q gc2_e9_qb 0 0 nch W=1.2e-06 L=5e-07
rgc2_e9_hra gc2_e9_h vthe 1e+06
rgc2_e9_hrf gc2_e9_h gc2_e9_qb 1.9e+07
cgc2_e9_hc gc2_e9_h 0 2.1e-09
ngc2_e9_dis gc2_e9_vm gc2_e9_q gc2_e9_vmd 0 nch W=4e-06 L=1e-06
va_rgc2_e9_rdis_n vrest rgc2_e9_rdis_n 0
rgc2_e9_rdis gc2_e9_vmd rgc2_e9_rdis_n 220000
ngc2_e9_rp gc2_e9_rt gc2_e9_qb vdd vsrc pch W=2e-06 L=1e-06
rgc2_e9_rrc gc2_e9_rt gc2_e9_rec 10000
cgc2_e9_rc gc2_e9_rec 0 1e-07
rgc2_e9_rr gc2_e9_rec 0 8.2e+06
ngc2_e9_sh1 gc2_e9_vm gc2_e9_rec gc2_e9_vms 0 nch W=2e-06 L=1e-06
va_ngc2_e9_sh2_s vrest ngc2_e9_sh2_s 0
ngc2_e9_sh2 gc2_e9_vms gc2_e9_qb ngc2_e9_sh2_s 0 nch W=2e-06 L=1e-06
ngc2_e9_porh gc2_e9_h por_hold vthe 0 nch W=2e-06 L=1e-06
va_ngc2_e9_porm_s vrest ngc2_e9_porm_s 0
ngc2_e9_porm gc2_e9_vm por_hold ngc2_e9_porm_s 0 nch W=2e-06 L=1e-06
ngc2_e9_ip gc2_e9_vm s2_yb vdd vsrc pch W=4e-06 L=4e-06
ngc2_e9_in gc2_e9_vm s2_za 0 0 nch W=4e-06 L=4e-06
ngc2_b9_sw gc2_b9_t gc2_e9_qb vdd vsrc pch W=2e-06 L=1e-06
rgc2_b9_rc gc2_b9_t gc2_b9 10000
cgc2_b9_c gc2_b9 0 1e-07
rgc2_b9_rl gc2_b9 0 2.2e+07
ngc2_b9_sh1p gc2_b9_n gc2_b9 vdd vsrc pch W=2.4e-06 L=5e-07
ngc2_b9_sh1n gc2_b9_n gc2_b9 0 0 nch W=1.2e-06 L=5e-07
ngc2_b9_sh2p gc2_b9_q gc2_b9_n vdd vsrc pch W=2.4e-06 L=5e-07
ngc2_b9_sh2n gc2_b9_q gc2_b9_n 0 0 nch W=1.2e-06 L=5e-07
cgc2_e10_cm gc2_e10_vm 0 1e-07
va_rgc2_e10_rm_n vrest rgc2_e10_rm_n 0
rgc2_e10_rm gc2_e10_vm rgc2_e10_rm_n 1e+06
ngc2_e10_bias0 gc2_e10_vm istep_n 0 0 nch W=4e-06 L=4e-06
ngc2_e10_bias1 gc2_e10_vm istep_n 0 0 nch W=4e-06 L=4e-06
ngc2_e10_bias2 gc2_e10_vm istep_n 0 0 nch W=4e-06 L=4e-06
ngc2_e10_bias3 gc2_e10_vm istep_n 0 0 nch W=4e-06 L=4e-06
ngc2_e10_bias4 gc2_e10_vm istep_n 0 0 nch W=4e-06 L=4e-06
ngc2_e10_bias5 gc2_e10_vm istep_n 0 0 nch W=4e-06 L=4e-06
ngc2_e10_bias6 gc2_e10_vm istep_n 0 0 nch W=4e-06 L=4e-06
ngc2_e10_bias7 gc2_e10_vm istep_n 0 0 nch W=4e-06 L=4e-06
ngc2_e10_bias8 gc2_e10_vm istep_n 0 0 nch W=4e-06 L=4e-06
ngc2_e10_bias9 gc2_e10_vm istep_n 0 0 nch W=4e-06 L=4e-06
rgc2_e10_kb vdd gc2_e10_knb 1e+06
ngc2_e10_kmb gc2_e10_knb gc2_e10_knb 0 0 nch W=4e-06 L=4e-06
ngc2_e10_kmt gc2_e10_ktail gc2_e10_knb 0 0 nch W=4e-06 L=4e-06
ngc2_e10_km1 gc2_e10_kd1 gc2_e10_vm gc2_e10_ktail 0 nch W=4e-06 L=4e-06
ngc2_e10_km2 gc2_e10_ko1 gc2_e10_h gc2_e10_ktail 0 nch W=4e-06 L=4e-06
ngc2_e10_km3 gc2_e10_kd1 gc2_e10_kd1 vdd vsrc pch W=4e-06 L=4e-06
ngc2_e10_km4 gc2_e10_ko1 gc2_e10_kd1 vdd vsrc pch W=4e-06 L=4e-06
ngc2_e10_kporclamp gc2_e10_ko1 por_hold 0 0 nch W=4e-06 L=1e-06
ngc2_e10_ki1p gc2_e10_qb gc2_e10_ko1 vdd vsrc pch W=2.4e-06 L=5e-07
ngc2_e10_ki1n gc2_e10_qb gc2_e10_ko1 0 0 nch W=1.2e-06 L=5e-07
ngc2_e10_ki2p gc2_e10_q gc2_e10_qb vdd vsrc pch W=2.4e-06 L=5e-07
ngc2_e10_ki2n gc2_e10_q gc2_e10_qb 0 0 nch W=1.2e-06 L=5e-07
rgc2_e10_hra gc2_e10_h vthe 1e+06
rgc2_e10_hrf gc2_e10_h gc2_e10_qb 1.9e+07
cgc2_e10_hc gc2_e10_h 0 2.1e-09
ngc2_e10_dis gc2_e10_vm gc2_e10_q gc2_e10_vmd 0 nch W=4e-06 L=1e-06
va_rgc2_e10_rdis_n vrest rgc2_e10_rdis_n 0
rgc2_e10_rdis gc2_e10_vmd rgc2_e10_rdis_n 220000
ngc2_e10_rp gc2_e10_rt gc2_e10_qb vdd vsrc pch W=2e-06 L=1e-06
rgc2_e10_rrc gc2_e10_rt gc2_e10_rec 10000
cgc2_e10_rc gc2_e10_rec 0 1e-07
rgc2_e10_rr gc2_e10_rec 0 8.2e+06
ngc2_e10_sh1 gc2_e10_vm gc2_e10_rec gc2_e10_vms 0 nch W=2e-06 L=1e-06
va_ngc2_e10_sh2_s vrest ngc2_e10_sh2_s 0
ngc2_e10_sh2 gc2_e10_vms gc2_e10_qb ngc2_e10_sh2_s 0 nch W=2e-06 L=1e-06
ngc2_e10_porh gc2_e10_h por_hold vthe 0 nch W=2e-06 L=1e-06
va_ngc2_e10_porm_s vrest ngc2_e10_porm_s 0
ngc2_e10_porm gc2_e10_vm por_hold ngc2_e10_porm_s 0 nch W=2e-06 L=1e-06
ngc2_e10_ip gc2_e10_vm s2_yb vdd vsrc pch W=4e-06 L=4e-06
ngc2_e10_in gc2_e10_vm s2_za 0 0 nch W=4e-06 L=4e-06
ngc2_b10_sw gc2_b10_t gc2_e10_qb vdd vsrc pch W=2e-06 L=1e-06
rgc2_b10_rc gc2_b10_t gc2_b10 10000
cgc2_b10_c gc2_b10 0 1e-07
rgc2_b10_rl gc2_b10 0 2.2e+07
ngc2_b10_sh1p gc2_b10_n gc2_b10 vdd vsrc pch W=2.4e-06 L=5e-07
ngc2_b10_sh1n gc2_b10_n gc2_b10 0 0 nch W=1.2e-06 L=5e-07
ngc2_b10_sh2p gc2_b10_q gc2_b10_n vdd vsrc pch W=2.4e-06 L=5e-07
ngc2_b10_sh2n gc2_b10_q gc2_b10_n 0 0 nch W=1.2e-06 L=5e-07
ngc2_and_a0_npa gc2_and_a0_nb gc2_b1_q vdd vsrc pch W=2.4e-06 L=5e-07
ngc2_and_a0_npb gc2_and_a0_nb gc2_b2_q vdd vsrc pch W=2.4e-06 L=5e-07
ngc2_and_a0_nna gc2_and_a0_nb gc2_b1_q gc2_and_a0_nx 0 nch W=2.4e-06 L=5e-07
ngc2_and_a0_nnb gc2_and_a0_nx gc2_b2_q 0 0 nch W=2.4e-06 L=5e-07
ngc2_and_a0_ip gc2_and_g0 gc2_and_a0_nb vdd vsrc pch W=2.4e-06 L=5e-07
ngc2_and_a0_in gc2_and_g0 gc2_and_a0_nb 0 0 nch W=1.2e-06 L=5e-07
ngc2_and_a1_npa gc2_and_a1_nb gc2_b3_q vdd vsrc pch W=2.4e-06 L=5e-07
ngc2_and_a1_npb gc2_and_a1_nb gc2_b4_q vdd vsrc pch W=2.4e-06 L=5e-07
ngc2_and_a1_nna gc2_and_a1_nb gc2_b3_q gc2_and_a1_nx 0 nch W=2.4e-06 L=5e-07
ngc2_and_a1_nnb gc2_and_a1_nx gc2_b4_q 0 0 nch W=2.4e-06 L=5e-07
ngc2_and_a1_ip gc2_and_g1 gc2_and_a1_nb vdd vsrc pch W=2.4e-06 L=5e-07
ngc2_and_a1_in gc2_and_g1 gc2_and_a1_nb 0 0 nch W=1.2e-06 L=5e-07
ngc2_and_a2_npa gc2_and_a2_nb gc2_b5_q vdd vsrc pch W=2.4e-06 L=5e-07
ngc2_and_a2_npb gc2_and_a2_nb gc2_b6_q vdd vsrc pch W=2.4e-06 L=5e-07
ngc2_and_a2_nna gc2_and_a2_nb gc2_b5_q gc2_and_a2_nx 0 nch W=2.4e-06 L=5e-07
ngc2_and_a2_nnb gc2_and_a2_nx gc2_b6_q 0 0 nch W=2.4e-06 L=5e-07
ngc2_and_a2_ip gc2_and_g2 gc2_and_a2_nb vdd vsrc pch W=2.4e-06 L=5e-07
ngc2_and_a2_in gc2_and_g2 gc2_and_a2_nb 0 0 nch W=1.2e-06 L=5e-07
ngc2_and_a3_npa gc2_and_a3_nb gc2_b7_q vdd vsrc pch W=2.4e-06 L=5e-07
ngc2_and_a3_npb gc2_and_a3_nb gc2_b8_q vdd vsrc pch W=2.4e-06 L=5e-07
ngc2_and_a3_nna gc2_and_a3_nb gc2_b7_q gc2_and_a3_nx 0 nch W=2.4e-06 L=5e-07
ngc2_and_a3_nnb gc2_and_a3_nx gc2_b8_q 0 0 nch W=2.4e-06 L=5e-07
ngc2_and_a3_ip gc2_and_g3 gc2_and_a3_nb vdd vsrc pch W=2.4e-06 L=5e-07
ngc2_and_a3_in gc2_and_g3 gc2_and_a3_nb 0 0 nch W=1.2e-06 L=5e-07
ngc2_and_a4_npa gc2_and_a4_nb gc2_b9_q vdd vsrc pch W=2.4e-06 L=5e-07
ngc2_and_a4_npb gc2_and_a4_nb gc2_b10_q vdd vsrc pch W=2.4e-06 L=5e-07
ngc2_and_a4_nna gc2_and_a4_nb gc2_b9_q gc2_and_a4_nx 0 nch W=2.4e-06 L=5e-07
ngc2_and_a4_nnb gc2_and_a4_nx gc2_b10_q 0 0 nch W=2.4e-06 L=5e-07
ngc2_and_a4_ip gc2_and_g4 gc2_and_a4_nb vdd vsrc pch W=2.4e-06 L=5e-07
ngc2_and_a4_in gc2_and_g4 gc2_and_a4_nb 0 0 nch W=1.2e-06 L=5e-07
ngc2_and_a5_npa gc2_and_a5_nb gc2_and_g0 vdd vsrc pch W=2.4e-06 L=5e-07
ngc2_and_a5_npb gc2_and_a5_nb gc2_and_g1 vdd vsrc pch W=2.4e-06 L=5e-07
ngc2_and_a5_nna gc2_and_a5_nb gc2_and_g0 gc2_and_a5_nx 0 nch W=2.4e-06 L=5e-07
ngc2_and_a5_nnb gc2_and_a5_nx gc2_and_g1 0 0 nch W=2.4e-06 L=5e-07
ngc2_and_a5_ip gc2_and_g5 gc2_and_a5_nb vdd vsrc pch W=2.4e-06 L=5e-07
ngc2_and_a5_in gc2_and_g5 gc2_and_a5_nb 0 0 nch W=1.2e-06 L=5e-07
ngc2_and_a6_npa gc2_and_a6_nb gc2_and_g2 vdd vsrc pch W=2.4e-06 L=5e-07
ngc2_and_a6_npb gc2_and_a6_nb gc2_and_g3 vdd vsrc pch W=2.4e-06 L=5e-07
ngc2_and_a6_nna gc2_and_a6_nb gc2_and_g2 gc2_and_a6_nx 0 nch W=2.4e-06 L=5e-07
ngc2_and_a6_nnb gc2_and_a6_nx gc2_and_g3 0 0 nch W=2.4e-06 L=5e-07
ngc2_and_a6_ip gc2_and_g6 gc2_and_a6_nb vdd vsrc pch W=2.4e-06 L=5e-07
ngc2_and_a6_in gc2_and_g6 gc2_and_a6_nb 0 0 nch W=1.2e-06 L=5e-07
ngc2_and_a7_npa gc2_and_a7_nb gc2_and_g5 vdd vsrc pch W=2.4e-06 L=5e-07
ngc2_and_a7_npb gc2_and_a7_nb gc2_and_g6 vdd vsrc pch W=2.4e-06 L=5e-07
ngc2_and_a7_nna gc2_and_a7_nb gc2_and_g5 gc2_and_a7_nx 0 nch W=2.4e-06 L=5e-07
ngc2_and_a7_nnb gc2_and_a7_nx gc2_and_g6 0 0 nch W=2.4e-06 L=5e-07
ngc2_and_a7_ip gc2_and_g7 gc2_and_a7_nb vdd vsrc pch W=2.4e-06 L=5e-07
ngc2_and_a7_in gc2_and_g7 gc2_and_a7_nb 0 0 nch W=1.2e-06 L=5e-07
ngc2_and_a8_npa gc2_and_a8_nb gc2_and_g7 vdd vsrc pch W=2.4e-06 L=5e-07
ngc2_and_a8_npb gc2_and_a8_nb gc2_and_g4 vdd vsrc pch W=2.4e-06 L=5e-07
ngc2_and_a8_nna gc2_and_a8_nb gc2_and_g7 gc2_and_a8_nx 0 nch W=2.4e-06 L=5e-07
ngc2_and_a8_nnb gc2_and_a8_nx gc2_and_g4 0 0 nch W=2.4e-06 L=5e-07
ngc2_and_a8_ip gc2_and_g8 gc2_and_a8_nb vdd vsrc pch W=2.4e-06 L=5e-07
ngc2_and_a8_in gc2_and_g8 gc2_and_a8_nb 0 0 nch W=1.2e-06 L=5e-07
ngc2_gip gc2_gb gc2_and_g8 vdd vsrc pch W=2.4e-06 L=5e-07
ngc2_gin gc2_gb gc2_and_g8 0 0 nch W=1.2e-06 L=5e-07
cgc2_col_cm gc2_col_vm 0 1e-07
va_rgc2_col_rm_n vrest rgc2_col_rm_n 0
rgc2_col_rm gc2_col_vm rgc2_col_rm_n 1e+06
rgc2_col_kb vdd gc2_col_knb 1e+06
ngc2_col_kmb gc2_col_knb gc2_col_knb 0 0 nch W=4e-06 L=4e-06
ngc2_col_kmt gc2_col_ktail gc2_col_knb 0 0 nch W=4e-06 L=4e-06
ngc2_col_km1 gc2_col_kd1 gc2_col_vm gc2_col_ktail 0 nch W=4e-06 L=4e-06
ngc2_col_km2 gc2_col_ko1 gc2_col_h gc2_col_ktail 0 nch W=4e-06 L=4e-06
ngc2_col_km3 gc2_col_kd1 gc2_col_kd1 vdd vsrc pch W=4e-06 L=4e-06
ngc2_col_km4 gc2_col_ko1 gc2_col_kd1 vdd vsrc pch W=4e-06 L=4e-06
ngc2_col_kporclamp gc2_col_ko1 por_hold 0 0 nch W=4e-06 L=1e-06
ngc2_col_ki1p gc2_col_qb gc2_col_ko1 vdd vsrc pch W=2.4e-06 L=5e-07
ngc2_col_ki1n gc2_col_qb gc2_col_ko1 0 0 nch W=1.2e-06 L=5e-07
ngc2_col_ki2p gc2_col_q gc2_col_qb vdd vsrc pch W=2.4e-06 L=5e-07
ngc2_col_ki2n gc2_col_q gc2_col_qb 0 0 nch W=1.2e-06 L=5e-07
rgc2_col_hra gc2_col_h vthe 1e+06
rgc2_col_hrf gc2_col_h gc2_col_qb 1.9e+07
cgc2_col_hc gc2_col_h 0 2.1e-09
ngc2_col_dis gc2_col_vm gc2_col_q gc2_col_vmd 0 nch W=4e-06 L=1e-06
va_rgc2_col_rdis_n vrest rgc2_col_rdis_n 0
rgc2_col_rdis gc2_col_vmd rgc2_col_rdis_n 220000
ngc2_col_rp gc2_col_rt gc2_col_qb vdd vsrc pch W=2e-06 L=1e-06
rgc2_col_rrc gc2_col_rt gc2_col_rec 10000
cgc2_col_rc gc2_col_rec 0 1e-07
rgc2_col_rr gc2_col_rec 0 8.2e+06
ngc2_col_sh1 gc2_col_vm gc2_col_rec gc2_col_vms 0 nch W=2e-06 L=1e-06
va_ngc2_col_sh2_s vrest ngc2_col_sh2_s 0
ngc2_col_sh2 gc2_col_vms gc2_col_qb ngc2_col_sh2_s 0 nch W=2e-06 L=1e-06
ngc2_col_porh gc2_col_h por_hold vthe 0 nch W=2e-06 L=1e-06
va_ngc2_col_porm_s vrest ngc2_col_porm_s 0
ngc2_col_porm gc2_col_vm por_hold ngc2_col_porm_s 0 nch W=2e-06 L=1e-06
ngc2_cin_eni_p gc2_cin_ena gc2_gb vdd vsrc pch W=2.4e-06 L=5e-07
ngc2_cin_eni_n gc2_cin_ena gc2_gb 0 0 nch W=1.2e-06 L=5e-07
ngc2_cin_cp gc2_col_vm gc2_cin_cg vdd vsrc pch W=4e-06 L=4e-06
ngc2_cin_bias ilimp_n gc2_gb gc2_cin_cg vsrc pch W=1.2e-06 L=1e-06
ngc2_cin_off gc2_cin_cg gc2_cin_ena vdd vsrc pch W=2.4e-06 L=1e-06
ngc2_op_tsw gc2_op_tt gc2_col_qb vdd vsrc pch W=2e-06 L=1e-06
rgc2_op_trc gc2_op_tt gc2_op_at 10000
cgc2_op_tc gc2_op_at 0 1e-07
rgc2_op_trl gc2_op_at 0 2.2e+07
ngc2_op_sh1p gc2_op_an gc2_op_at vdd vsrc pch W=2.4e-06 L=5e-07
ngc2_op_sh1n gc2_op_an gc2_op_at 0 0 nch W=1.2e-06 L=5e-07
ngc2_op_sh2p gc2_op_aq gc2_op_an vdd vsrc pch W=2.4e-06 L=5e-07
ngc2_op_sh2n gc2_op_aq gc2_op_an 0 0 nch W=1.2e-06 L=5e-07
ngc2_op_abp gc2_op_aqb gc2_op_aq vdd vsrc pch W=2.4e-06 L=5e-07
ngc2_op_abn gc2_op_aqb gc2_op_aq 0 0 nch W=1.2e-06 L=5e-07
rgc2_op_dr gc2_op_aq gc2_op_ad 1e+06
cgc2_op_dc gc2_op_ad 0 3.3e-07
ngc2_op_d2p gc2_op_adn gc2_op_ad vdd vsrc pch W=2.4e-06 L=5e-07
ngc2_op_d2n gc2_op_adn gc2_op_ad 0 0 nch W=1.2e-06 L=5e-07
ngc2_op_gpa gc2_op_pb gc2_op_aq vdd vsrc pch W=2.4e-06 L=5e-07
ngc2_op_gpb gc2_op_pb gc2_op_adn vdd vsrc pch W=2.4e-06 L=5e-07
ngc2_op_gna gc2_op_pb gc2_op_aq gc2_op_gx 0 nch W=2.4e-06 L=5e-07
ngc2_op_gnb gc2_op_gx gc2_op_adn 0 0 nch W=2.4e-06 L=5e-07
ngc2_op_op gc2_op_p gc2_op_pb vdd vsrc pch W=2.4e-06 L=5e-07
ngc2_op_on gc2_op_p gc2_op_pb 0 0 nch W=1.2e-06 L=5e-07
cgw3_e1_cm gw3_e1_vm 0 1e-07
va_rgw3_e1_rm_n vrest rgw3_e1_rm_n 0
rgw3_e1_rm gw3_e1_vm rgw3_e1_rm_n 1e+06
ngw3_e1_bias0 gw3_e1_vm istep_n 0 0 nch W=4e-06 L=4e-06
rgw3_e1_kb vdd gw3_e1_knb 1e+06
ngw3_e1_kmb gw3_e1_knb gw3_e1_knb 0 0 nch W=4e-06 L=4e-06
ngw3_e1_kmt gw3_e1_ktail gw3_e1_knb 0 0 nch W=4e-06 L=4e-06
ngw3_e1_km1 gw3_e1_kd1 gw3_e1_vm gw3_e1_ktail 0 nch W=4e-06 L=4e-06
ngw3_e1_km2 gw3_e1_ko1 gw3_e1_h gw3_e1_ktail 0 nch W=4e-06 L=4e-06
ngw3_e1_km3 gw3_e1_kd1 gw3_e1_kd1 vdd vsrc pch W=4e-06 L=4e-06
ngw3_e1_km4 gw3_e1_ko1 gw3_e1_kd1 vdd vsrc pch W=4e-06 L=4e-06
ngw3_e1_kporclamp gw3_e1_ko1 por_hold 0 0 nch W=4e-06 L=1e-06
ngw3_e1_ki1p gw3_e1_qb gw3_e1_ko1 vdd vsrc pch W=2.4e-06 L=5e-07
ngw3_e1_ki1n gw3_e1_qb gw3_e1_ko1 0 0 nch W=1.2e-06 L=5e-07
ngw3_e1_ki2p gw3_e1_q gw3_e1_qb vdd vsrc pch W=2.4e-06 L=5e-07
ngw3_e1_ki2n gw3_e1_q gw3_e1_qb 0 0 nch W=1.2e-06 L=5e-07
rgw3_e1_hra gw3_e1_h vthe 1e+06
rgw3_e1_hrf gw3_e1_h gw3_e1_qb 1.9e+07
cgw3_e1_hc gw3_e1_h 0 2.1e-09
ngw3_e1_dis gw3_e1_vm gw3_e1_q gw3_e1_vmd 0 nch W=4e-06 L=1e-06
va_rgw3_e1_rdis_n vrest rgw3_e1_rdis_n 0
rgw3_e1_rdis gw3_e1_vmd rgw3_e1_rdis_n 220000
ngw3_e1_rp gw3_e1_rt gw3_e1_qb vdd vsrc pch W=2e-06 L=1e-06
rgw3_e1_rrc gw3_e1_rt gw3_e1_rec 10000
cgw3_e1_rc gw3_e1_rec 0 1e-07
rgw3_e1_rr gw3_e1_rec 0 8.2e+06
ngw3_e1_sh1 gw3_e1_vm gw3_e1_rec gw3_e1_vms 0 nch W=2e-06 L=1e-06
va_ngw3_e1_sh2_s vrest ngw3_e1_sh2_s 0
ngw3_e1_sh2 gw3_e1_vms gw3_e1_qb ngw3_e1_sh2_s 0 nch W=2e-06 L=1e-06
ngw3_e1_porh gw3_e1_h por_hold vthe 0 nch W=2e-06 L=1e-06
va_ngw3_e1_porm_s vrest ngw3_e1_porm_s 0
ngw3_e1_porm gw3_e1_vm por_hold ngw3_e1_porm_s 0 nch W=2e-06 L=1e-06
ngw3_e1_ip gw3_e1_vm s3_ya vdd vsrc pch W=4e-06 L=4e-06
ngw3_e1_in gw3_e1_vm s3_zb 0 0 nch W=4e-06 L=4e-06
ngw3_b1_sw gw3_b1_t gw3_e1_qb vdd vsrc pch W=2e-06 L=1e-06
rgw3_b1_rc gw3_b1_t gw3_b1 10000
cgw3_b1_c gw3_b1 0 1e-07
rgw3_b1_rl gw3_b1 0 2.2e+07
ngw3_b1_sh1p gw3_b1_n gw3_b1 vdd vsrc pch W=2.4e-06 L=5e-07
ngw3_b1_sh1n gw3_b1_n gw3_b1 0 0 nch W=1.2e-06 L=5e-07
ngw3_b1_sh2p gw3_b1_q gw3_b1_n vdd vsrc pch W=2.4e-06 L=5e-07
ngw3_b1_sh2n gw3_b1_q gw3_b1_n 0 0 nch W=1.2e-06 L=5e-07
cgw3_e2_cm gw3_e2_vm 0 1e-07
va_rgw3_e2_rm_n vrest rgw3_e2_rm_n 0
rgw3_e2_rm gw3_e2_vm rgw3_e2_rm_n 1e+06
ngw3_e2_bias0 gw3_e2_vm istep_n 0 0 nch W=4e-06 L=4e-06
ngw3_e2_bias1 gw3_e2_vm istep_n 0 0 nch W=4e-06 L=4e-06
rgw3_e2_kb vdd gw3_e2_knb 1e+06
ngw3_e2_kmb gw3_e2_knb gw3_e2_knb 0 0 nch W=4e-06 L=4e-06
ngw3_e2_kmt gw3_e2_ktail gw3_e2_knb 0 0 nch W=4e-06 L=4e-06
ngw3_e2_km1 gw3_e2_kd1 gw3_e2_vm gw3_e2_ktail 0 nch W=4e-06 L=4e-06
ngw3_e2_km2 gw3_e2_ko1 gw3_e2_h gw3_e2_ktail 0 nch W=4e-06 L=4e-06
ngw3_e2_km3 gw3_e2_kd1 gw3_e2_kd1 vdd vsrc pch W=4e-06 L=4e-06
ngw3_e2_km4 gw3_e2_ko1 gw3_e2_kd1 vdd vsrc pch W=4e-06 L=4e-06
ngw3_e2_kporclamp gw3_e2_ko1 por_hold 0 0 nch W=4e-06 L=1e-06
ngw3_e2_ki1p gw3_e2_qb gw3_e2_ko1 vdd vsrc pch W=2.4e-06 L=5e-07
ngw3_e2_ki1n gw3_e2_qb gw3_e2_ko1 0 0 nch W=1.2e-06 L=5e-07
ngw3_e2_ki2p gw3_e2_q gw3_e2_qb vdd vsrc pch W=2.4e-06 L=5e-07
ngw3_e2_ki2n gw3_e2_q gw3_e2_qb 0 0 nch W=1.2e-06 L=5e-07
rgw3_e2_hra gw3_e2_h vthe 1e+06
rgw3_e2_hrf gw3_e2_h gw3_e2_qb 1.9e+07
cgw3_e2_hc gw3_e2_h 0 2.1e-09
ngw3_e2_dis gw3_e2_vm gw3_e2_q gw3_e2_vmd 0 nch W=4e-06 L=1e-06
va_rgw3_e2_rdis_n vrest rgw3_e2_rdis_n 0
rgw3_e2_rdis gw3_e2_vmd rgw3_e2_rdis_n 220000
ngw3_e2_rp gw3_e2_rt gw3_e2_qb vdd vsrc pch W=2e-06 L=1e-06
rgw3_e2_rrc gw3_e2_rt gw3_e2_rec 10000
cgw3_e2_rc gw3_e2_rec 0 1e-07
rgw3_e2_rr gw3_e2_rec 0 8.2e+06
ngw3_e2_sh1 gw3_e2_vm gw3_e2_rec gw3_e2_vms 0 nch W=2e-06 L=1e-06
va_ngw3_e2_sh2_s vrest ngw3_e2_sh2_s 0
ngw3_e2_sh2 gw3_e2_vms gw3_e2_qb ngw3_e2_sh2_s 0 nch W=2e-06 L=1e-06
ngw3_e2_porh gw3_e2_h por_hold vthe 0 nch W=2e-06 L=1e-06
va_ngw3_e2_porm_s vrest ngw3_e2_porm_s 0
ngw3_e2_porm gw3_e2_vm por_hold ngw3_e2_porm_s 0 nch W=2e-06 L=1e-06
ngw3_e2_ip gw3_e2_vm s3_ya vdd vsrc pch W=4e-06 L=4e-06
ngw3_e2_in gw3_e2_vm s3_zb 0 0 nch W=4e-06 L=4e-06
ngw3_b2_sw gw3_b2_t gw3_e2_qb vdd vsrc pch W=2e-06 L=1e-06
rgw3_b2_rc gw3_b2_t gw3_b2 10000
cgw3_b2_c gw3_b2 0 1e-07
rgw3_b2_rl gw3_b2 0 2.2e+07
ngw3_b2_sh1p gw3_b2_n gw3_b2 vdd vsrc pch W=2.4e-06 L=5e-07
ngw3_b2_sh1n gw3_b2_n gw3_b2 0 0 nch W=1.2e-06 L=5e-07
ngw3_b2_sh2p gw3_b2_q gw3_b2_n vdd vsrc pch W=2.4e-06 L=5e-07
ngw3_b2_sh2n gw3_b2_q gw3_b2_n 0 0 nch W=1.2e-06 L=5e-07
cgw3_e3_cm gw3_e3_vm 0 1e-07
va_rgw3_e3_rm_n vrest rgw3_e3_rm_n 0
rgw3_e3_rm gw3_e3_vm rgw3_e3_rm_n 1e+06
ngw3_e3_bias0 gw3_e3_vm istep_n 0 0 nch W=4e-06 L=4e-06
ngw3_e3_bias1 gw3_e3_vm istep_n 0 0 nch W=4e-06 L=4e-06
ngw3_e3_bias2 gw3_e3_vm istep_n 0 0 nch W=4e-06 L=4e-06
rgw3_e3_kb vdd gw3_e3_knb 1e+06
ngw3_e3_kmb gw3_e3_knb gw3_e3_knb 0 0 nch W=4e-06 L=4e-06
ngw3_e3_kmt gw3_e3_ktail gw3_e3_knb 0 0 nch W=4e-06 L=4e-06
ngw3_e3_km1 gw3_e3_kd1 gw3_e3_vm gw3_e3_ktail 0 nch W=4e-06 L=4e-06
ngw3_e3_km2 gw3_e3_ko1 gw3_e3_h gw3_e3_ktail 0 nch W=4e-06 L=4e-06
ngw3_e3_km3 gw3_e3_kd1 gw3_e3_kd1 vdd vsrc pch W=4e-06 L=4e-06
ngw3_e3_km4 gw3_e3_ko1 gw3_e3_kd1 vdd vsrc pch W=4e-06 L=4e-06
ngw3_e3_kporclamp gw3_e3_ko1 por_hold 0 0 nch W=4e-06 L=1e-06
ngw3_e3_ki1p gw3_e3_qb gw3_e3_ko1 vdd vsrc pch W=2.4e-06 L=5e-07
ngw3_e3_ki1n gw3_e3_qb gw3_e3_ko1 0 0 nch W=1.2e-06 L=5e-07
ngw3_e3_ki2p gw3_e3_q gw3_e3_qb vdd vsrc pch W=2.4e-06 L=5e-07
ngw3_e3_ki2n gw3_e3_q gw3_e3_qb 0 0 nch W=1.2e-06 L=5e-07
rgw3_e3_hra gw3_e3_h vthe 1e+06
rgw3_e3_hrf gw3_e3_h gw3_e3_qb 1.9e+07
cgw3_e3_hc gw3_e3_h 0 2.1e-09
ngw3_e3_dis gw3_e3_vm gw3_e3_q gw3_e3_vmd 0 nch W=4e-06 L=1e-06
va_rgw3_e3_rdis_n vrest rgw3_e3_rdis_n 0
rgw3_e3_rdis gw3_e3_vmd rgw3_e3_rdis_n 220000
ngw3_e3_rp gw3_e3_rt gw3_e3_qb vdd vsrc pch W=2e-06 L=1e-06
rgw3_e3_rrc gw3_e3_rt gw3_e3_rec 10000
cgw3_e3_rc gw3_e3_rec 0 1e-07
rgw3_e3_rr gw3_e3_rec 0 8.2e+06
ngw3_e3_sh1 gw3_e3_vm gw3_e3_rec gw3_e3_vms 0 nch W=2e-06 L=1e-06
va_ngw3_e3_sh2_s vrest ngw3_e3_sh2_s 0
ngw3_e3_sh2 gw3_e3_vms gw3_e3_qb ngw3_e3_sh2_s 0 nch W=2e-06 L=1e-06
ngw3_e3_porh gw3_e3_h por_hold vthe 0 nch W=2e-06 L=1e-06
va_ngw3_e3_porm_s vrest ngw3_e3_porm_s 0
ngw3_e3_porm gw3_e3_vm por_hold ngw3_e3_porm_s 0 nch W=2e-06 L=1e-06
ngw3_e3_ip gw3_e3_vm s3_ya vdd vsrc pch W=4e-06 L=4e-06
ngw3_e3_in gw3_e3_vm s3_zb 0 0 nch W=4e-06 L=4e-06
ngw3_b3_sw gw3_b3_t gw3_e3_qb vdd vsrc pch W=2e-06 L=1e-06
rgw3_b3_rc gw3_b3_t gw3_b3 10000
cgw3_b3_c gw3_b3 0 1e-07
rgw3_b3_rl gw3_b3 0 2.2e+07
ngw3_b3_sh1p gw3_b3_n gw3_b3 vdd vsrc pch W=2.4e-06 L=5e-07
ngw3_b3_sh1n gw3_b3_n gw3_b3 0 0 nch W=1.2e-06 L=5e-07
ngw3_b3_sh2p gw3_b3_q gw3_b3_n vdd vsrc pch W=2.4e-06 L=5e-07
ngw3_b3_sh2n gw3_b3_q gw3_b3_n 0 0 nch W=1.2e-06 L=5e-07
cgw3_e4_cm gw3_e4_vm 0 1e-07
va_rgw3_e4_rm_n vrest rgw3_e4_rm_n 0
rgw3_e4_rm gw3_e4_vm rgw3_e4_rm_n 1e+06
ngw3_e4_bias0 gw3_e4_vm istep_n 0 0 nch W=4e-06 L=4e-06
ngw3_e4_bias1 gw3_e4_vm istep_n 0 0 nch W=4e-06 L=4e-06
ngw3_e4_bias2 gw3_e4_vm istep_n 0 0 nch W=4e-06 L=4e-06
ngw3_e4_bias3 gw3_e4_vm istep_n 0 0 nch W=4e-06 L=4e-06
rgw3_e4_kb vdd gw3_e4_knb 1e+06
ngw3_e4_kmb gw3_e4_knb gw3_e4_knb 0 0 nch W=4e-06 L=4e-06
ngw3_e4_kmt gw3_e4_ktail gw3_e4_knb 0 0 nch W=4e-06 L=4e-06
ngw3_e4_km1 gw3_e4_kd1 gw3_e4_vm gw3_e4_ktail 0 nch W=4e-06 L=4e-06
ngw3_e4_km2 gw3_e4_ko1 gw3_e4_h gw3_e4_ktail 0 nch W=4e-06 L=4e-06
ngw3_e4_km3 gw3_e4_kd1 gw3_e4_kd1 vdd vsrc pch W=4e-06 L=4e-06
ngw3_e4_km4 gw3_e4_ko1 gw3_e4_kd1 vdd vsrc pch W=4e-06 L=4e-06
ngw3_e4_kporclamp gw3_e4_ko1 por_hold 0 0 nch W=4e-06 L=1e-06
ngw3_e4_ki1p gw3_e4_qb gw3_e4_ko1 vdd vsrc pch W=2.4e-06 L=5e-07
ngw3_e4_ki1n gw3_e4_qb gw3_e4_ko1 0 0 nch W=1.2e-06 L=5e-07
ngw3_e4_ki2p gw3_e4_q gw3_e4_qb vdd vsrc pch W=2.4e-06 L=5e-07
ngw3_e4_ki2n gw3_e4_q gw3_e4_qb 0 0 nch W=1.2e-06 L=5e-07
rgw3_e4_hra gw3_e4_h vthe 1e+06
rgw3_e4_hrf gw3_e4_h gw3_e4_qb 1.9e+07
cgw3_e4_hc gw3_e4_h 0 2.1e-09
ngw3_e4_dis gw3_e4_vm gw3_e4_q gw3_e4_vmd 0 nch W=4e-06 L=1e-06
va_rgw3_e4_rdis_n vrest rgw3_e4_rdis_n 0
rgw3_e4_rdis gw3_e4_vmd rgw3_e4_rdis_n 220000
ngw3_e4_rp gw3_e4_rt gw3_e4_qb vdd vsrc pch W=2e-06 L=1e-06
rgw3_e4_rrc gw3_e4_rt gw3_e4_rec 10000
cgw3_e4_rc gw3_e4_rec 0 1e-07
rgw3_e4_rr gw3_e4_rec 0 8.2e+06
ngw3_e4_sh1 gw3_e4_vm gw3_e4_rec gw3_e4_vms 0 nch W=2e-06 L=1e-06
va_ngw3_e4_sh2_s vrest ngw3_e4_sh2_s 0
ngw3_e4_sh2 gw3_e4_vms gw3_e4_qb ngw3_e4_sh2_s 0 nch W=2e-06 L=1e-06
ngw3_e4_porh gw3_e4_h por_hold vthe 0 nch W=2e-06 L=1e-06
va_ngw3_e4_porm_s vrest ngw3_e4_porm_s 0
ngw3_e4_porm gw3_e4_vm por_hold ngw3_e4_porm_s 0 nch W=2e-06 L=1e-06
ngw3_e4_ip gw3_e4_vm s3_ya vdd vsrc pch W=4e-06 L=4e-06
ngw3_e4_in gw3_e4_vm s3_zb 0 0 nch W=4e-06 L=4e-06
ngw3_b4_sw gw3_b4_t gw3_e4_qb vdd vsrc pch W=2e-06 L=1e-06
rgw3_b4_rc gw3_b4_t gw3_b4 10000
cgw3_b4_c gw3_b4 0 1e-07
rgw3_b4_rl gw3_b4 0 2.2e+07
ngw3_b4_sh1p gw3_b4_n gw3_b4 vdd vsrc pch W=2.4e-06 L=5e-07
ngw3_b4_sh1n gw3_b4_n gw3_b4 0 0 nch W=1.2e-06 L=5e-07
ngw3_b4_sh2p gw3_b4_q gw3_b4_n vdd vsrc pch W=2.4e-06 L=5e-07
ngw3_b4_sh2n gw3_b4_q gw3_b4_n 0 0 nch W=1.2e-06 L=5e-07
cgw3_e5_cm gw3_e5_vm 0 1e-07
va_rgw3_e5_rm_n vrest rgw3_e5_rm_n 0
rgw3_e5_rm gw3_e5_vm rgw3_e5_rm_n 1e+06
ngw3_e5_bias0 gw3_e5_vm istep_n 0 0 nch W=4e-06 L=4e-06
ngw3_e5_bias1 gw3_e5_vm istep_n 0 0 nch W=4e-06 L=4e-06
ngw3_e5_bias2 gw3_e5_vm istep_n 0 0 nch W=4e-06 L=4e-06
ngw3_e5_bias3 gw3_e5_vm istep_n 0 0 nch W=4e-06 L=4e-06
ngw3_e5_bias4 gw3_e5_vm istep_n 0 0 nch W=4e-06 L=4e-06
rgw3_e5_kb vdd gw3_e5_knb 1e+06
ngw3_e5_kmb gw3_e5_knb gw3_e5_knb 0 0 nch W=4e-06 L=4e-06
ngw3_e5_kmt gw3_e5_ktail gw3_e5_knb 0 0 nch W=4e-06 L=4e-06
ngw3_e5_km1 gw3_e5_kd1 gw3_e5_vm gw3_e5_ktail 0 nch W=4e-06 L=4e-06
ngw3_e5_km2 gw3_e5_ko1 gw3_e5_h gw3_e5_ktail 0 nch W=4e-06 L=4e-06
ngw3_e5_km3 gw3_e5_kd1 gw3_e5_kd1 vdd vsrc pch W=4e-06 L=4e-06
ngw3_e5_km4 gw3_e5_ko1 gw3_e5_kd1 vdd vsrc pch W=4e-06 L=4e-06
ngw3_e5_kporclamp gw3_e5_ko1 por_hold 0 0 nch W=4e-06 L=1e-06
ngw3_e5_ki1p gw3_e5_qb gw3_e5_ko1 vdd vsrc pch W=2.4e-06 L=5e-07
ngw3_e5_ki1n gw3_e5_qb gw3_e5_ko1 0 0 nch W=1.2e-06 L=5e-07
ngw3_e5_ki2p gw3_e5_q gw3_e5_qb vdd vsrc pch W=2.4e-06 L=5e-07
ngw3_e5_ki2n gw3_e5_q gw3_e5_qb 0 0 nch W=1.2e-06 L=5e-07
rgw3_e5_hra gw3_e5_h vthe 1e+06
rgw3_e5_hrf gw3_e5_h gw3_e5_qb 1.9e+07
cgw3_e5_hc gw3_e5_h 0 2.1e-09
ngw3_e5_dis gw3_e5_vm gw3_e5_q gw3_e5_vmd 0 nch W=4e-06 L=1e-06
va_rgw3_e5_rdis_n vrest rgw3_e5_rdis_n 0
rgw3_e5_rdis gw3_e5_vmd rgw3_e5_rdis_n 220000
ngw3_e5_rp gw3_e5_rt gw3_e5_qb vdd vsrc pch W=2e-06 L=1e-06
rgw3_e5_rrc gw3_e5_rt gw3_e5_rec 10000
cgw3_e5_rc gw3_e5_rec 0 1e-07
rgw3_e5_rr gw3_e5_rec 0 8.2e+06
ngw3_e5_sh1 gw3_e5_vm gw3_e5_rec gw3_e5_vms 0 nch W=2e-06 L=1e-06
va_ngw3_e5_sh2_s vrest ngw3_e5_sh2_s 0
ngw3_e5_sh2 gw3_e5_vms gw3_e5_qb ngw3_e5_sh2_s 0 nch W=2e-06 L=1e-06
ngw3_e5_porh gw3_e5_h por_hold vthe 0 nch W=2e-06 L=1e-06
va_ngw3_e5_porm_s vrest ngw3_e5_porm_s 0
ngw3_e5_porm gw3_e5_vm por_hold ngw3_e5_porm_s 0 nch W=2e-06 L=1e-06
ngw3_e5_ip gw3_e5_vm s3_ya vdd vsrc pch W=4e-06 L=4e-06
ngw3_e5_in gw3_e5_vm s3_zb 0 0 nch W=4e-06 L=4e-06
ngw3_b5_sw gw3_b5_t gw3_e5_qb vdd vsrc pch W=2e-06 L=1e-06
rgw3_b5_rc gw3_b5_t gw3_b5 10000
cgw3_b5_c gw3_b5 0 1e-07
rgw3_b5_rl gw3_b5 0 2.2e+07
ngw3_b5_sh1p gw3_b5_n gw3_b5 vdd vsrc pch W=2.4e-06 L=5e-07
ngw3_b5_sh1n gw3_b5_n gw3_b5 0 0 nch W=1.2e-06 L=5e-07
ngw3_b5_sh2p gw3_b5_q gw3_b5_n vdd vsrc pch W=2.4e-06 L=5e-07
ngw3_b5_sh2n gw3_b5_q gw3_b5_n 0 0 nch W=1.2e-06 L=5e-07
cgw3_e6_cm gw3_e6_vm 0 1e-07
va_rgw3_e6_rm_n vrest rgw3_e6_rm_n 0
rgw3_e6_rm gw3_e6_vm rgw3_e6_rm_n 1e+06
ngw3_e6_bias0 gw3_e6_vm istep_n 0 0 nch W=4e-06 L=4e-06
ngw3_e6_bias1 gw3_e6_vm istep_n 0 0 nch W=4e-06 L=4e-06
ngw3_e6_bias2 gw3_e6_vm istep_n 0 0 nch W=4e-06 L=4e-06
ngw3_e6_bias3 gw3_e6_vm istep_n 0 0 nch W=4e-06 L=4e-06
ngw3_e6_bias4 gw3_e6_vm istep_n 0 0 nch W=4e-06 L=4e-06
ngw3_e6_bias5 gw3_e6_vm istep_n 0 0 nch W=4e-06 L=4e-06
rgw3_e6_kb vdd gw3_e6_knb 1e+06
ngw3_e6_kmb gw3_e6_knb gw3_e6_knb 0 0 nch W=4e-06 L=4e-06
ngw3_e6_kmt gw3_e6_ktail gw3_e6_knb 0 0 nch W=4e-06 L=4e-06
ngw3_e6_km1 gw3_e6_kd1 gw3_e6_vm gw3_e6_ktail 0 nch W=4e-06 L=4e-06
ngw3_e6_km2 gw3_e6_ko1 gw3_e6_h gw3_e6_ktail 0 nch W=4e-06 L=4e-06
ngw3_e6_km3 gw3_e6_kd1 gw3_e6_kd1 vdd vsrc pch W=4e-06 L=4e-06
ngw3_e6_km4 gw3_e6_ko1 gw3_e6_kd1 vdd vsrc pch W=4e-06 L=4e-06
ngw3_e6_kporclamp gw3_e6_ko1 por_hold 0 0 nch W=4e-06 L=1e-06
ngw3_e6_ki1p gw3_e6_qb gw3_e6_ko1 vdd vsrc pch W=2.4e-06 L=5e-07
ngw3_e6_ki1n gw3_e6_qb gw3_e6_ko1 0 0 nch W=1.2e-06 L=5e-07
ngw3_e6_ki2p gw3_e6_q gw3_e6_qb vdd vsrc pch W=2.4e-06 L=5e-07
ngw3_e6_ki2n gw3_e6_q gw3_e6_qb 0 0 nch W=1.2e-06 L=5e-07
rgw3_e6_hra gw3_e6_h vthe 1e+06
rgw3_e6_hrf gw3_e6_h gw3_e6_qb 1.9e+07
cgw3_e6_hc gw3_e6_h 0 2.1e-09
ngw3_e6_dis gw3_e6_vm gw3_e6_q gw3_e6_vmd 0 nch W=4e-06 L=1e-06
va_rgw3_e6_rdis_n vrest rgw3_e6_rdis_n 0
rgw3_e6_rdis gw3_e6_vmd rgw3_e6_rdis_n 220000
ngw3_e6_rp gw3_e6_rt gw3_e6_qb vdd vsrc pch W=2e-06 L=1e-06
rgw3_e6_rrc gw3_e6_rt gw3_e6_rec 10000
cgw3_e6_rc gw3_e6_rec 0 1e-07
rgw3_e6_rr gw3_e6_rec 0 8.2e+06
ngw3_e6_sh1 gw3_e6_vm gw3_e6_rec gw3_e6_vms 0 nch W=2e-06 L=1e-06
va_ngw3_e6_sh2_s vrest ngw3_e6_sh2_s 0
ngw3_e6_sh2 gw3_e6_vms gw3_e6_qb ngw3_e6_sh2_s 0 nch W=2e-06 L=1e-06
ngw3_e6_porh gw3_e6_h por_hold vthe 0 nch W=2e-06 L=1e-06
va_ngw3_e6_porm_s vrest ngw3_e6_porm_s 0
ngw3_e6_porm gw3_e6_vm por_hold ngw3_e6_porm_s 0 nch W=2e-06 L=1e-06
ngw3_e6_ip gw3_e6_vm s3_ya vdd vsrc pch W=4e-06 L=4e-06
ngw3_e6_in gw3_e6_vm s3_zb 0 0 nch W=4e-06 L=4e-06
ngw3_b6_sw gw3_b6_t gw3_e6_qb vdd vsrc pch W=2e-06 L=1e-06
rgw3_b6_rc gw3_b6_t gw3_b6 10000
cgw3_b6_c gw3_b6 0 1e-07
rgw3_b6_rl gw3_b6 0 2.2e+07
ngw3_b6_sh1p gw3_b6_n gw3_b6 vdd vsrc pch W=2.4e-06 L=5e-07
ngw3_b6_sh1n gw3_b6_n gw3_b6 0 0 nch W=1.2e-06 L=5e-07
ngw3_b6_sh2p gw3_b6_q gw3_b6_n vdd vsrc pch W=2.4e-06 L=5e-07
ngw3_b6_sh2n gw3_b6_q gw3_b6_n 0 0 nch W=1.2e-06 L=5e-07
cgw3_e7_cm gw3_e7_vm 0 1e-07
va_rgw3_e7_rm_n vrest rgw3_e7_rm_n 0
rgw3_e7_rm gw3_e7_vm rgw3_e7_rm_n 1e+06
ngw3_e7_bias0 gw3_e7_vm istep_n 0 0 nch W=4e-06 L=4e-06
ngw3_e7_bias1 gw3_e7_vm istep_n 0 0 nch W=4e-06 L=4e-06
ngw3_e7_bias2 gw3_e7_vm istep_n 0 0 nch W=4e-06 L=4e-06
ngw3_e7_bias3 gw3_e7_vm istep_n 0 0 nch W=4e-06 L=4e-06
ngw3_e7_bias4 gw3_e7_vm istep_n 0 0 nch W=4e-06 L=4e-06
ngw3_e7_bias5 gw3_e7_vm istep_n 0 0 nch W=4e-06 L=4e-06
ngw3_e7_bias6 gw3_e7_vm istep_n 0 0 nch W=4e-06 L=4e-06
rgw3_e7_kb vdd gw3_e7_knb 1e+06
ngw3_e7_kmb gw3_e7_knb gw3_e7_knb 0 0 nch W=4e-06 L=4e-06
ngw3_e7_kmt gw3_e7_ktail gw3_e7_knb 0 0 nch W=4e-06 L=4e-06
ngw3_e7_km1 gw3_e7_kd1 gw3_e7_vm gw3_e7_ktail 0 nch W=4e-06 L=4e-06
ngw3_e7_km2 gw3_e7_ko1 gw3_e7_h gw3_e7_ktail 0 nch W=4e-06 L=4e-06
ngw3_e7_km3 gw3_e7_kd1 gw3_e7_kd1 vdd vsrc pch W=4e-06 L=4e-06
ngw3_e7_km4 gw3_e7_ko1 gw3_e7_kd1 vdd vsrc pch W=4e-06 L=4e-06
ngw3_e7_kporclamp gw3_e7_ko1 por_hold 0 0 nch W=4e-06 L=1e-06
ngw3_e7_ki1p gw3_e7_qb gw3_e7_ko1 vdd vsrc pch W=2.4e-06 L=5e-07
ngw3_e7_ki1n gw3_e7_qb gw3_e7_ko1 0 0 nch W=1.2e-06 L=5e-07
ngw3_e7_ki2p gw3_e7_q gw3_e7_qb vdd vsrc pch W=2.4e-06 L=5e-07
ngw3_e7_ki2n gw3_e7_q gw3_e7_qb 0 0 nch W=1.2e-06 L=5e-07
rgw3_e7_hra gw3_e7_h vthe 1e+06
rgw3_e7_hrf gw3_e7_h gw3_e7_qb 1.9e+07
cgw3_e7_hc gw3_e7_h 0 2.1e-09
ngw3_e7_dis gw3_e7_vm gw3_e7_q gw3_e7_vmd 0 nch W=4e-06 L=1e-06
va_rgw3_e7_rdis_n vrest rgw3_e7_rdis_n 0
rgw3_e7_rdis gw3_e7_vmd rgw3_e7_rdis_n 220000
ngw3_e7_rp gw3_e7_rt gw3_e7_qb vdd vsrc pch W=2e-06 L=1e-06
rgw3_e7_rrc gw3_e7_rt gw3_e7_rec 10000
cgw3_e7_rc gw3_e7_rec 0 1e-07
rgw3_e7_rr gw3_e7_rec 0 8.2e+06
ngw3_e7_sh1 gw3_e7_vm gw3_e7_rec gw3_e7_vms 0 nch W=2e-06 L=1e-06
va_ngw3_e7_sh2_s vrest ngw3_e7_sh2_s 0
ngw3_e7_sh2 gw3_e7_vms gw3_e7_qb ngw3_e7_sh2_s 0 nch W=2e-06 L=1e-06
ngw3_e7_porh gw3_e7_h por_hold vthe 0 nch W=2e-06 L=1e-06
va_ngw3_e7_porm_s vrest ngw3_e7_porm_s 0
ngw3_e7_porm gw3_e7_vm por_hold ngw3_e7_porm_s 0 nch W=2e-06 L=1e-06
ngw3_e7_ip gw3_e7_vm s3_ya vdd vsrc pch W=4e-06 L=4e-06
ngw3_e7_in gw3_e7_vm s3_zb 0 0 nch W=4e-06 L=4e-06
ngw3_b7_sw gw3_b7_t gw3_e7_qb vdd vsrc pch W=2e-06 L=1e-06
rgw3_b7_rc gw3_b7_t gw3_b7 10000
cgw3_b7_c gw3_b7 0 1e-07
rgw3_b7_rl gw3_b7 0 2.2e+07
ngw3_b7_sh1p gw3_b7_n gw3_b7 vdd vsrc pch W=2.4e-06 L=5e-07
ngw3_b7_sh1n gw3_b7_n gw3_b7 0 0 nch W=1.2e-06 L=5e-07
ngw3_b7_sh2p gw3_b7_q gw3_b7_n vdd vsrc pch W=2.4e-06 L=5e-07
ngw3_b7_sh2n gw3_b7_q gw3_b7_n 0 0 nch W=1.2e-06 L=5e-07
cgw3_e8_cm gw3_e8_vm 0 1e-07
va_rgw3_e8_rm_n vrest rgw3_e8_rm_n 0
rgw3_e8_rm gw3_e8_vm rgw3_e8_rm_n 1e+06
ngw3_e8_bias0 gw3_e8_vm istep_n 0 0 nch W=4e-06 L=4e-06
ngw3_e8_bias1 gw3_e8_vm istep_n 0 0 nch W=4e-06 L=4e-06
ngw3_e8_bias2 gw3_e8_vm istep_n 0 0 nch W=4e-06 L=4e-06
ngw3_e8_bias3 gw3_e8_vm istep_n 0 0 nch W=4e-06 L=4e-06
ngw3_e8_bias4 gw3_e8_vm istep_n 0 0 nch W=4e-06 L=4e-06
ngw3_e8_bias5 gw3_e8_vm istep_n 0 0 nch W=4e-06 L=4e-06
ngw3_e8_bias6 gw3_e8_vm istep_n 0 0 nch W=4e-06 L=4e-06
ngw3_e8_bias7 gw3_e8_vm istep_n 0 0 nch W=4e-06 L=4e-06
rgw3_e8_kb vdd gw3_e8_knb 1e+06
ngw3_e8_kmb gw3_e8_knb gw3_e8_knb 0 0 nch W=4e-06 L=4e-06
ngw3_e8_kmt gw3_e8_ktail gw3_e8_knb 0 0 nch W=4e-06 L=4e-06
ngw3_e8_km1 gw3_e8_kd1 gw3_e8_vm gw3_e8_ktail 0 nch W=4e-06 L=4e-06
ngw3_e8_km2 gw3_e8_ko1 gw3_e8_h gw3_e8_ktail 0 nch W=4e-06 L=4e-06
ngw3_e8_km3 gw3_e8_kd1 gw3_e8_kd1 vdd vsrc pch W=4e-06 L=4e-06
ngw3_e8_km4 gw3_e8_ko1 gw3_e8_kd1 vdd vsrc pch W=4e-06 L=4e-06
ngw3_e8_kporclamp gw3_e8_ko1 por_hold 0 0 nch W=4e-06 L=1e-06
ngw3_e8_ki1p gw3_e8_qb gw3_e8_ko1 vdd vsrc pch W=2.4e-06 L=5e-07
ngw3_e8_ki1n gw3_e8_qb gw3_e8_ko1 0 0 nch W=1.2e-06 L=5e-07
ngw3_e8_ki2p gw3_e8_q gw3_e8_qb vdd vsrc pch W=2.4e-06 L=5e-07
ngw3_e8_ki2n gw3_e8_q gw3_e8_qb 0 0 nch W=1.2e-06 L=5e-07
rgw3_e8_hra gw3_e8_h vthe 1e+06
rgw3_e8_hrf gw3_e8_h gw3_e8_qb 1.9e+07
cgw3_e8_hc gw3_e8_h 0 2.1e-09
ngw3_e8_dis gw3_e8_vm gw3_e8_q gw3_e8_vmd 0 nch W=4e-06 L=1e-06
va_rgw3_e8_rdis_n vrest rgw3_e8_rdis_n 0
rgw3_e8_rdis gw3_e8_vmd rgw3_e8_rdis_n 220000
ngw3_e8_rp gw3_e8_rt gw3_e8_qb vdd vsrc pch W=2e-06 L=1e-06
rgw3_e8_rrc gw3_e8_rt gw3_e8_rec 10000
cgw3_e8_rc gw3_e8_rec 0 1e-07
rgw3_e8_rr gw3_e8_rec 0 8.2e+06
ngw3_e8_sh1 gw3_e8_vm gw3_e8_rec gw3_e8_vms 0 nch W=2e-06 L=1e-06
va_ngw3_e8_sh2_s vrest ngw3_e8_sh2_s 0
ngw3_e8_sh2 gw3_e8_vms gw3_e8_qb ngw3_e8_sh2_s 0 nch W=2e-06 L=1e-06
ngw3_e8_porh gw3_e8_h por_hold vthe 0 nch W=2e-06 L=1e-06
va_ngw3_e8_porm_s vrest ngw3_e8_porm_s 0
ngw3_e8_porm gw3_e8_vm por_hold ngw3_e8_porm_s 0 nch W=2e-06 L=1e-06
ngw3_e8_ip gw3_e8_vm s3_ya vdd vsrc pch W=4e-06 L=4e-06
ngw3_e8_in gw3_e8_vm s3_zb 0 0 nch W=4e-06 L=4e-06
ngw3_b8_sw gw3_b8_t gw3_e8_qb vdd vsrc pch W=2e-06 L=1e-06
rgw3_b8_rc gw3_b8_t gw3_b8 10000
cgw3_b8_c gw3_b8 0 1e-07
rgw3_b8_rl gw3_b8 0 2.2e+07
ngw3_b8_sh1p gw3_b8_n gw3_b8 vdd vsrc pch W=2.4e-06 L=5e-07
ngw3_b8_sh1n gw3_b8_n gw3_b8 0 0 nch W=1.2e-06 L=5e-07
ngw3_b8_sh2p gw3_b8_q gw3_b8_n vdd vsrc pch W=2.4e-06 L=5e-07
ngw3_b8_sh2n gw3_b8_q gw3_b8_n 0 0 nch W=1.2e-06 L=5e-07
cgw3_e9_cm gw3_e9_vm 0 1e-07
va_rgw3_e9_rm_n vrest rgw3_e9_rm_n 0
rgw3_e9_rm gw3_e9_vm rgw3_e9_rm_n 1e+06
ngw3_e9_bias0 gw3_e9_vm istep_n 0 0 nch W=4e-06 L=4e-06
ngw3_e9_bias1 gw3_e9_vm istep_n 0 0 nch W=4e-06 L=4e-06
ngw3_e9_bias2 gw3_e9_vm istep_n 0 0 nch W=4e-06 L=4e-06
ngw3_e9_bias3 gw3_e9_vm istep_n 0 0 nch W=4e-06 L=4e-06
ngw3_e9_bias4 gw3_e9_vm istep_n 0 0 nch W=4e-06 L=4e-06
ngw3_e9_bias5 gw3_e9_vm istep_n 0 0 nch W=4e-06 L=4e-06
ngw3_e9_bias6 gw3_e9_vm istep_n 0 0 nch W=4e-06 L=4e-06
ngw3_e9_bias7 gw3_e9_vm istep_n 0 0 nch W=4e-06 L=4e-06
ngw3_e9_bias8 gw3_e9_vm istep_n 0 0 nch W=4e-06 L=4e-06
rgw3_e9_kb vdd gw3_e9_knb 1e+06
ngw3_e9_kmb gw3_e9_knb gw3_e9_knb 0 0 nch W=4e-06 L=4e-06
ngw3_e9_kmt gw3_e9_ktail gw3_e9_knb 0 0 nch W=4e-06 L=4e-06
ngw3_e9_km1 gw3_e9_kd1 gw3_e9_vm gw3_e9_ktail 0 nch W=4e-06 L=4e-06
ngw3_e9_km2 gw3_e9_ko1 gw3_e9_h gw3_e9_ktail 0 nch W=4e-06 L=4e-06
ngw3_e9_km3 gw3_e9_kd1 gw3_e9_kd1 vdd vsrc pch W=4e-06 L=4e-06
ngw3_e9_km4 gw3_e9_ko1 gw3_e9_kd1 vdd vsrc pch W=4e-06 L=4e-06
ngw3_e9_kporclamp gw3_e9_ko1 por_hold 0 0 nch W=4e-06 L=1e-06
ngw3_e9_ki1p gw3_e9_qb gw3_e9_ko1 vdd vsrc pch W=2.4e-06 L=5e-07
ngw3_e9_ki1n gw3_e9_qb gw3_e9_ko1 0 0 nch W=1.2e-06 L=5e-07
ngw3_e9_ki2p gw3_e9_q gw3_e9_qb vdd vsrc pch W=2.4e-06 L=5e-07
ngw3_e9_ki2n gw3_e9_q gw3_e9_qb 0 0 nch W=1.2e-06 L=5e-07
rgw3_e9_hra gw3_e9_h vthe 1e+06
rgw3_e9_hrf gw3_e9_h gw3_e9_qb 1.9e+07
cgw3_e9_hc gw3_e9_h 0 2.1e-09
ngw3_e9_dis gw3_e9_vm gw3_e9_q gw3_e9_vmd 0 nch W=4e-06 L=1e-06
va_rgw3_e9_rdis_n vrest rgw3_e9_rdis_n 0
rgw3_e9_rdis gw3_e9_vmd rgw3_e9_rdis_n 220000
ngw3_e9_rp gw3_e9_rt gw3_e9_qb vdd vsrc pch W=2e-06 L=1e-06
rgw3_e9_rrc gw3_e9_rt gw3_e9_rec 10000
cgw3_e9_rc gw3_e9_rec 0 1e-07
rgw3_e9_rr gw3_e9_rec 0 8.2e+06
ngw3_e9_sh1 gw3_e9_vm gw3_e9_rec gw3_e9_vms 0 nch W=2e-06 L=1e-06
va_ngw3_e9_sh2_s vrest ngw3_e9_sh2_s 0
ngw3_e9_sh2 gw3_e9_vms gw3_e9_qb ngw3_e9_sh2_s 0 nch W=2e-06 L=1e-06
ngw3_e9_porh gw3_e9_h por_hold vthe 0 nch W=2e-06 L=1e-06
va_ngw3_e9_porm_s vrest ngw3_e9_porm_s 0
ngw3_e9_porm gw3_e9_vm por_hold ngw3_e9_porm_s 0 nch W=2e-06 L=1e-06
ngw3_e9_ip gw3_e9_vm s3_ya vdd vsrc pch W=4e-06 L=4e-06
ngw3_e9_in gw3_e9_vm s3_zb 0 0 nch W=4e-06 L=4e-06
ngw3_b9_sw gw3_b9_t gw3_e9_qb vdd vsrc pch W=2e-06 L=1e-06
rgw3_b9_rc gw3_b9_t gw3_b9 10000
cgw3_b9_c gw3_b9 0 1e-07
rgw3_b9_rl gw3_b9 0 2.2e+07
ngw3_b9_sh1p gw3_b9_n gw3_b9 vdd vsrc pch W=2.4e-06 L=5e-07
ngw3_b9_sh1n gw3_b9_n gw3_b9 0 0 nch W=1.2e-06 L=5e-07
ngw3_b9_sh2p gw3_b9_q gw3_b9_n vdd vsrc pch W=2.4e-06 L=5e-07
ngw3_b9_sh2n gw3_b9_q gw3_b9_n 0 0 nch W=1.2e-06 L=5e-07
cgw3_e10_cm gw3_e10_vm 0 1e-07
va_rgw3_e10_rm_n vrest rgw3_e10_rm_n 0
rgw3_e10_rm gw3_e10_vm rgw3_e10_rm_n 1e+06
ngw3_e10_bias0 gw3_e10_vm istep_n 0 0 nch W=4e-06 L=4e-06
ngw3_e10_bias1 gw3_e10_vm istep_n 0 0 nch W=4e-06 L=4e-06
ngw3_e10_bias2 gw3_e10_vm istep_n 0 0 nch W=4e-06 L=4e-06
ngw3_e10_bias3 gw3_e10_vm istep_n 0 0 nch W=4e-06 L=4e-06
ngw3_e10_bias4 gw3_e10_vm istep_n 0 0 nch W=4e-06 L=4e-06
ngw3_e10_bias5 gw3_e10_vm istep_n 0 0 nch W=4e-06 L=4e-06
ngw3_e10_bias6 gw3_e10_vm istep_n 0 0 nch W=4e-06 L=4e-06
ngw3_e10_bias7 gw3_e10_vm istep_n 0 0 nch W=4e-06 L=4e-06
ngw3_e10_bias8 gw3_e10_vm istep_n 0 0 nch W=4e-06 L=4e-06
ngw3_e10_bias9 gw3_e10_vm istep_n 0 0 nch W=4e-06 L=4e-06
rgw3_e10_kb vdd gw3_e10_knb 1e+06
ngw3_e10_kmb gw3_e10_knb gw3_e10_knb 0 0 nch W=4e-06 L=4e-06
ngw3_e10_kmt gw3_e10_ktail gw3_e10_knb 0 0 nch W=4e-06 L=4e-06
ngw3_e10_km1 gw3_e10_kd1 gw3_e10_vm gw3_e10_ktail 0 nch W=4e-06 L=4e-06
ngw3_e10_km2 gw3_e10_ko1 gw3_e10_h gw3_e10_ktail 0 nch W=4e-06 L=4e-06
ngw3_e10_km3 gw3_e10_kd1 gw3_e10_kd1 vdd vsrc pch W=4e-06 L=4e-06
ngw3_e10_km4 gw3_e10_ko1 gw3_e10_kd1 vdd vsrc pch W=4e-06 L=4e-06
ngw3_e10_kporclamp gw3_e10_ko1 por_hold 0 0 nch W=4e-06 L=1e-06
ngw3_e10_ki1p gw3_e10_qb gw3_e10_ko1 vdd vsrc pch W=2.4e-06 L=5e-07
ngw3_e10_ki1n gw3_e10_qb gw3_e10_ko1 0 0 nch W=1.2e-06 L=5e-07
ngw3_e10_ki2p gw3_e10_q gw3_e10_qb vdd vsrc pch W=2.4e-06 L=5e-07
ngw3_e10_ki2n gw3_e10_q gw3_e10_qb 0 0 nch W=1.2e-06 L=5e-07
rgw3_e10_hra gw3_e10_h vthe 1e+06
rgw3_e10_hrf gw3_e10_h gw3_e10_qb 1.9e+07
cgw3_e10_hc gw3_e10_h 0 2.1e-09
ngw3_e10_dis gw3_e10_vm gw3_e10_q gw3_e10_vmd 0 nch W=4e-06 L=1e-06
va_rgw3_e10_rdis_n vrest rgw3_e10_rdis_n 0
rgw3_e10_rdis gw3_e10_vmd rgw3_e10_rdis_n 220000
ngw3_e10_rp gw3_e10_rt gw3_e10_qb vdd vsrc pch W=2e-06 L=1e-06
rgw3_e10_rrc gw3_e10_rt gw3_e10_rec 10000
cgw3_e10_rc gw3_e10_rec 0 1e-07
rgw3_e10_rr gw3_e10_rec 0 8.2e+06
ngw3_e10_sh1 gw3_e10_vm gw3_e10_rec gw3_e10_vms 0 nch W=2e-06 L=1e-06
va_ngw3_e10_sh2_s vrest ngw3_e10_sh2_s 0
ngw3_e10_sh2 gw3_e10_vms gw3_e10_qb ngw3_e10_sh2_s 0 nch W=2e-06 L=1e-06
ngw3_e10_porh gw3_e10_h por_hold vthe 0 nch W=2e-06 L=1e-06
va_ngw3_e10_porm_s vrest ngw3_e10_porm_s 0
ngw3_e10_porm gw3_e10_vm por_hold ngw3_e10_porm_s 0 nch W=2e-06 L=1e-06
ngw3_e10_ip gw3_e10_vm s3_ya vdd vsrc pch W=4e-06 L=4e-06
ngw3_e10_in gw3_e10_vm s3_zb 0 0 nch W=4e-06 L=4e-06
ngw3_b10_sw gw3_b10_t gw3_e10_qb vdd vsrc pch W=2e-06 L=1e-06
rgw3_b10_rc gw3_b10_t gw3_b10 10000
cgw3_b10_c gw3_b10 0 1e-07
rgw3_b10_rl gw3_b10 0 2.2e+07
ngw3_b10_sh1p gw3_b10_n gw3_b10 vdd vsrc pch W=2.4e-06 L=5e-07
ngw3_b10_sh1n gw3_b10_n gw3_b10 0 0 nch W=1.2e-06 L=5e-07
ngw3_b10_sh2p gw3_b10_q gw3_b10_n vdd vsrc pch W=2.4e-06 L=5e-07
ngw3_b10_sh2n gw3_b10_q gw3_b10_n 0 0 nch W=1.2e-06 L=5e-07
ngw3_and_a0_npa gw3_and_a0_nb gw3_b1_q vdd vsrc pch W=2.4e-06 L=5e-07
ngw3_and_a0_npb gw3_and_a0_nb gw3_b2_q vdd vsrc pch W=2.4e-06 L=5e-07
ngw3_and_a0_nna gw3_and_a0_nb gw3_b1_q gw3_and_a0_nx 0 nch W=2.4e-06 L=5e-07
ngw3_and_a0_nnb gw3_and_a0_nx gw3_b2_q 0 0 nch W=2.4e-06 L=5e-07
ngw3_and_a0_ip gw3_and_g0 gw3_and_a0_nb vdd vsrc pch W=2.4e-06 L=5e-07
ngw3_and_a0_in gw3_and_g0 gw3_and_a0_nb 0 0 nch W=1.2e-06 L=5e-07
ngw3_and_a1_npa gw3_and_a1_nb gw3_b3_q vdd vsrc pch W=2.4e-06 L=5e-07
ngw3_and_a1_npb gw3_and_a1_nb gw3_b4_q vdd vsrc pch W=2.4e-06 L=5e-07
ngw3_and_a1_nna gw3_and_a1_nb gw3_b3_q gw3_and_a1_nx 0 nch W=2.4e-06 L=5e-07
ngw3_and_a1_nnb gw3_and_a1_nx gw3_b4_q 0 0 nch W=2.4e-06 L=5e-07
ngw3_and_a1_ip gw3_and_g1 gw3_and_a1_nb vdd vsrc pch W=2.4e-06 L=5e-07
ngw3_and_a1_in gw3_and_g1 gw3_and_a1_nb 0 0 nch W=1.2e-06 L=5e-07
ngw3_and_a2_npa gw3_and_a2_nb gw3_b5_q vdd vsrc pch W=2.4e-06 L=5e-07
ngw3_and_a2_npb gw3_and_a2_nb gw3_b6_q vdd vsrc pch W=2.4e-06 L=5e-07
ngw3_and_a2_nna gw3_and_a2_nb gw3_b5_q gw3_and_a2_nx 0 nch W=2.4e-06 L=5e-07
ngw3_and_a2_nnb gw3_and_a2_nx gw3_b6_q 0 0 nch W=2.4e-06 L=5e-07
ngw3_and_a2_ip gw3_and_g2 gw3_and_a2_nb vdd vsrc pch W=2.4e-06 L=5e-07
ngw3_and_a2_in gw3_and_g2 gw3_and_a2_nb 0 0 nch W=1.2e-06 L=5e-07
ngw3_and_a3_npa gw3_and_a3_nb gw3_b7_q vdd vsrc pch W=2.4e-06 L=5e-07
ngw3_and_a3_npb gw3_and_a3_nb gw3_b8_q vdd vsrc pch W=2.4e-06 L=5e-07
ngw3_and_a3_nna gw3_and_a3_nb gw3_b7_q gw3_and_a3_nx 0 nch W=2.4e-06 L=5e-07
ngw3_and_a3_nnb gw3_and_a3_nx gw3_b8_q 0 0 nch W=2.4e-06 L=5e-07
ngw3_and_a3_ip gw3_and_g3 gw3_and_a3_nb vdd vsrc pch W=2.4e-06 L=5e-07
ngw3_and_a3_in gw3_and_g3 gw3_and_a3_nb 0 0 nch W=1.2e-06 L=5e-07
ngw3_and_a4_npa gw3_and_a4_nb gw3_b9_q vdd vsrc pch W=2.4e-06 L=5e-07
ngw3_and_a4_npb gw3_and_a4_nb gw3_b10_q vdd vsrc pch W=2.4e-06 L=5e-07
ngw3_and_a4_nna gw3_and_a4_nb gw3_b9_q gw3_and_a4_nx 0 nch W=2.4e-06 L=5e-07
ngw3_and_a4_nnb gw3_and_a4_nx gw3_b10_q 0 0 nch W=2.4e-06 L=5e-07
ngw3_and_a4_ip gw3_and_g4 gw3_and_a4_nb vdd vsrc pch W=2.4e-06 L=5e-07
ngw3_and_a4_in gw3_and_g4 gw3_and_a4_nb 0 0 nch W=1.2e-06 L=5e-07
ngw3_and_a5_npa gw3_and_a5_nb gw3_and_g0 vdd vsrc pch W=2.4e-06 L=5e-07
ngw3_and_a5_npb gw3_and_a5_nb gw3_and_g1 vdd vsrc pch W=2.4e-06 L=5e-07
ngw3_and_a5_nna gw3_and_a5_nb gw3_and_g0 gw3_and_a5_nx 0 nch W=2.4e-06 L=5e-07
ngw3_and_a5_nnb gw3_and_a5_nx gw3_and_g1 0 0 nch W=2.4e-06 L=5e-07
ngw3_and_a5_ip gw3_and_g5 gw3_and_a5_nb vdd vsrc pch W=2.4e-06 L=5e-07
ngw3_and_a5_in gw3_and_g5 gw3_and_a5_nb 0 0 nch W=1.2e-06 L=5e-07
ngw3_and_a6_npa gw3_and_a6_nb gw3_and_g2 vdd vsrc pch W=2.4e-06 L=5e-07
ngw3_and_a6_npb gw3_and_a6_nb gw3_and_g3 vdd vsrc pch W=2.4e-06 L=5e-07
ngw3_and_a6_nna gw3_and_a6_nb gw3_and_g2 gw3_and_a6_nx 0 nch W=2.4e-06 L=5e-07
ngw3_and_a6_nnb gw3_and_a6_nx gw3_and_g3 0 0 nch W=2.4e-06 L=5e-07
ngw3_and_a6_ip gw3_and_g6 gw3_and_a6_nb vdd vsrc pch W=2.4e-06 L=5e-07
ngw3_and_a6_in gw3_and_g6 gw3_and_a6_nb 0 0 nch W=1.2e-06 L=5e-07
ngw3_and_a7_npa gw3_and_a7_nb gw3_and_g5 vdd vsrc pch W=2.4e-06 L=5e-07
ngw3_and_a7_npb gw3_and_a7_nb gw3_and_g6 vdd vsrc pch W=2.4e-06 L=5e-07
ngw3_and_a7_nna gw3_and_a7_nb gw3_and_g5 gw3_and_a7_nx 0 nch W=2.4e-06 L=5e-07
ngw3_and_a7_nnb gw3_and_a7_nx gw3_and_g6 0 0 nch W=2.4e-06 L=5e-07
ngw3_and_a7_ip gw3_and_g7 gw3_and_a7_nb vdd vsrc pch W=2.4e-06 L=5e-07
ngw3_and_a7_in gw3_and_g7 gw3_and_a7_nb 0 0 nch W=1.2e-06 L=5e-07
ngw3_and_a8_npa gw3_and_a8_nb gw3_and_g7 vdd vsrc pch W=2.4e-06 L=5e-07
ngw3_and_a8_npb gw3_and_a8_nb gw3_and_g4 vdd vsrc pch W=2.4e-06 L=5e-07
ngw3_and_a8_nna gw3_and_a8_nb gw3_and_g7 gw3_and_a8_nx 0 nch W=2.4e-06 L=5e-07
ngw3_and_a8_nnb gw3_and_a8_nx gw3_and_g4 0 0 nch W=2.4e-06 L=5e-07
ngw3_and_a8_ip gw3_and_g8 gw3_and_a8_nb vdd vsrc pch W=2.4e-06 L=5e-07
ngw3_and_a8_in gw3_and_g8 gw3_and_a8_nb 0 0 nch W=1.2e-06 L=5e-07
ngw3_gip gw3_gb gw3_and_g8 vdd vsrc pch W=2.4e-06 L=5e-07
ngw3_gin gw3_gb gw3_and_g8 0 0 nch W=1.2e-06 L=5e-07
cgw3_col_cm gw3_col_vm 0 1e-07
va_rgw3_col_rm_n vrest rgw3_col_rm_n 0
rgw3_col_rm gw3_col_vm rgw3_col_rm_n 1e+06
rgw3_col_kb vdd gw3_col_knb 1e+06
ngw3_col_kmb gw3_col_knb gw3_col_knb 0 0 nch W=4e-06 L=4e-06
ngw3_col_kmt gw3_col_ktail gw3_col_knb 0 0 nch W=4e-06 L=4e-06
ngw3_col_km1 gw3_col_kd1 gw3_col_vm gw3_col_ktail 0 nch W=4e-06 L=4e-06
ngw3_col_km2 gw3_col_ko1 gw3_col_h gw3_col_ktail 0 nch W=4e-06 L=4e-06
ngw3_col_km3 gw3_col_kd1 gw3_col_kd1 vdd vsrc pch W=4e-06 L=4e-06
ngw3_col_km4 gw3_col_ko1 gw3_col_kd1 vdd vsrc pch W=4e-06 L=4e-06
ngw3_col_kporclamp gw3_col_ko1 por_hold 0 0 nch W=4e-06 L=1e-06
ngw3_col_ki1p gw3_col_qb gw3_col_ko1 vdd vsrc pch W=2.4e-06 L=5e-07
ngw3_col_ki1n gw3_col_qb gw3_col_ko1 0 0 nch W=1.2e-06 L=5e-07
ngw3_col_ki2p gw3_col_q gw3_col_qb vdd vsrc pch W=2.4e-06 L=5e-07
ngw3_col_ki2n gw3_col_q gw3_col_qb 0 0 nch W=1.2e-06 L=5e-07
rgw3_col_hra gw3_col_h vthe 1e+06
rgw3_col_hrf gw3_col_h gw3_col_qb 1.9e+07
cgw3_col_hc gw3_col_h 0 2.1e-09
ngw3_col_dis gw3_col_vm gw3_col_q gw3_col_vmd 0 nch W=4e-06 L=1e-06
va_rgw3_col_rdis_n vrest rgw3_col_rdis_n 0
rgw3_col_rdis gw3_col_vmd rgw3_col_rdis_n 220000
ngw3_col_rp gw3_col_rt gw3_col_qb vdd vsrc pch W=2e-06 L=1e-06
rgw3_col_rrc gw3_col_rt gw3_col_rec 10000
cgw3_col_rc gw3_col_rec 0 1e-07
rgw3_col_rr gw3_col_rec 0 8.2e+06
ngw3_col_sh1 gw3_col_vm gw3_col_rec gw3_col_vms 0 nch W=2e-06 L=1e-06
va_ngw3_col_sh2_s vrest ngw3_col_sh2_s 0
ngw3_col_sh2 gw3_col_vms gw3_col_qb ngw3_col_sh2_s 0 nch W=2e-06 L=1e-06
ngw3_col_porh gw3_col_h por_hold vthe 0 nch W=2e-06 L=1e-06
va_ngw3_col_porm_s vrest ngw3_col_porm_s 0
ngw3_col_porm gw3_col_vm por_hold ngw3_col_porm_s 0 nch W=2e-06 L=1e-06
ngw3_cin_eni_p gw3_cin_ena gw3_gb vdd vsrc pch W=2.4e-06 L=5e-07
ngw3_cin_eni_n gw3_cin_ena gw3_gb 0 0 nch W=1.2e-06 L=5e-07
ngw3_cin_cp gw3_col_vm gw3_cin_cg vdd vsrc pch W=4e-06 L=4e-06
ngw3_cin_bias ilimp_n gw3_gb gw3_cin_cg vsrc pch W=1.2e-06 L=1e-06
ngw3_cin_off gw3_cin_cg gw3_cin_ena vdd vsrc pch W=2.4e-06 L=1e-06
ngw3_op_tsw gw3_op_tt gw3_col_qb vdd vsrc pch W=2e-06 L=1e-06
rgw3_op_trc gw3_op_tt gw3_op_at 10000
cgw3_op_tc gw3_op_at 0 1e-07
rgw3_op_trl gw3_op_at 0 2.2e+07
ngw3_op_sh1p gw3_op_an gw3_op_at vdd vsrc pch W=2.4e-06 L=5e-07
ngw3_op_sh1n gw3_op_an gw3_op_at 0 0 nch W=1.2e-06 L=5e-07
ngw3_op_sh2p gw3_op_aq gw3_op_an vdd vsrc pch W=2.4e-06 L=5e-07
ngw3_op_sh2n gw3_op_aq gw3_op_an 0 0 nch W=1.2e-06 L=5e-07
ngw3_op_abp gw3_op_aqb gw3_op_aq vdd vsrc pch W=2.4e-06 L=5e-07
ngw3_op_abn gw3_op_aqb gw3_op_aq 0 0 nch W=1.2e-06 L=5e-07
rgw3_op_dr gw3_op_aq gw3_op_ad 1e+06
cgw3_op_dc gw3_op_ad 0 3.3e-07
ngw3_op_d2p gw3_op_adn gw3_op_ad vdd vsrc pch W=2.4e-06 L=5e-07
ngw3_op_d2n gw3_op_adn gw3_op_ad 0 0 nch W=1.2e-06 L=5e-07
ngw3_op_gpa gw3_op_pb gw3_op_aq vdd vsrc pch W=2.4e-06 L=5e-07
ngw3_op_gpb gw3_op_pb gw3_op_adn vdd vsrc pch W=2.4e-06 L=5e-07
ngw3_op_gna gw3_op_pb gw3_op_aq gw3_op_gx 0 nch W=2.4e-06 L=5e-07
ngw3_op_gnb gw3_op_gx gw3_op_adn 0 0 nch W=2.4e-06 L=5e-07
ngw3_op_op gw3_op_p gw3_op_pb vdd vsrc pch W=2.4e-06 L=5e-07
ngw3_op_on gw3_op_p gw3_op_pb 0 0 nch W=1.2e-06 L=5e-07
cgc3_e1_cm gc3_e1_vm 0 1e-07
va_rgc3_e1_rm_n vrest rgc3_e1_rm_n 0
rgc3_e1_rm gc3_e1_vm rgc3_e1_rm_n 1e+06
ngc3_e1_bias0 gc3_e1_vm istep_n 0 0 nch W=4e-06 L=4e-06
rgc3_e1_kb vdd gc3_e1_knb 1e+06
ngc3_e1_kmb gc3_e1_knb gc3_e1_knb 0 0 nch W=4e-06 L=4e-06
ngc3_e1_kmt gc3_e1_ktail gc3_e1_knb 0 0 nch W=4e-06 L=4e-06
ngc3_e1_km1 gc3_e1_kd1 gc3_e1_vm gc3_e1_ktail 0 nch W=4e-06 L=4e-06
ngc3_e1_km2 gc3_e1_ko1 gc3_e1_h gc3_e1_ktail 0 nch W=4e-06 L=4e-06
ngc3_e1_km3 gc3_e1_kd1 gc3_e1_kd1 vdd vsrc pch W=4e-06 L=4e-06
ngc3_e1_km4 gc3_e1_ko1 gc3_e1_kd1 vdd vsrc pch W=4e-06 L=4e-06
ngc3_e1_kporclamp gc3_e1_ko1 por_hold 0 0 nch W=4e-06 L=1e-06
ngc3_e1_ki1p gc3_e1_qb gc3_e1_ko1 vdd vsrc pch W=2.4e-06 L=5e-07
ngc3_e1_ki1n gc3_e1_qb gc3_e1_ko1 0 0 nch W=1.2e-06 L=5e-07
ngc3_e1_ki2p gc3_e1_q gc3_e1_qb vdd vsrc pch W=2.4e-06 L=5e-07
ngc3_e1_ki2n gc3_e1_q gc3_e1_qb 0 0 nch W=1.2e-06 L=5e-07
rgc3_e1_hra gc3_e1_h vthe 1e+06
rgc3_e1_hrf gc3_e1_h gc3_e1_qb 1.9e+07
cgc3_e1_hc gc3_e1_h 0 2.1e-09
ngc3_e1_dis gc3_e1_vm gc3_e1_q gc3_e1_vmd 0 nch W=4e-06 L=1e-06
va_rgc3_e1_rdis_n vrest rgc3_e1_rdis_n 0
rgc3_e1_rdis gc3_e1_vmd rgc3_e1_rdis_n 220000
ngc3_e1_rp gc3_e1_rt gc3_e1_qb vdd vsrc pch W=2e-06 L=1e-06
rgc3_e1_rrc gc3_e1_rt gc3_e1_rec 10000
cgc3_e1_rc gc3_e1_rec 0 1e-07
rgc3_e1_rr gc3_e1_rec 0 8.2e+06
ngc3_e1_sh1 gc3_e1_vm gc3_e1_rec gc3_e1_vms 0 nch W=2e-06 L=1e-06
va_ngc3_e1_sh2_s vrest ngc3_e1_sh2_s 0
ngc3_e1_sh2 gc3_e1_vms gc3_e1_qb ngc3_e1_sh2_s 0 nch W=2e-06 L=1e-06
ngc3_e1_porh gc3_e1_h por_hold vthe 0 nch W=2e-06 L=1e-06
va_ngc3_e1_porm_s vrest ngc3_e1_porm_s 0
ngc3_e1_porm gc3_e1_vm por_hold ngc3_e1_porm_s 0 nch W=2e-06 L=1e-06
ngc3_e1_ip gc3_e1_vm s3_yb vdd vsrc pch W=4e-06 L=4e-06
ngc3_e1_in gc3_e1_vm s3_za 0 0 nch W=4e-06 L=4e-06
ngc3_b1_sw gc3_b1_t gc3_e1_qb vdd vsrc pch W=2e-06 L=1e-06
rgc3_b1_rc gc3_b1_t gc3_b1 10000
cgc3_b1_c gc3_b1 0 1e-07
rgc3_b1_rl gc3_b1 0 2.2e+07
ngc3_b1_sh1p gc3_b1_n gc3_b1 vdd vsrc pch W=2.4e-06 L=5e-07
ngc3_b1_sh1n gc3_b1_n gc3_b1 0 0 nch W=1.2e-06 L=5e-07
ngc3_b1_sh2p gc3_b1_q gc3_b1_n vdd vsrc pch W=2.4e-06 L=5e-07
ngc3_b1_sh2n gc3_b1_q gc3_b1_n 0 0 nch W=1.2e-06 L=5e-07
cgc3_e2_cm gc3_e2_vm 0 1e-07
va_rgc3_e2_rm_n vrest rgc3_e2_rm_n 0
rgc3_e2_rm gc3_e2_vm rgc3_e2_rm_n 1e+06
ngc3_e2_bias0 gc3_e2_vm istep_n 0 0 nch W=4e-06 L=4e-06
ngc3_e2_bias1 gc3_e2_vm istep_n 0 0 nch W=4e-06 L=4e-06
rgc3_e2_kb vdd gc3_e2_knb 1e+06
ngc3_e2_kmb gc3_e2_knb gc3_e2_knb 0 0 nch W=4e-06 L=4e-06
ngc3_e2_kmt gc3_e2_ktail gc3_e2_knb 0 0 nch W=4e-06 L=4e-06
ngc3_e2_km1 gc3_e2_kd1 gc3_e2_vm gc3_e2_ktail 0 nch W=4e-06 L=4e-06
ngc3_e2_km2 gc3_e2_ko1 gc3_e2_h gc3_e2_ktail 0 nch W=4e-06 L=4e-06
ngc3_e2_km3 gc3_e2_kd1 gc3_e2_kd1 vdd vsrc pch W=4e-06 L=4e-06
ngc3_e2_km4 gc3_e2_ko1 gc3_e2_kd1 vdd vsrc pch W=4e-06 L=4e-06
ngc3_e2_kporclamp gc3_e2_ko1 por_hold 0 0 nch W=4e-06 L=1e-06
ngc3_e2_ki1p gc3_e2_qb gc3_e2_ko1 vdd vsrc pch W=2.4e-06 L=5e-07
ngc3_e2_ki1n gc3_e2_qb gc3_e2_ko1 0 0 nch W=1.2e-06 L=5e-07
ngc3_e2_ki2p gc3_e2_q gc3_e2_qb vdd vsrc pch W=2.4e-06 L=5e-07
ngc3_e2_ki2n gc3_e2_q gc3_e2_qb 0 0 nch W=1.2e-06 L=5e-07
rgc3_e2_hra gc3_e2_h vthe 1e+06
rgc3_e2_hrf gc3_e2_h gc3_e2_qb 1.9e+07
cgc3_e2_hc gc3_e2_h 0 2.1e-09
ngc3_e2_dis gc3_e2_vm gc3_e2_q gc3_e2_vmd 0 nch W=4e-06 L=1e-06
va_rgc3_e2_rdis_n vrest rgc3_e2_rdis_n 0
rgc3_e2_rdis gc3_e2_vmd rgc3_e2_rdis_n 220000
ngc3_e2_rp gc3_e2_rt gc3_e2_qb vdd vsrc pch W=2e-06 L=1e-06
rgc3_e2_rrc gc3_e2_rt gc3_e2_rec 10000
cgc3_e2_rc gc3_e2_rec 0 1e-07
rgc3_e2_rr gc3_e2_rec 0 8.2e+06
ngc3_e2_sh1 gc3_e2_vm gc3_e2_rec gc3_e2_vms 0 nch W=2e-06 L=1e-06
va_ngc3_e2_sh2_s vrest ngc3_e2_sh2_s 0
ngc3_e2_sh2 gc3_e2_vms gc3_e2_qb ngc3_e2_sh2_s 0 nch W=2e-06 L=1e-06
ngc3_e2_porh gc3_e2_h por_hold vthe 0 nch W=2e-06 L=1e-06
va_ngc3_e2_porm_s vrest ngc3_e2_porm_s 0
ngc3_e2_porm gc3_e2_vm por_hold ngc3_e2_porm_s 0 nch W=2e-06 L=1e-06
ngc3_e2_ip gc3_e2_vm s3_yb vdd vsrc pch W=4e-06 L=4e-06
ngc3_e2_in gc3_e2_vm s3_za 0 0 nch W=4e-06 L=4e-06
ngc3_b2_sw gc3_b2_t gc3_e2_qb vdd vsrc pch W=2e-06 L=1e-06
rgc3_b2_rc gc3_b2_t gc3_b2 10000
cgc3_b2_c gc3_b2 0 1e-07
rgc3_b2_rl gc3_b2 0 2.2e+07
ngc3_b2_sh1p gc3_b2_n gc3_b2 vdd vsrc pch W=2.4e-06 L=5e-07
ngc3_b2_sh1n gc3_b2_n gc3_b2 0 0 nch W=1.2e-06 L=5e-07
ngc3_b2_sh2p gc3_b2_q gc3_b2_n vdd vsrc pch W=2.4e-06 L=5e-07
ngc3_b2_sh2n gc3_b2_q gc3_b2_n 0 0 nch W=1.2e-06 L=5e-07
cgc3_e3_cm gc3_e3_vm 0 1e-07
va_rgc3_e3_rm_n vrest rgc3_e3_rm_n 0
rgc3_e3_rm gc3_e3_vm rgc3_e3_rm_n 1e+06
ngc3_e3_bias0 gc3_e3_vm istep_n 0 0 nch W=4e-06 L=4e-06
ngc3_e3_bias1 gc3_e3_vm istep_n 0 0 nch W=4e-06 L=4e-06
ngc3_e3_bias2 gc3_e3_vm istep_n 0 0 nch W=4e-06 L=4e-06
rgc3_e3_kb vdd gc3_e3_knb 1e+06
ngc3_e3_kmb gc3_e3_knb gc3_e3_knb 0 0 nch W=4e-06 L=4e-06
ngc3_e3_kmt gc3_e3_ktail gc3_e3_knb 0 0 nch W=4e-06 L=4e-06
ngc3_e3_km1 gc3_e3_kd1 gc3_e3_vm gc3_e3_ktail 0 nch W=4e-06 L=4e-06
ngc3_e3_km2 gc3_e3_ko1 gc3_e3_h gc3_e3_ktail 0 nch W=4e-06 L=4e-06
ngc3_e3_km3 gc3_e3_kd1 gc3_e3_kd1 vdd vsrc pch W=4e-06 L=4e-06
ngc3_e3_km4 gc3_e3_ko1 gc3_e3_kd1 vdd vsrc pch W=4e-06 L=4e-06
ngc3_e3_kporclamp gc3_e3_ko1 por_hold 0 0 nch W=4e-06 L=1e-06
ngc3_e3_ki1p gc3_e3_qb gc3_e3_ko1 vdd vsrc pch W=2.4e-06 L=5e-07
ngc3_e3_ki1n gc3_e3_qb gc3_e3_ko1 0 0 nch W=1.2e-06 L=5e-07
ngc3_e3_ki2p gc3_e3_q gc3_e3_qb vdd vsrc pch W=2.4e-06 L=5e-07
ngc3_e3_ki2n gc3_e3_q gc3_e3_qb 0 0 nch W=1.2e-06 L=5e-07
rgc3_e3_hra gc3_e3_h vthe 1e+06
rgc3_e3_hrf gc3_e3_h gc3_e3_qb 1.9e+07
cgc3_e3_hc gc3_e3_h 0 2.1e-09
ngc3_e3_dis gc3_e3_vm gc3_e3_q gc3_e3_vmd 0 nch W=4e-06 L=1e-06
va_rgc3_e3_rdis_n vrest rgc3_e3_rdis_n 0
rgc3_e3_rdis gc3_e3_vmd rgc3_e3_rdis_n 220000
ngc3_e3_rp gc3_e3_rt gc3_e3_qb vdd vsrc pch W=2e-06 L=1e-06
rgc3_e3_rrc gc3_e3_rt gc3_e3_rec 10000
cgc3_e3_rc gc3_e3_rec 0 1e-07
rgc3_e3_rr gc3_e3_rec 0 8.2e+06
ngc3_e3_sh1 gc3_e3_vm gc3_e3_rec gc3_e3_vms 0 nch W=2e-06 L=1e-06
va_ngc3_e3_sh2_s vrest ngc3_e3_sh2_s 0
ngc3_e3_sh2 gc3_e3_vms gc3_e3_qb ngc3_e3_sh2_s 0 nch W=2e-06 L=1e-06
ngc3_e3_porh gc3_e3_h por_hold vthe 0 nch W=2e-06 L=1e-06
va_ngc3_e3_porm_s vrest ngc3_e3_porm_s 0
ngc3_e3_porm gc3_e3_vm por_hold ngc3_e3_porm_s 0 nch W=2e-06 L=1e-06
ngc3_e3_ip gc3_e3_vm s3_yb vdd vsrc pch W=4e-06 L=4e-06
ngc3_e3_in gc3_e3_vm s3_za 0 0 nch W=4e-06 L=4e-06
ngc3_b3_sw gc3_b3_t gc3_e3_qb vdd vsrc pch W=2e-06 L=1e-06
rgc3_b3_rc gc3_b3_t gc3_b3 10000
cgc3_b3_c gc3_b3 0 1e-07
rgc3_b3_rl gc3_b3 0 2.2e+07
ngc3_b3_sh1p gc3_b3_n gc3_b3 vdd vsrc pch W=2.4e-06 L=5e-07
ngc3_b3_sh1n gc3_b3_n gc3_b3 0 0 nch W=1.2e-06 L=5e-07
ngc3_b3_sh2p gc3_b3_q gc3_b3_n vdd vsrc pch W=2.4e-06 L=5e-07
ngc3_b3_sh2n gc3_b3_q gc3_b3_n 0 0 nch W=1.2e-06 L=5e-07
cgc3_e4_cm gc3_e4_vm 0 1e-07
va_rgc3_e4_rm_n vrest rgc3_e4_rm_n 0
rgc3_e4_rm gc3_e4_vm rgc3_e4_rm_n 1e+06
ngc3_e4_bias0 gc3_e4_vm istep_n 0 0 nch W=4e-06 L=4e-06
ngc3_e4_bias1 gc3_e4_vm istep_n 0 0 nch W=4e-06 L=4e-06
ngc3_e4_bias2 gc3_e4_vm istep_n 0 0 nch W=4e-06 L=4e-06
ngc3_e4_bias3 gc3_e4_vm istep_n 0 0 nch W=4e-06 L=4e-06
rgc3_e4_kb vdd gc3_e4_knb 1e+06
ngc3_e4_kmb gc3_e4_knb gc3_e4_knb 0 0 nch W=4e-06 L=4e-06
ngc3_e4_kmt gc3_e4_ktail gc3_e4_knb 0 0 nch W=4e-06 L=4e-06
ngc3_e4_km1 gc3_e4_kd1 gc3_e4_vm gc3_e4_ktail 0 nch W=4e-06 L=4e-06
ngc3_e4_km2 gc3_e4_ko1 gc3_e4_h gc3_e4_ktail 0 nch W=4e-06 L=4e-06
ngc3_e4_km3 gc3_e4_kd1 gc3_e4_kd1 vdd vsrc pch W=4e-06 L=4e-06
ngc3_e4_km4 gc3_e4_ko1 gc3_e4_kd1 vdd vsrc pch W=4e-06 L=4e-06
ngc3_e4_kporclamp gc3_e4_ko1 por_hold 0 0 nch W=4e-06 L=1e-06
ngc3_e4_ki1p gc3_e4_qb gc3_e4_ko1 vdd vsrc pch W=2.4e-06 L=5e-07
ngc3_e4_ki1n gc3_e4_qb gc3_e4_ko1 0 0 nch W=1.2e-06 L=5e-07
ngc3_e4_ki2p gc3_e4_q gc3_e4_qb vdd vsrc pch W=2.4e-06 L=5e-07
ngc3_e4_ki2n gc3_e4_q gc3_e4_qb 0 0 nch W=1.2e-06 L=5e-07
rgc3_e4_hra gc3_e4_h vthe 1e+06
rgc3_e4_hrf gc3_e4_h gc3_e4_qb 1.9e+07
cgc3_e4_hc gc3_e4_h 0 2.1e-09
ngc3_e4_dis gc3_e4_vm gc3_e4_q gc3_e4_vmd 0 nch W=4e-06 L=1e-06
va_rgc3_e4_rdis_n vrest rgc3_e4_rdis_n 0
rgc3_e4_rdis gc3_e4_vmd rgc3_e4_rdis_n 220000
ngc3_e4_rp gc3_e4_rt gc3_e4_qb vdd vsrc pch W=2e-06 L=1e-06
rgc3_e4_rrc gc3_e4_rt gc3_e4_rec 10000
cgc3_e4_rc gc3_e4_rec 0 1e-07
rgc3_e4_rr gc3_e4_rec 0 8.2e+06
ngc3_e4_sh1 gc3_e4_vm gc3_e4_rec gc3_e4_vms 0 nch W=2e-06 L=1e-06
va_ngc3_e4_sh2_s vrest ngc3_e4_sh2_s 0
ngc3_e4_sh2 gc3_e4_vms gc3_e4_qb ngc3_e4_sh2_s 0 nch W=2e-06 L=1e-06
ngc3_e4_porh gc3_e4_h por_hold vthe 0 nch W=2e-06 L=1e-06
va_ngc3_e4_porm_s vrest ngc3_e4_porm_s 0
ngc3_e4_porm gc3_e4_vm por_hold ngc3_e4_porm_s 0 nch W=2e-06 L=1e-06
ngc3_e4_ip gc3_e4_vm s3_yb vdd vsrc pch W=4e-06 L=4e-06
ngc3_e4_in gc3_e4_vm s3_za 0 0 nch W=4e-06 L=4e-06
ngc3_b4_sw gc3_b4_t gc3_e4_qb vdd vsrc pch W=2e-06 L=1e-06
rgc3_b4_rc gc3_b4_t gc3_b4 10000
cgc3_b4_c gc3_b4 0 1e-07
rgc3_b4_rl gc3_b4 0 2.2e+07
ngc3_b4_sh1p gc3_b4_n gc3_b4 vdd vsrc pch W=2.4e-06 L=5e-07
ngc3_b4_sh1n gc3_b4_n gc3_b4 0 0 nch W=1.2e-06 L=5e-07
ngc3_b4_sh2p gc3_b4_q gc3_b4_n vdd vsrc pch W=2.4e-06 L=5e-07
ngc3_b4_sh2n gc3_b4_q gc3_b4_n 0 0 nch W=1.2e-06 L=5e-07
cgc3_e5_cm gc3_e5_vm 0 1e-07
va_rgc3_e5_rm_n vrest rgc3_e5_rm_n 0
rgc3_e5_rm gc3_e5_vm rgc3_e5_rm_n 1e+06
ngc3_e5_bias0 gc3_e5_vm istep_n 0 0 nch W=4e-06 L=4e-06
ngc3_e5_bias1 gc3_e5_vm istep_n 0 0 nch W=4e-06 L=4e-06
ngc3_e5_bias2 gc3_e5_vm istep_n 0 0 nch W=4e-06 L=4e-06
ngc3_e5_bias3 gc3_e5_vm istep_n 0 0 nch W=4e-06 L=4e-06
ngc3_e5_bias4 gc3_e5_vm istep_n 0 0 nch W=4e-06 L=4e-06
rgc3_e5_kb vdd gc3_e5_knb 1e+06
ngc3_e5_kmb gc3_e5_knb gc3_e5_knb 0 0 nch W=4e-06 L=4e-06
ngc3_e5_kmt gc3_e5_ktail gc3_e5_knb 0 0 nch W=4e-06 L=4e-06
ngc3_e5_km1 gc3_e5_kd1 gc3_e5_vm gc3_e5_ktail 0 nch W=4e-06 L=4e-06
ngc3_e5_km2 gc3_e5_ko1 gc3_e5_h gc3_e5_ktail 0 nch W=4e-06 L=4e-06
ngc3_e5_km3 gc3_e5_kd1 gc3_e5_kd1 vdd vsrc pch W=4e-06 L=4e-06
ngc3_e5_km4 gc3_e5_ko1 gc3_e5_kd1 vdd vsrc pch W=4e-06 L=4e-06
ngc3_e5_kporclamp gc3_e5_ko1 por_hold 0 0 nch W=4e-06 L=1e-06
ngc3_e5_ki1p gc3_e5_qb gc3_e5_ko1 vdd vsrc pch W=2.4e-06 L=5e-07
ngc3_e5_ki1n gc3_e5_qb gc3_e5_ko1 0 0 nch W=1.2e-06 L=5e-07
ngc3_e5_ki2p gc3_e5_q gc3_e5_qb vdd vsrc pch W=2.4e-06 L=5e-07
ngc3_e5_ki2n gc3_e5_q gc3_e5_qb 0 0 nch W=1.2e-06 L=5e-07
rgc3_e5_hra gc3_e5_h vthe 1e+06
rgc3_e5_hrf gc3_e5_h gc3_e5_qb 1.9e+07
cgc3_e5_hc gc3_e5_h 0 2.1e-09
ngc3_e5_dis gc3_e5_vm gc3_e5_q gc3_e5_vmd 0 nch W=4e-06 L=1e-06
va_rgc3_e5_rdis_n vrest rgc3_e5_rdis_n 0
rgc3_e5_rdis gc3_e5_vmd rgc3_e5_rdis_n 220000
ngc3_e5_rp gc3_e5_rt gc3_e5_qb vdd vsrc pch W=2e-06 L=1e-06
rgc3_e5_rrc gc3_e5_rt gc3_e5_rec 10000
cgc3_e5_rc gc3_e5_rec 0 1e-07
rgc3_e5_rr gc3_e5_rec 0 8.2e+06
ngc3_e5_sh1 gc3_e5_vm gc3_e5_rec gc3_e5_vms 0 nch W=2e-06 L=1e-06
va_ngc3_e5_sh2_s vrest ngc3_e5_sh2_s 0
ngc3_e5_sh2 gc3_e5_vms gc3_e5_qb ngc3_e5_sh2_s 0 nch W=2e-06 L=1e-06
ngc3_e5_porh gc3_e5_h por_hold vthe 0 nch W=2e-06 L=1e-06
va_ngc3_e5_porm_s vrest ngc3_e5_porm_s 0
ngc3_e5_porm gc3_e5_vm por_hold ngc3_e5_porm_s 0 nch W=2e-06 L=1e-06
ngc3_e5_ip gc3_e5_vm s3_yb vdd vsrc pch W=4e-06 L=4e-06
ngc3_e5_in gc3_e5_vm s3_za 0 0 nch W=4e-06 L=4e-06
ngc3_b5_sw gc3_b5_t gc3_e5_qb vdd vsrc pch W=2e-06 L=1e-06
rgc3_b5_rc gc3_b5_t gc3_b5 10000
cgc3_b5_c gc3_b5 0 1e-07
rgc3_b5_rl gc3_b5 0 2.2e+07
ngc3_b5_sh1p gc3_b5_n gc3_b5 vdd vsrc pch W=2.4e-06 L=5e-07
ngc3_b5_sh1n gc3_b5_n gc3_b5 0 0 nch W=1.2e-06 L=5e-07
ngc3_b5_sh2p gc3_b5_q gc3_b5_n vdd vsrc pch W=2.4e-06 L=5e-07
ngc3_b5_sh2n gc3_b5_q gc3_b5_n 0 0 nch W=1.2e-06 L=5e-07
cgc3_e6_cm gc3_e6_vm 0 1e-07
va_rgc3_e6_rm_n vrest rgc3_e6_rm_n 0
rgc3_e6_rm gc3_e6_vm rgc3_e6_rm_n 1e+06
ngc3_e6_bias0 gc3_e6_vm istep_n 0 0 nch W=4e-06 L=4e-06
ngc3_e6_bias1 gc3_e6_vm istep_n 0 0 nch W=4e-06 L=4e-06
ngc3_e6_bias2 gc3_e6_vm istep_n 0 0 nch W=4e-06 L=4e-06
ngc3_e6_bias3 gc3_e6_vm istep_n 0 0 nch W=4e-06 L=4e-06
ngc3_e6_bias4 gc3_e6_vm istep_n 0 0 nch W=4e-06 L=4e-06
ngc3_e6_bias5 gc3_e6_vm istep_n 0 0 nch W=4e-06 L=4e-06
rgc3_e6_kb vdd gc3_e6_knb 1e+06
ngc3_e6_kmb gc3_e6_knb gc3_e6_knb 0 0 nch W=4e-06 L=4e-06
ngc3_e6_kmt gc3_e6_ktail gc3_e6_knb 0 0 nch W=4e-06 L=4e-06
ngc3_e6_km1 gc3_e6_kd1 gc3_e6_vm gc3_e6_ktail 0 nch W=4e-06 L=4e-06
ngc3_e6_km2 gc3_e6_ko1 gc3_e6_h gc3_e6_ktail 0 nch W=4e-06 L=4e-06
ngc3_e6_km3 gc3_e6_kd1 gc3_e6_kd1 vdd vsrc pch W=4e-06 L=4e-06
ngc3_e6_km4 gc3_e6_ko1 gc3_e6_kd1 vdd vsrc pch W=4e-06 L=4e-06
ngc3_e6_kporclamp gc3_e6_ko1 por_hold 0 0 nch W=4e-06 L=1e-06
ngc3_e6_ki1p gc3_e6_qb gc3_e6_ko1 vdd vsrc pch W=2.4e-06 L=5e-07
ngc3_e6_ki1n gc3_e6_qb gc3_e6_ko1 0 0 nch W=1.2e-06 L=5e-07
ngc3_e6_ki2p gc3_e6_q gc3_e6_qb vdd vsrc pch W=2.4e-06 L=5e-07
ngc3_e6_ki2n gc3_e6_q gc3_e6_qb 0 0 nch W=1.2e-06 L=5e-07
rgc3_e6_hra gc3_e6_h vthe 1e+06
rgc3_e6_hrf gc3_e6_h gc3_e6_qb 1.9e+07
cgc3_e6_hc gc3_e6_h 0 2.1e-09
ngc3_e6_dis gc3_e6_vm gc3_e6_q gc3_e6_vmd 0 nch W=4e-06 L=1e-06
va_rgc3_e6_rdis_n vrest rgc3_e6_rdis_n 0
rgc3_e6_rdis gc3_e6_vmd rgc3_e6_rdis_n 220000
ngc3_e6_rp gc3_e6_rt gc3_e6_qb vdd vsrc pch W=2e-06 L=1e-06
rgc3_e6_rrc gc3_e6_rt gc3_e6_rec 10000
cgc3_e6_rc gc3_e6_rec 0 1e-07
rgc3_e6_rr gc3_e6_rec 0 8.2e+06
ngc3_e6_sh1 gc3_e6_vm gc3_e6_rec gc3_e6_vms 0 nch W=2e-06 L=1e-06
va_ngc3_e6_sh2_s vrest ngc3_e6_sh2_s 0
ngc3_e6_sh2 gc3_e6_vms gc3_e6_qb ngc3_e6_sh2_s 0 nch W=2e-06 L=1e-06
ngc3_e6_porh gc3_e6_h por_hold vthe 0 nch W=2e-06 L=1e-06
va_ngc3_e6_porm_s vrest ngc3_e6_porm_s 0
ngc3_e6_porm gc3_e6_vm por_hold ngc3_e6_porm_s 0 nch W=2e-06 L=1e-06
ngc3_e6_ip gc3_e6_vm s3_yb vdd vsrc pch W=4e-06 L=4e-06
ngc3_e6_in gc3_e6_vm s3_za 0 0 nch W=4e-06 L=4e-06
ngc3_b6_sw gc3_b6_t gc3_e6_qb vdd vsrc pch W=2e-06 L=1e-06
rgc3_b6_rc gc3_b6_t gc3_b6 10000
cgc3_b6_c gc3_b6 0 1e-07
rgc3_b6_rl gc3_b6 0 2.2e+07
ngc3_b6_sh1p gc3_b6_n gc3_b6 vdd vsrc pch W=2.4e-06 L=5e-07
ngc3_b6_sh1n gc3_b6_n gc3_b6 0 0 nch W=1.2e-06 L=5e-07
ngc3_b6_sh2p gc3_b6_q gc3_b6_n vdd vsrc pch W=2.4e-06 L=5e-07
ngc3_b6_sh2n gc3_b6_q gc3_b6_n 0 0 nch W=1.2e-06 L=5e-07
cgc3_e7_cm gc3_e7_vm 0 1e-07
va_rgc3_e7_rm_n vrest rgc3_e7_rm_n 0
rgc3_e7_rm gc3_e7_vm rgc3_e7_rm_n 1e+06
ngc3_e7_bias0 gc3_e7_vm istep_n 0 0 nch W=4e-06 L=4e-06
ngc3_e7_bias1 gc3_e7_vm istep_n 0 0 nch W=4e-06 L=4e-06
ngc3_e7_bias2 gc3_e7_vm istep_n 0 0 nch W=4e-06 L=4e-06
ngc3_e7_bias3 gc3_e7_vm istep_n 0 0 nch W=4e-06 L=4e-06
ngc3_e7_bias4 gc3_e7_vm istep_n 0 0 nch W=4e-06 L=4e-06
ngc3_e7_bias5 gc3_e7_vm istep_n 0 0 nch W=4e-06 L=4e-06
ngc3_e7_bias6 gc3_e7_vm istep_n 0 0 nch W=4e-06 L=4e-06
rgc3_e7_kb vdd gc3_e7_knb 1e+06
ngc3_e7_kmb gc3_e7_knb gc3_e7_knb 0 0 nch W=4e-06 L=4e-06
ngc3_e7_kmt gc3_e7_ktail gc3_e7_knb 0 0 nch W=4e-06 L=4e-06
ngc3_e7_km1 gc3_e7_kd1 gc3_e7_vm gc3_e7_ktail 0 nch W=4e-06 L=4e-06
ngc3_e7_km2 gc3_e7_ko1 gc3_e7_h gc3_e7_ktail 0 nch W=4e-06 L=4e-06
ngc3_e7_km3 gc3_e7_kd1 gc3_e7_kd1 vdd vsrc pch W=4e-06 L=4e-06
ngc3_e7_km4 gc3_e7_ko1 gc3_e7_kd1 vdd vsrc pch W=4e-06 L=4e-06
ngc3_e7_kporclamp gc3_e7_ko1 por_hold 0 0 nch W=4e-06 L=1e-06
ngc3_e7_ki1p gc3_e7_qb gc3_e7_ko1 vdd vsrc pch W=2.4e-06 L=5e-07
ngc3_e7_ki1n gc3_e7_qb gc3_e7_ko1 0 0 nch W=1.2e-06 L=5e-07
ngc3_e7_ki2p gc3_e7_q gc3_e7_qb vdd vsrc pch W=2.4e-06 L=5e-07
ngc3_e7_ki2n gc3_e7_q gc3_e7_qb 0 0 nch W=1.2e-06 L=5e-07
rgc3_e7_hra gc3_e7_h vthe 1e+06
rgc3_e7_hrf gc3_e7_h gc3_e7_qb 1.9e+07
cgc3_e7_hc gc3_e7_h 0 2.1e-09
ngc3_e7_dis gc3_e7_vm gc3_e7_q gc3_e7_vmd 0 nch W=4e-06 L=1e-06
va_rgc3_e7_rdis_n vrest rgc3_e7_rdis_n 0
rgc3_e7_rdis gc3_e7_vmd rgc3_e7_rdis_n 220000
ngc3_e7_rp gc3_e7_rt gc3_e7_qb vdd vsrc pch W=2e-06 L=1e-06
rgc3_e7_rrc gc3_e7_rt gc3_e7_rec 10000
cgc3_e7_rc gc3_e7_rec 0 1e-07
rgc3_e7_rr gc3_e7_rec 0 8.2e+06
ngc3_e7_sh1 gc3_e7_vm gc3_e7_rec gc3_e7_vms 0 nch W=2e-06 L=1e-06
va_ngc3_e7_sh2_s vrest ngc3_e7_sh2_s 0
ngc3_e7_sh2 gc3_e7_vms gc3_e7_qb ngc3_e7_sh2_s 0 nch W=2e-06 L=1e-06
ngc3_e7_porh gc3_e7_h por_hold vthe 0 nch W=2e-06 L=1e-06
va_ngc3_e7_porm_s vrest ngc3_e7_porm_s 0
ngc3_e7_porm gc3_e7_vm por_hold ngc3_e7_porm_s 0 nch W=2e-06 L=1e-06
ngc3_e7_ip gc3_e7_vm s3_yb vdd vsrc pch W=4e-06 L=4e-06
ngc3_e7_in gc3_e7_vm s3_za 0 0 nch W=4e-06 L=4e-06
ngc3_b7_sw gc3_b7_t gc3_e7_qb vdd vsrc pch W=2e-06 L=1e-06
rgc3_b7_rc gc3_b7_t gc3_b7 10000
cgc3_b7_c gc3_b7 0 1e-07
rgc3_b7_rl gc3_b7 0 2.2e+07
ngc3_b7_sh1p gc3_b7_n gc3_b7 vdd vsrc pch W=2.4e-06 L=5e-07
ngc3_b7_sh1n gc3_b7_n gc3_b7 0 0 nch W=1.2e-06 L=5e-07
ngc3_b7_sh2p gc3_b7_q gc3_b7_n vdd vsrc pch W=2.4e-06 L=5e-07
ngc3_b7_sh2n gc3_b7_q gc3_b7_n 0 0 nch W=1.2e-06 L=5e-07
cgc3_e8_cm gc3_e8_vm 0 1e-07
va_rgc3_e8_rm_n vrest rgc3_e8_rm_n 0
rgc3_e8_rm gc3_e8_vm rgc3_e8_rm_n 1e+06
ngc3_e8_bias0 gc3_e8_vm istep_n 0 0 nch W=4e-06 L=4e-06
ngc3_e8_bias1 gc3_e8_vm istep_n 0 0 nch W=4e-06 L=4e-06
ngc3_e8_bias2 gc3_e8_vm istep_n 0 0 nch W=4e-06 L=4e-06
ngc3_e8_bias3 gc3_e8_vm istep_n 0 0 nch W=4e-06 L=4e-06
ngc3_e8_bias4 gc3_e8_vm istep_n 0 0 nch W=4e-06 L=4e-06
ngc3_e8_bias5 gc3_e8_vm istep_n 0 0 nch W=4e-06 L=4e-06
ngc3_e8_bias6 gc3_e8_vm istep_n 0 0 nch W=4e-06 L=4e-06
ngc3_e8_bias7 gc3_e8_vm istep_n 0 0 nch W=4e-06 L=4e-06
rgc3_e8_kb vdd gc3_e8_knb 1e+06
ngc3_e8_kmb gc3_e8_knb gc3_e8_knb 0 0 nch W=4e-06 L=4e-06
ngc3_e8_kmt gc3_e8_ktail gc3_e8_knb 0 0 nch W=4e-06 L=4e-06
ngc3_e8_km1 gc3_e8_kd1 gc3_e8_vm gc3_e8_ktail 0 nch W=4e-06 L=4e-06
ngc3_e8_km2 gc3_e8_ko1 gc3_e8_h gc3_e8_ktail 0 nch W=4e-06 L=4e-06
ngc3_e8_km3 gc3_e8_kd1 gc3_e8_kd1 vdd vsrc pch W=4e-06 L=4e-06
ngc3_e8_km4 gc3_e8_ko1 gc3_e8_kd1 vdd vsrc pch W=4e-06 L=4e-06
ngc3_e8_kporclamp gc3_e8_ko1 por_hold 0 0 nch W=4e-06 L=1e-06
ngc3_e8_ki1p gc3_e8_qb gc3_e8_ko1 vdd vsrc pch W=2.4e-06 L=5e-07
ngc3_e8_ki1n gc3_e8_qb gc3_e8_ko1 0 0 nch W=1.2e-06 L=5e-07
ngc3_e8_ki2p gc3_e8_q gc3_e8_qb vdd vsrc pch W=2.4e-06 L=5e-07
ngc3_e8_ki2n gc3_e8_q gc3_e8_qb 0 0 nch W=1.2e-06 L=5e-07
rgc3_e8_hra gc3_e8_h vthe 1e+06
rgc3_e8_hrf gc3_e8_h gc3_e8_qb 1.9e+07
cgc3_e8_hc gc3_e8_h 0 2.1e-09
ngc3_e8_dis gc3_e8_vm gc3_e8_q gc3_e8_vmd 0 nch W=4e-06 L=1e-06
va_rgc3_e8_rdis_n vrest rgc3_e8_rdis_n 0
rgc3_e8_rdis gc3_e8_vmd rgc3_e8_rdis_n 220000
ngc3_e8_rp gc3_e8_rt gc3_e8_qb vdd vsrc pch W=2e-06 L=1e-06
rgc3_e8_rrc gc3_e8_rt gc3_e8_rec 10000
cgc3_e8_rc gc3_e8_rec 0 1e-07
rgc3_e8_rr gc3_e8_rec 0 8.2e+06
ngc3_e8_sh1 gc3_e8_vm gc3_e8_rec gc3_e8_vms 0 nch W=2e-06 L=1e-06
va_ngc3_e8_sh2_s vrest ngc3_e8_sh2_s 0
ngc3_e8_sh2 gc3_e8_vms gc3_e8_qb ngc3_e8_sh2_s 0 nch W=2e-06 L=1e-06
ngc3_e8_porh gc3_e8_h por_hold vthe 0 nch W=2e-06 L=1e-06
va_ngc3_e8_porm_s vrest ngc3_e8_porm_s 0
ngc3_e8_porm gc3_e8_vm por_hold ngc3_e8_porm_s 0 nch W=2e-06 L=1e-06
ngc3_e8_ip gc3_e8_vm s3_yb vdd vsrc pch W=4e-06 L=4e-06
ngc3_e8_in gc3_e8_vm s3_za 0 0 nch W=4e-06 L=4e-06
ngc3_b8_sw gc3_b8_t gc3_e8_qb vdd vsrc pch W=2e-06 L=1e-06
rgc3_b8_rc gc3_b8_t gc3_b8 10000
cgc3_b8_c gc3_b8 0 1e-07
rgc3_b8_rl gc3_b8 0 2.2e+07
ngc3_b8_sh1p gc3_b8_n gc3_b8 vdd vsrc pch W=2.4e-06 L=5e-07
ngc3_b8_sh1n gc3_b8_n gc3_b8 0 0 nch W=1.2e-06 L=5e-07
ngc3_b8_sh2p gc3_b8_q gc3_b8_n vdd vsrc pch W=2.4e-06 L=5e-07
ngc3_b8_sh2n gc3_b8_q gc3_b8_n 0 0 nch W=1.2e-06 L=5e-07
cgc3_e9_cm gc3_e9_vm 0 1e-07
va_rgc3_e9_rm_n vrest rgc3_e9_rm_n 0
rgc3_e9_rm gc3_e9_vm rgc3_e9_rm_n 1e+06
ngc3_e9_bias0 gc3_e9_vm istep_n 0 0 nch W=4e-06 L=4e-06
ngc3_e9_bias1 gc3_e9_vm istep_n 0 0 nch W=4e-06 L=4e-06
ngc3_e9_bias2 gc3_e9_vm istep_n 0 0 nch W=4e-06 L=4e-06
ngc3_e9_bias3 gc3_e9_vm istep_n 0 0 nch W=4e-06 L=4e-06
ngc3_e9_bias4 gc3_e9_vm istep_n 0 0 nch W=4e-06 L=4e-06
ngc3_e9_bias5 gc3_e9_vm istep_n 0 0 nch W=4e-06 L=4e-06
ngc3_e9_bias6 gc3_e9_vm istep_n 0 0 nch W=4e-06 L=4e-06
ngc3_e9_bias7 gc3_e9_vm istep_n 0 0 nch W=4e-06 L=4e-06
ngc3_e9_bias8 gc3_e9_vm istep_n 0 0 nch W=4e-06 L=4e-06
rgc3_e9_kb vdd gc3_e9_knb 1e+06
ngc3_e9_kmb gc3_e9_knb gc3_e9_knb 0 0 nch W=4e-06 L=4e-06
ngc3_e9_kmt gc3_e9_ktail gc3_e9_knb 0 0 nch W=4e-06 L=4e-06
ngc3_e9_km1 gc3_e9_kd1 gc3_e9_vm gc3_e9_ktail 0 nch W=4e-06 L=4e-06
ngc3_e9_km2 gc3_e9_ko1 gc3_e9_h gc3_e9_ktail 0 nch W=4e-06 L=4e-06
ngc3_e9_km3 gc3_e9_kd1 gc3_e9_kd1 vdd vsrc pch W=4e-06 L=4e-06
ngc3_e9_km4 gc3_e9_ko1 gc3_e9_kd1 vdd vsrc pch W=4e-06 L=4e-06
ngc3_e9_kporclamp gc3_e9_ko1 por_hold 0 0 nch W=4e-06 L=1e-06
ngc3_e9_ki1p gc3_e9_qb gc3_e9_ko1 vdd vsrc pch W=2.4e-06 L=5e-07
ngc3_e9_ki1n gc3_e9_qb gc3_e9_ko1 0 0 nch W=1.2e-06 L=5e-07
ngc3_e9_ki2p gc3_e9_q gc3_e9_qb vdd vsrc pch W=2.4e-06 L=5e-07
ngc3_e9_ki2n gc3_e9_q gc3_e9_qb 0 0 nch W=1.2e-06 L=5e-07
rgc3_e9_hra gc3_e9_h vthe 1e+06
rgc3_e9_hrf gc3_e9_h gc3_e9_qb 1.9e+07
cgc3_e9_hc gc3_e9_h 0 2.1e-09
ngc3_e9_dis gc3_e9_vm gc3_e9_q gc3_e9_vmd 0 nch W=4e-06 L=1e-06
va_rgc3_e9_rdis_n vrest rgc3_e9_rdis_n 0
rgc3_e9_rdis gc3_e9_vmd rgc3_e9_rdis_n 220000
ngc3_e9_rp gc3_e9_rt gc3_e9_qb vdd vsrc pch W=2e-06 L=1e-06
rgc3_e9_rrc gc3_e9_rt gc3_e9_rec 10000
cgc3_e9_rc gc3_e9_rec 0 1e-07
rgc3_e9_rr gc3_e9_rec 0 8.2e+06
ngc3_e9_sh1 gc3_e9_vm gc3_e9_rec gc3_e9_vms 0 nch W=2e-06 L=1e-06
va_ngc3_e9_sh2_s vrest ngc3_e9_sh2_s 0
ngc3_e9_sh2 gc3_e9_vms gc3_e9_qb ngc3_e9_sh2_s 0 nch W=2e-06 L=1e-06
ngc3_e9_porh gc3_e9_h por_hold vthe 0 nch W=2e-06 L=1e-06
va_ngc3_e9_porm_s vrest ngc3_e9_porm_s 0
ngc3_e9_porm gc3_e9_vm por_hold ngc3_e9_porm_s 0 nch W=2e-06 L=1e-06
ngc3_e9_ip gc3_e9_vm s3_yb vdd vsrc pch W=4e-06 L=4e-06
ngc3_e9_in gc3_e9_vm s3_za 0 0 nch W=4e-06 L=4e-06
ngc3_b9_sw gc3_b9_t gc3_e9_qb vdd vsrc pch W=2e-06 L=1e-06
rgc3_b9_rc gc3_b9_t gc3_b9 10000
cgc3_b9_c gc3_b9 0 1e-07
rgc3_b9_rl gc3_b9 0 2.2e+07
ngc3_b9_sh1p gc3_b9_n gc3_b9 vdd vsrc pch W=2.4e-06 L=5e-07
ngc3_b9_sh1n gc3_b9_n gc3_b9 0 0 nch W=1.2e-06 L=5e-07
ngc3_b9_sh2p gc3_b9_q gc3_b9_n vdd vsrc pch W=2.4e-06 L=5e-07
ngc3_b9_sh2n gc3_b9_q gc3_b9_n 0 0 nch W=1.2e-06 L=5e-07
cgc3_e10_cm gc3_e10_vm 0 1e-07
va_rgc3_e10_rm_n vrest rgc3_e10_rm_n 0
rgc3_e10_rm gc3_e10_vm rgc3_e10_rm_n 1e+06
ngc3_e10_bias0 gc3_e10_vm istep_n 0 0 nch W=4e-06 L=4e-06
ngc3_e10_bias1 gc3_e10_vm istep_n 0 0 nch W=4e-06 L=4e-06
ngc3_e10_bias2 gc3_e10_vm istep_n 0 0 nch W=4e-06 L=4e-06
ngc3_e10_bias3 gc3_e10_vm istep_n 0 0 nch W=4e-06 L=4e-06
ngc3_e10_bias4 gc3_e10_vm istep_n 0 0 nch W=4e-06 L=4e-06
ngc3_e10_bias5 gc3_e10_vm istep_n 0 0 nch W=4e-06 L=4e-06
ngc3_e10_bias6 gc3_e10_vm istep_n 0 0 nch W=4e-06 L=4e-06
ngc3_e10_bias7 gc3_e10_vm istep_n 0 0 nch W=4e-06 L=4e-06
ngc3_e10_bias8 gc3_e10_vm istep_n 0 0 nch W=4e-06 L=4e-06
ngc3_e10_bias9 gc3_e10_vm istep_n 0 0 nch W=4e-06 L=4e-06
rgc3_e10_kb vdd gc3_e10_knb 1e+06
ngc3_e10_kmb gc3_e10_knb gc3_e10_knb 0 0 nch W=4e-06 L=4e-06
ngc3_e10_kmt gc3_e10_ktail gc3_e10_knb 0 0 nch W=4e-06 L=4e-06
ngc3_e10_km1 gc3_e10_kd1 gc3_e10_vm gc3_e10_ktail 0 nch W=4e-06 L=4e-06
ngc3_e10_km2 gc3_e10_ko1 gc3_e10_h gc3_e10_ktail 0 nch W=4e-06 L=4e-06
ngc3_e10_km3 gc3_e10_kd1 gc3_e10_kd1 vdd vsrc pch W=4e-06 L=4e-06
ngc3_e10_km4 gc3_e10_ko1 gc3_e10_kd1 vdd vsrc pch W=4e-06 L=4e-06
ngc3_e10_kporclamp gc3_e10_ko1 por_hold 0 0 nch W=4e-06 L=1e-06
ngc3_e10_ki1p gc3_e10_qb gc3_e10_ko1 vdd vsrc pch W=2.4e-06 L=5e-07
ngc3_e10_ki1n gc3_e10_qb gc3_e10_ko1 0 0 nch W=1.2e-06 L=5e-07
ngc3_e10_ki2p gc3_e10_q gc3_e10_qb vdd vsrc pch W=2.4e-06 L=5e-07
ngc3_e10_ki2n gc3_e10_q gc3_e10_qb 0 0 nch W=1.2e-06 L=5e-07
rgc3_e10_hra gc3_e10_h vthe 1e+06
rgc3_e10_hrf gc3_e10_h gc3_e10_qb 1.9e+07
cgc3_e10_hc gc3_e10_h 0 2.1e-09
ngc3_e10_dis gc3_e10_vm gc3_e10_q gc3_e10_vmd 0 nch W=4e-06 L=1e-06
va_rgc3_e10_rdis_n vrest rgc3_e10_rdis_n 0
rgc3_e10_rdis gc3_e10_vmd rgc3_e10_rdis_n 220000
ngc3_e10_rp gc3_e10_rt gc3_e10_qb vdd vsrc pch W=2e-06 L=1e-06
rgc3_e10_rrc gc3_e10_rt gc3_e10_rec 10000
cgc3_e10_rc gc3_e10_rec 0 1e-07
rgc3_e10_rr gc3_e10_rec 0 8.2e+06
ngc3_e10_sh1 gc3_e10_vm gc3_e10_rec gc3_e10_vms 0 nch W=2e-06 L=1e-06
va_ngc3_e10_sh2_s vrest ngc3_e10_sh2_s 0
ngc3_e10_sh2 gc3_e10_vms gc3_e10_qb ngc3_e10_sh2_s 0 nch W=2e-06 L=1e-06
ngc3_e10_porh gc3_e10_h por_hold vthe 0 nch W=2e-06 L=1e-06
va_ngc3_e10_porm_s vrest ngc3_e10_porm_s 0
ngc3_e10_porm gc3_e10_vm por_hold ngc3_e10_porm_s 0 nch W=2e-06 L=1e-06
ngc3_e10_ip gc3_e10_vm s3_yb vdd vsrc pch W=4e-06 L=4e-06
ngc3_e10_in gc3_e10_vm s3_za 0 0 nch W=4e-06 L=4e-06
ngc3_b10_sw gc3_b10_t gc3_e10_qb vdd vsrc pch W=2e-06 L=1e-06
rgc3_b10_rc gc3_b10_t gc3_b10 10000
cgc3_b10_c gc3_b10 0 1e-07
rgc3_b10_rl gc3_b10 0 2.2e+07
ngc3_b10_sh1p gc3_b10_n gc3_b10 vdd vsrc pch W=2.4e-06 L=5e-07
ngc3_b10_sh1n gc3_b10_n gc3_b10 0 0 nch W=1.2e-06 L=5e-07
ngc3_b10_sh2p gc3_b10_q gc3_b10_n vdd vsrc pch W=2.4e-06 L=5e-07
ngc3_b10_sh2n gc3_b10_q gc3_b10_n 0 0 nch W=1.2e-06 L=5e-07
ngc3_and_a0_npa gc3_and_a0_nb gc3_b1_q vdd vsrc pch W=2.4e-06 L=5e-07
ngc3_and_a0_npb gc3_and_a0_nb gc3_b2_q vdd vsrc pch W=2.4e-06 L=5e-07
ngc3_and_a0_nna gc3_and_a0_nb gc3_b1_q gc3_and_a0_nx 0 nch W=2.4e-06 L=5e-07
ngc3_and_a0_nnb gc3_and_a0_nx gc3_b2_q 0 0 nch W=2.4e-06 L=5e-07
ngc3_and_a0_ip gc3_and_g0 gc3_and_a0_nb vdd vsrc pch W=2.4e-06 L=5e-07
ngc3_and_a0_in gc3_and_g0 gc3_and_a0_nb 0 0 nch W=1.2e-06 L=5e-07
ngc3_and_a1_npa gc3_and_a1_nb gc3_b3_q vdd vsrc pch W=2.4e-06 L=5e-07
ngc3_and_a1_npb gc3_and_a1_nb gc3_b4_q vdd vsrc pch W=2.4e-06 L=5e-07
ngc3_and_a1_nna gc3_and_a1_nb gc3_b3_q gc3_and_a1_nx 0 nch W=2.4e-06 L=5e-07
ngc3_and_a1_nnb gc3_and_a1_nx gc3_b4_q 0 0 nch W=2.4e-06 L=5e-07
ngc3_and_a1_ip gc3_and_g1 gc3_and_a1_nb vdd vsrc pch W=2.4e-06 L=5e-07
ngc3_and_a1_in gc3_and_g1 gc3_and_a1_nb 0 0 nch W=1.2e-06 L=5e-07
ngc3_and_a2_npa gc3_and_a2_nb gc3_b5_q vdd vsrc pch W=2.4e-06 L=5e-07
ngc3_and_a2_npb gc3_and_a2_nb gc3_b6_q vdd vsrc pch W=2.4e-06 L=5e-07
ngc3_and_a2_nna gc3_and_a2_nb gc3_b5_q gc3_and_a2_nx 0 nch W=2.4e-06 L=5e-07
ngc3_and_a2_nnb gc3_and_a2_nx gc3_b6_q 0 0 nch W=2.4e-06 L=5e-07
ngc3_and_a2_ip gc3_and_g2 gc3_and_a2_nb vdd vsrc pch W=2.4e-06 L=5e-07
ngc3_and_a2_in gc3_and_g2 gc3_and_a2_nb 0 0 nch W=1.2e-06 L=5e-07
ngc3_and_a3_npa gc3_and_a3_nb gc3_b7_q vdd vsrc pch W=2.4e-06 L=5e-07
ngc3_and_a3_npb gc3_and_a3_nb gc3_b8_q vdd vsrc pch W=2.4e-06 L=5e-07
ngc3_and_a3_nna gc3_and_a3_nb gc3_b7_q gc3_and_a3_nx 0 nch W=2.4e-06 L=5e-07
ngc3_and_a3_nnb gc3_and_a3_nx gc3_b8_q 0 0 nch W=2.4e-06 L=5e-07
ngc3_and_a3_ip gc3_and_g3 gc3_and_a3_nb vdd vsrc pch W=2.4e-06 L=5e-07
ngc3_and_a3_in gc3_and_g3 gc3_and_a3_nb 0 0 nch W=1.2e-06 L=5e-07
ngc3_and_a4_npa gc3_and_a4_nb gc3_b9_q vdd vsrc pch W=2.4e-06 L=5e-07
ngc3_and_a4_npb gc3_and_a4_nb gc3_b10_q vdd vsrc pch W=2.4e-06 L=5e-07
ngc3_and_a4_nna gc3_and_a4_nb gc3_b9_q gc3_and_a4_nx 0 nch W=2.4e-06 L=5e-07
ngc3_and_a4_nnb gc3_and_a4_nx gc3_b10_q 0 0 nch W=2.4e-06 L=5e-07
ngc3_and_a4_ip gc3_and_g4 gc3_and_a4_nb vdd vsrc pch W=2.4e-06 L=5e-07
ngc3_and_a4_in gc3_and_g4 gc3_and_a4_nb 0 0 nch W=1.2e-06 L=5e-07
ngc3_and_a5_npa gc3_and_a5_nb gc3_and_g0 vdd vsrc pch W=2.4e-06 L=5e-07
ngc3_and_a5_npb gc3_and_a5_nb gc3_and_g1 vdd vsrc pch W=2.4e-06 L=5e-07
ngc3_and_a5_nna gc3_and_a5_nb gc3_and_g0 gc3_and_a5_nx 0 nch W=2.4e-06 L=5e-07
ngc3_and_a5_nnb gc3_and_a5_nx gc3_and_g1 0 0 nch W=2.4e-06 L=5e-07
ngc3_and_a5_ip gc3_and_g5 gc3_and_a5_nb vdd vsrc pch W=2.4e-06 L=5e-07
ngc3_and_a5_in gc3_and_g5 gc3_and_a5_nb 0 0 nch W=1.2e-06 L=5e-07
ngc3_and_a6_npa gc3_and_a6_nb gc3_and_g2 vdd vsrc pch W=2.4e-06 L=5e-07
ngc3_and_a6_npb gc3_and_a6_nb gc3_and_g3 vdd vsrc pch W=2.4e-06 L=5e-07
ngc3_and_a6_nna gc3_and_a6_nb gc3_and_g2 gc3_and_a6_nx 0 nch W=2.4e-06 L=5e-07
ngc3_and_a6_nnb gc3_and_a6_nx gc3_and_g3 0 0 nch W=2.4e-06 L=5e-07
ngc3_and_a6_ip gc3_and_g6 gc3_and_a6_nb vdd vsrc pch W=2.4e-06 L=5e-07
ngc3_and_a6_in gc3_and_g6 gc3_and_a6_nb 0 0 nch W=1.2e-06 L=5e-07
ngc3_and_a7_npa gc3_and_a7_nb gc3_and_g5 vdd vsrc pch W=2.4e-06 L=5e-07
ngc3_and_a7_npb gc3_and_a7_nb gc3_and_g6 vdd vsrc pch W=2.4e-06 L=5e-07
ngc3_and_a7_nna gc3_and_a7_nb gc3_and_g5 gc3_and_a7_nx 0 nch W=2.4e-06 L=5e-07
ngc3_and_a7_nnb gc3_and_a7_nx gc3_and_g6 0 0 nch W=2.4e-06 L=5e-07
ngc3_and_a7_ip gc3_and_g7 gc3_and_a7_nb vdd vsrc pch W=2.4e-06 L=5e-07
ngc3_and_a7_in gc3_and_g7 gc3_and_a7_nb 0 0 nch W=1.2e-06 L=5e-07
ngc3_and_a8_npa gc3_and_a8_nb gc3_and_g7 vdd vsrc pch W=2.4e-06 L=5e-07
ngc3_and_a8_npb gc3_and_a8_nb gc3_and_g4 vdd vsrc pch W=2.4e-06 L=5e-07
ngc3_and_a8_nna gc3_and_a8_nb gc3_and_g7 gc3_and_a8_nx 0 nch W=2.4e-06 L=5e-07
ngc3_and_a8_nnb gc3_and_a8_nx gc3_and_g4 0 0 nch W=2.4e-06 L=5e-07
ngc3_and_a8_ip gc3_and_g8 gc3_and_a8_nb vdd vsrc pch W=2.4e-06 L=5e-07
ngc3_and_a8_in gc3_and_g8 gc3_and_a8_nb 0 0 nch W=1.2e-06 L=5e-07
ngc3_gip gc3_gb gc3_and_g8 vdd vsrc pch W=2.4e-06 L=5e-07
ngc3_gin gc3_gb gc3_and_g8 0 0 nch W=1.2e-06 L=5e-07
cgc3_col_cm gc3_col_vm 0 1e-07
va_rgc3_col_rm_n vrest rgc3_col_rm_n 0
rgc3_col_rm gc3_col_vm rgc3_col_rm_n 1e+06
rgc3_col_kb vdd gc3_col_knb 1e+06
ngc3_col_kmb gc3_col_knb gc3_col_knb 0 0 nch W=4e-06 L=4e-06
ngc3_col_kmt gc3_col_ktail gc3_col_knb 0 0 nch W=4e-06 L=4e-06
ngc3_col_km1 gc3_col_kd1 gc3_col_vm gc3_col_ktail 0 nch W=4e-06 L=4e-06
ngc3_col_km2 gc3_col_ko1 gc3_col_h gc3_col_ktail 0 nch W=4e-06 L=4e-06
ngc3_col_km3 gc3_col_kd1 gc3_col_kd1 vdd vsrc pch W=4e-06 L=4e-06
ngc3_col_km4 gc3_col_ko1 gc3_col_kd1 vdd vsrc pch W=4e-06 L=4e-06
ngc3_col_kporclamp gc3_col_ko1 por_hold 0 0 nch W=4e-06 L=1e-06
ngc3_col_ki1p gc3_col_qb gc3_col_ko1 vdd vsrc pch W=2.4e-06 L=5e-07
ngc3_col_ki1n gc3_col_qb gc3_col_ko1 0 0 nch W=1.2e-06 L=5e-07
ngc3_col_ki2p gc3_col_q gc3_col_qb vdd vsrc pch W=2.4e-06 L=5e-07
ngc3_col_ki2n gc3_col_q gc3_col_qb 0 0 nch W=1.2e-06 L=5e-07
rgc3_col_hra gc3_col_h vthe 1e+06
rgc3_col_hrf gc3_col_h gc3_col_qb 1.9e+07
cgc3_col_hc gc3_col_h 0 2.1e-09
ngc3_col_dis gc3_col_vm gc3_col_q gc3_col_vmd 0 nch W=4e-06 L=1e-06
va_rgc3_col_rdis_n vrest rgc3_col_rdis_n 0
rgc3_col_rdis gc3_col_vmd rgc3_col_rdis_n 220000
ngc3_col_rp gc3_col_rt gc3_col_qb vdd vsrc pch W=2e-06 L=1e-06
rgc3_col_rrc gc3_col_rt gc3_col_rec 10000
cgc3_col_rc gc3_col_rec 0 1e-07
rgc3_col_rr gc3_col_rec 0 8.2e+06
ngc3_col_sh1 gc3_col_vm gc3_col_rec gc3_col_vms 0 nch W=2e-06 L=1e-06
va_ngc3_col_sh2_s vrest ngc3_col_sh2_s 0
ngc3_col_sh2 gc3_col_vms gc3_col_qb ngc3_col_sh2_s 0 nch W=2e-06 L=1e-06
ngc3_col_porh gc3_col_h por_hold vthe 0 nch W=2e-06 L=1e-06
va_ngc3_col_porm_s vrest ngc3_col_porm_s 0
ngc3_col_porm gc3_col_vm por_hold ngc3_col_porm_s 0 nch W=2e-06 L=1e-06
ngc3_cin_eni_p gc3_cin_ena gc3_gb vdd vsrc pch W=2.4e-06 L=5e-07
ngc3_cin_eni_n gc3_cin_ena gc3_gb 0 0 nch W=1.2e-06 L=5e-07
ngc3_cin_cp gc3_col_vm gc3_cin_cg vdd vsrc pch W=4e-06 L=4e-06
ngc3_cin_bias ilimp_n gc3_gb gc3_cin_cg vsrc pch W=1.2e-06 L=1e-06
ngc3_cin_off gc3_cin_cg gc3_cin_ena vdd vsrc pch W=2.4e-06 L=1e-06
ngc3_op_tsw gc3_op_tt gc3_col_qb vdd vsrc pch W=2e-06 L=1e-06
rgc3_op_trc gc3_op_tt gc3_op_at 10000
cgc3_op_tc gc3_op_at 0 1e-07
rgc3_op_trl gc3_op_at 0 2.2e+07
ngc3_op_sh1p gc3_op_an gc3_op_at vdd vsrc pch W=2.4e-06 L=5e-07
ngc3_op_sh1n gc3_op_an gc3_op_at 0 0 nch W=1.2e-06 L=5e-07
ngc3_op_sh2p gc3_op_aq gc3_op_an vdd vsrc pch W=2.4e-06 L=5e-07
ngc3_op_sh2n gc3_op_aq gc3_op_an 0 0 nch W=1.2e-06 L=5e-07
ngc3_op_abp gc3_op_aqb gc3_op_aq vdd vsrc pch W=2.4e-06 L=5e-07
ngc3_op_abn gc3_op_aqb gc3_op_aq 0 0 nch W=1.2e-06 L=5e-07
rgc3_op_dr gc3_op_aq gc3_op_ad 1e+06
cgc3_op_dc gc3_op_ad 0 3.3e-07
ngc3_op_d2p gc3_op_adn gc3_op_ad vdd vsrc pch W=2.4e-06 L=5e-07
ngc3_op_d2n gc3_op_adn gc3_op_ad 0 0 nch W=1.2e-06 L=5e-07
ngc3_op_gpa gc3_op_pb gc3_op_aq vdd vsrc pch W=2.4e-06 L=5e-07
ngc3_op_gpb gc3_op_pb gc3_op_adn vdd vsrc pch W=2.4e-06 L=5e-07
ngc3_op_gna gc3_op_pb gc3_op_aq gc3_op_gx 0 nch W=2.4e-06 L=5e-07
ngc3_op_gnb gc3_op_gx gc3_op_adn 0 0 nch W=2.4e-06 L=5e-07
ngc3_op_op gc3_op_p gc3_op_pb vdd vsrc pch W=2.4e-06 L=5e-07
ngc3_op_on gc3_op_p gc3_op_pb 0 0 nch W=1.2e-06 L=5e-07
cgw4_e1_cm gw4_e1_vm 0 1e-07
va_rgw4_e1_rm_n vrest rgw4_e1_rm_n 0
rgw4_e1_rm gw4_e1_vm rgw4_e1_rm_n 1e+06
ngw4_e1_bias0 gw4_e1_vm istep_n 0 0 nch W=4e-06 L=4e-06
rgw4_e1_kb vdd gw4_e1_knb 1e+06
ngw4_e1_kmb gw4_e1_knb gw4_e1_knb 0 0 nch W=4e-06 L=4e-06
ngw4_e1_kmt gw4_e1_ktail gw4_e1_knb 0 0 nch W=4e-06 L=4e-06
ngw4_e1_km1 gw4_e1_kd1 gw4_e1_vm gw4_e1_ktail 0 nch W=4e-06 L=4e-06
ngw4_e1_km2 gw4_e1_ko1 gw4_e1_h gw4_e1_ktail 0 nch W=4e-06 L=4e-06
ngw4_e1_km3 gw4_e1_kd1 gw4_e1_kd1 vdd vsrc pch W=4e-06 L=4e-06
ngw4_e1_km4 gw4_e1_ko1 gw4_e1_kd1 vdd vsrc pch W=4e-06 L=4e-06
ngw4_e1_kporclamp gw4_e1_ko1 por_hold 0 0 nch W=4e-06 L=1e-06
ngw4_e1_ki1p gw4_e1_qb gw4_e1_ko1 vdd vsrc pch W=2.4e-06 L=5e-07
ngw4_e1_ki1n gw4_e1_qb gw4_e1_ko1 0 0 nch W=1.2e-06 L=5e-07
ngw4_e1_ki2p gw4_e1_q gw4_e1_qb vdd vsrc pch W=2.4e-06 L=5e-07
ngw4_e1_ki2n gw4_e1_q gw4_e1_qb 0 0 nch W=1.2e-06 L=5e-07
rgw4_e1_hra gw4_e1_h vthe 1e+06
rgw4_e1_hrf gw4_e1_h gw4_e1_qb 1.9e+07
cgw4_e1_hc gw4_e1_h 0 2.1e-09
ngw4_e1_dis gw4_e1_vm gw4_e1_q gw4_e1_vmd 0 nch W=4e-06 L=1e-06
va_rgw4_e1_rdis_n vrest rgw4_e1_rdis_n 0
rgw4_e1_rdis gw4_e1_vmd rgw4_e1_rdis_n 220000
ngw4_e1_rp gw4_e1_rt gw4_e1_qb vdd vsrc pch W=2e-06 L=1e-06
rgw4_e1_rrc gw4_e1_rt gw4_e1_rec 10000
cgw4_e1_rc gw4_e1_rec 0 1e-07
rgw4_e1_rr gw4_e1_rec 0 8.2e+06
ngw4_e1_sh1 gw4_e1_vm gw4_e1_rec gw4_e1_vms 0 nch W=2e-06 L=1e-06
va_ngw4_e1_sh2_s vrest ngw4_e1_sh2_s 0
ngw4_e1_sh2 gw4_e1_vms gw4_e1_qb ngw4_e1_sh2_s 0 nch W=2e-06 L=1e-06
ngw4_e1_porh gw4_e1_h por_hold vthe 0 nch W=2e-06 L=1e-06
va_ngw4_e1_porm_s vrest ngw4_e1_porm_s 0
ngw4_e1_porm gw4_e1_vm por_hold ngw4_e1_porm_s 0 nch W=2e-06 L=1e-06
ngw4_e1_ip gw4_e1_vm s4_ya vdd vsrc pch W=4e-06 L=4e-06
ngw4_e1_in gw4_e1_vm s4_zb 0 0 nch W=4e-06 L=4e-06
ngw4_b1_sw gw4_b1_t gw4_e1_qb vdd vsrc pch W=2e-06 L=1e-06
rgw4_b1_rc gw4_b1_t gw4_b1 10000
cgw4_b1_c gw4_b1 0 1e-07
rgw4_b1_rl gw4_b1 0 2.2e+07
ngw4_b1_sh1p gw4_b1_n gw4_b1 vdd vsrc pch W=2.4e-06 L=5e-07
ngw4_b1_sh1n gw4_b1_n gw4_b1 0 0 nch W=1.2e-06 L=5e-07
ngw4_b1_sh2p gw4_b1_q gw4_b1_n vdd vsrc pch W=2.4e-06 L=5e-07
ngw4_b1_sh2n gw4_b1_q gw4_b1_n 0 0 nch W=1.2e-06 L=5e-07
cgw4_e2_cm gw4_e2_vm 0 1e-07
va_rgw4_e2_rm_n vrest rgw4_e2_rm_n 0
rgw4_e2_rm gw4_e2_vm rgw4_e2_rm_n 1e+06
ngw4_e2_bias0 gw4_e2_vm istep_n 0 0 nch W=4e-06 L=4e-06
ngw4_e2_bias1 gw4_e2_vm istep_n 0 0 nch W=4e-06 L=4e-06
rgw4_e2_kb vdd gw4_e2_knb 1e+06
ngw4_e2_kmb gw4_e2_knb gw4_e2_knb 0 0 nch W=4e-06 L=4e-06
ngw4_e2_kmt gw4_e2_ktail gw4_e2_knb 0 0 nch W=4e-06 L=4e-06
ngw4_e2_km1 gw4_e2_kd1 gw4_e2_vm gw4_e2_ktail 0 nch W=4e-06 L=4e-06
ngw4_e2_km2 gw4_e2_ko1 gw4_e2_h gw4_e2_ktail 0 nch W=4e-06 L=4e-06
ngw4_e2_km3 gw4_e2_kd1 gw4_e2_kd1 vdd vsrc pch W=4e-06 L=4e-06
ngw4_e2_km4 gw4_e2_ko1 gw4_e2_kd1 vdd vsrc pch W=4e-06 L=4e-06
ngw4_e2_kporclamp gw4_e2_ko1 por_hold 0 0 nch W=4e-06 L=1e-06
ngw4_e2_ki1p gw4_e2_qb gw4_e2_ko1 vdd vsrc pch W=2.4e-06 L=5e-07
ngw4_e2_ki1n gw4_e2_qb gw4_e2_ko1 0 0 nch W=1.2e-06 L=5e-07
ngw4_e2_ki2p gw4_e2_q gw4_e2_qb vdd vsrc pch W=2.4e-06 L=5e-07
ngw4_e2_ki2n gw4_e2_q gw4_e2_qb 0 0 nch W=1.2e-06 L=5e-07
rgw4_e2_hra gw4_e2_h vthe 1e+06
rgw4_e2_hrf gw4_e2_h gw4_e2_qb 1.9e+07
cgw4_e2_hc gw4_e2_h 0 2.1e-09
ngw4_e2_dis gw4_e2_vm gw4_e2_q gw4_e2_vmd 0 nch W=4e-06 L=1e-06
va_rgw4_e2_rdis_n vrest rgw4_e2_rdis_n 0
rgw4_e2_rdis gw4_e2_vmd rgw4_e2_rdis_n 220000
ngw4_e2_rp gw4_e2_rt gw4_e2_qb vdd vsrc pch W=2e-06 L=1e-06
rgw4_e2_rrc gw4_e2_rt gw4_e2_rec 10000
cgw4_e2_rc gw4_e2_rec 0 1e-07
rgw4_e2_rr gw4_e2_rec 0 8.2e+06
ngw4_e2_sh1 gw4_e2_vm gw4_e2_rec gw4_e2_vms 0 nch W=2e-06 L=1e-06
va_ngw4_e2_sh2_s vrest ngw4_e2_sh2_s 0
ngw4_e2_sh2 gw4_e2_vms gw4_e2_qb ngw4_e2_sh2_s 0 nch W=2e-06 L=1e-06
ngw4_e2_porh gw4_e2_h por_hold vthe 0 nch W=2e-06 L=1e-06
va_ngw4_e2_porm_s vrest ngw4_e2_porm_s 0
ngw4_e2_porm gw4_e2_vm por_hold ngw4_e2_porm_s 0 nch W=2e-06 L=1e-06
ngw4_e2_ip gw4_e2_vm s4_ya vdd vsrc pch W=4e-06 L=4e-06
ngw4_e2_in gw4_e2_vm s4_zb 0 0 nch W=4e-06 L=4e-06
ngw4_b2_sw gw4_b2_t gw4_e2_qb vdd vsrc pch W=2e-06 L=1e-06
rgw4_b2_rc gw4_b2_t gw4_b2 10000
cgw4_b2_c gw4_b2 0 1e-07
rgw4_b2_rl gw4_b2 0 2.2e+07
ngw4_b2_sh1p gw4_b2_n gw4_b2 vdd vsrc pch W=2.4e-06 L=5e-07
ngw4_b2_sh1n gw4_b2_n gw4_b2 0 0 nch W=1.2e-06 L=5e-07
ngw4_b2_sh2p gw4_b2_q gw4_b2_n vdd vsrc pch W=2.4e-06 L=5e-07
ngw4_b2_sh2n gw4_b2_q gw4_b2_n 0 0 nch W=1.2e-06 L=5e-07
cgw4_e3_cm gw4_e3_vm 0 1e-07
va_rgw4_e3_rm_n vrest rgw4_e3_rm_n 0
rgw4_e3_rm gw4_e3_vm rgw4_e3_rm_n 1e+06
ngw4_e3_bias0 gw4_e3_vm istep_n 0 0 nch W=4e-06 L=4e-06
ngw4_e3_bias1 gw4_e3_vm istep_n 0 0 nch W=4e-06 L=4e-06
ngw4_e3_bias2 gw4_e3_vm istep_n 0 0 nch W=4e-06 L=4e-06
rgw4_e3_kb vdd gw4_e3_knb 1e+06
ngw4_e3_kmb gw4_e3_knb gw4_e3_knb 0 0 nch W=4e-06 L=4e-06
ngw4_e3_kmt gw4_e3_ktail gw4_e3_knb 0 0 nch W=4e-06 L=4e-06
ngw4_e3_km1 gw4_e3_kd1 gw4_e3_vm gw4_e3_ktail 0 nch W=4e-06 L=4e-06
ngw4_e3_km2 gw4_e3_ko1 gw4_e3_h gw4_e3_ktail 0 nch W=4e-06 L=4e-06
ngw4_e3_km3 gw4_e3_kd1 gw4_e3_kd1 vdd vsrc pch W=4e-06 L=4e-06
ngw4_e3_km4 gw4_e3_ko1 gw4_e3_kd1 vdd vsrc pch W=4e-06 L=4e-06
ngw4_e3_kporclamp gw4_e3_ko1 por_hold 0 0 nch W=4e-06 L=1e-06
ngw4_e3_ki1p gw4_e3_qb gw4_e3_ko1 vdd vsrc pch W=2.4e-06 L=5e-07
ngw4_e3_ki1n gw4_e3_qb gw4_e3_ko1 0 0 nch W=1.2e-06 L=5e-07
ngw4_e3_ki2p gw4_e3_q gw4_e3_qb vdd vsrc pch W=2.4e-06 L=5e-07
ngw4_e3_ki2n gw4_e3_q gw4_e3_qb 0 0 nch W=1.2e-06 L=5e-07
rgw4_e3_hra gw4_e3_h vthe 1e+06
rgw4_e3_hrf gw4_e3_h gw4_e3_qb 1.9e+07
cgw4_e3_hc gw4_e3_h 0 2.1e-09
ngw4_e3_dis gw4_e3_vm gw4_e3_q gw4_e3_vmd 0 nch W=4e-06 L=1e-06
va_rgw4_e3_rdis_n vrest rgw4_e3_rdis_n 0
rgw4_e3_rdis gw4_e3_vmd rgw4_e3_rdis_n 220000
ngw4_e3_rp gw4_e3_rt gw4_e3_qb vdd vsrc pch W=2e-06 L=1e-06
rgw4_e3_rrc gw4_e3_rt gw4_e3_rec 10000
cgw4_e3_rc gw4_e3_rec 0 1e-07
rgw4_e3_rr gw4_e3_rec 0 8.2e+06
ngw4_e3_sh1 gw4_e3_vm gw4_e3_rec gw4_e3_vms 0 nch W=2e-06 L=1e-06
va_ngw4_e3_sh2_s vrest ngw4_e3_sh2_s 0
ngw4_e3_sh2 gw4_e3_vms gw4_e3_qb ngw4_e3_sh2_s 0 nch W=2e-06 L=1e-06
ngw4_e3_porh gw4_e3_h por_hold vthe 0 nch W=2e-06 L=1e-06
va_ngw4_e3_porm_s vrest ngw4_e3_porm_s 0
ngw4_e3_porm gw4_e3_vm por_hold ngw4_e3_porm_s 0 nch W=2e-06 L=1e-06
ngw4_e3_ip gw4_e3_vm s4_ya vdd vsrc pch W=4e-06 L=4e-06
ngw4_e3_in gw4_e3_vm s4_zb 0 0 nch W=4e-06 L=4e-06
ngw4_b3_sw gw4_b3_t gw4_e3_qb vdd vsrc pch W=2e-06 L=1e-06
rgw4_b3_rc gw4_b3_t gw4_b3 10000
cgw4_b3_c gw4_b3 0 1e-07
rgw4_b3_rl gw4_b3 0 2.2e+07
ngw4_b3_sh1p gw4_b3_n gw4_b3 vdd vsrc pch W=2.4e-06 L=5e-07
ngw4_b3_sh1n gw4_b3_n gw4_b3 0 0 nch W=1.2e-06 L=5e-07
ngw4_b3_sh2p gw4_b3_q gw4_b3_n vdd vsrc pch W=2.4e-06 L=5e-07
ngw4_b3_sh2n gw4_b3_q gw4_b3_n 0 0 nch W=1.2e-06 L=5e-07
cgw4_e4_cm gw4_e4_vm 0 1e-07
va_rgw4_e4_rm_n vrest rgw4_e4_rm_n 0
rgw4_e4_rm gw4_e4_vm rgw4_e4_rm_n 1e+06
ngw4_e4_bias0 gw4_e4_vm istep_n 0 0 nch W=4e-06 L=4e-06
ngw4_e4_bias1 gw4_e4_vm istep_n 0 0 nch W=4e-06 L=4e-06
ngw4_e4_bias2 gw4_e4_vm istep_n 0 0 nch W=4e-06 L=4e-06
ngw4_e4_bias3 gw4_e4_vm istep_n 0 0 nch W=4e-06 L=4e-06
rgw4_e4_kb vdd gw4_e4_knb 1e+06
ngw4_e4_kmb gw4_e4_knb gw4_e4_knb 0 0 nch W=4e-06 L=4e-06
ngw4_e4_kmt gw4_e4_ktail gw4_e4_knb 0 0 nch W=4e-06 L=4e-06
ngw4_e4_km1 gw4_e4_kd1 gw4_e4_vm gw4_e4_ktail 0 nch W=4e-06 L=4e-06
ngw4_e4_km2 gw4_e4_ko1 gw4_e4_h gw4_e4_ktail 0 nch W=4e-06 L=4e-06
ngw4_e4_km3 gw4_e4_kd1 gw4_e4_kd1 vdd vsrc pch W=4e-06 L=4e-06
ngw4_e4_km4 gw4_e4_ko1 gw4_e4_kd1 vdd vsrc pch W=4e-06 L=4e-06
ngw4_e4_kporclamp gw4_e4_ko1 por_hold 0 0 nch W=4e-06 L=1e-06
ngw4_e4_ki1p gw4_e4_qb gw4_e4_ko1 vdd vsrc pch W=2.4e-06 L=5e-07
ngw4_e4_ki1n gw4_e4_qb gw4_e4_ko1 0 0 nch W=1.2e-06 L=5e-07
ngw4_e4_ki2p gw4_e4_q gw4_e4_qb vdd vsrc pch W=2.4e-06 L=5e-07
ngw4_e4_ki2n gw4_e4_q gw4_e4_qb 0 0 nch W=1.2e-06 L=5e-07
rgw4_e4_hra gw4_e4_h vthe 1e+06
rgw4_e4_hrf gw4_e4_h gw4_e4_qb 1.9e+07
cgw4_e4_hc gw4_e4_h 0 2.1e-09
ngw4_e4_dis gw4_e4_vm gw4_e4_q gw4_e4_vmd 0 nch W=4e-06 L=1e-06
va_rgw4_e4_rdis_n vrest rgw4_e4_rdis_n 0
rgw4_e4_rdis gw4_e4_vmd rgw4_e4_rdis_n 220000
ngw4_e4_rp gw4_e4_rt gw4_e4_qb vdd vsrc pch W=2e-06 L=1e-06
rgw4_e4_rrc gw4_e4_rt gw4_e4_rec 10000
cgw4_e4_rc gw4_e4_rec 0 1e-07
rgw4_e4_rr gw4_e4_rec 0 8.2e+06
ngw4_e4_sh1 gw4_e4_vm gw4_e4_rec gw4_e4_vms 0 nch W=2e-06 L=1e-06
va_ngw4_e4_sh2_s vrest ngw4_e4_sh2_s 0
ngw4_e4_sh2 gw4_e4_vms gw4_e4_qb ngw4_e4_sh2_s 0 nch W=2e-06 L=1e-06
ngw4_e4_porh gw4_e4_h por_hold vthe 0 nch W=2e-06 L=1e-06
va_ngw4_e4_porm_s vrest ngw4_e4_porm_s 0
ngw4_e4_porm gw4_e4_vm por_hold ngw4_e4_porm_s 0 nch W=2e-06 L=1e-06
ngw4_e4_ip gw4_e4_vm s4_ya vdd vsrc pch W=4e-06 L=4e-06
ngw4_e4_in gw4_e4_vm s4_zb 0 0 nch W=4e-06 L=4e-06
ngw4_b4_sw gw4_b4_t gw4_e4_qb vdd vsrc pch W=2e-06 L=1e-06
rgw4_b4_rc gw4_b4_t gw4_b4 10000
cgw4_b4_c gw4_b4 0 1e-07
rgw4_b4_rl gw4_b4 0 2.2e+07
ngw4_b4_sh1p gw4_b4_n gw4_b4 vdd vsrc pch W=2.4e-06 L=5e-07
ngw4_b4_sh1n gw4_b4_n gw4_b4 0 0 nch W=1.2e-06 L=5e-07
ngw4_b4_sh2p gw4_b4_q gw4_b4_n vdd vsrc pch W=2.4e-06 L=5e-07
ngw4_b4_sh2n gw4_b4_q gw4_b4_n 0 0 nch W=1.2e-06 L=5e-07
cgw4_e5_cm gw4_e5_vm 0 1e-07
va_rgw4_e5_rm_n vrest rgw4_e5_rm_n 0
rgw4_e5_rm gw4_e5_vm rgw4_e5_rm_n 1e+06
ngw4_e5_bias0 gw4_e5_vm istep_n 0 0 nch W=4e-06 L=4e-06
ngw4_e5_bias1 gw4_e5_vm istep_n 0 0 nch W=4e-06 L=4e-06
ngw4_e5_bias2 gw4_e5_vm istep_n 0 0 nch W=4e-06 L=4e-06
ngw4_e5_bias3 gw4_e5_vm istep_n 0 0 nch W=4e-06 L=4e-06
ngw4_e5_bias4 gw4_e5_vm istep_n 0 0 nch W=4e-06 L=4e-06
rgw4_e5_kb vdd gw4_e5_knb 1e+06
ngw4_e5_kmb gw4_e5_knb gw4_e5_knb 0 0 nch W=4e-06 L=4e-06
ngw4_e5_kmt gw4_e5_ktail gw4_e5_knb 0 0 nch W=4e-06 L=4e-06
ngw4_e5_km1 gw4_e5_kd1 gw4_e5_vm gw4_e5_ktail 0 nch W=4e-06 L=4e-06
ngw4_e5_km2 gw4_e5_ko1 gw4_e5_h gw4_e5_ktail 0 nch W=4e-06 L=4e-06
ngw4_e5_km3 gw4_e5_kd1 gw4_e5_kd1 vdd vsrc pch W=4e-06 L=4e-06
ngw4_e5_km4 gw4_e5_ko1 gw4_e5_kd1 vdd vsrc pch W=4e-06 L=4e-06
ngw4_e5_kporclamp gw4_e5_ko1 por_hold 0 0 nch W=4e-06 L=1e-06
ngw4_e5_ki1p gw4_e5_qb gw4_e5_ko1 vdd vsrc pch W=2.4e-06 L=5e-07
ngw4_e5_ki1n gw4_e5_qb gw4_e5_ko1 0 0 nch W=1.2e-06 L=5e-07
ngw4_e5_ki2p gw4_e5_q gw4_e5_qb vdd vsrc pch W=2.4e-06 L=5e-07
ngw4_e5_ki2n gw4_e5_q gw4_e5_qb 0 0 nch W=1.2e-06 L=5e-07
rgw4_e5_hra gw4_e5_h vthe 1e+06
rgw4_e5_hrf gw4_e5_h gw4_e5_qb 1.9e+07
cgw4_e5_hc gw4_e5_h 0 2.1e-09
ngw4_e5_dis gw4_e5_vm gw4_e5_q gw4_e5_vmd 0 nch W=4e-06 L=1e-06
va_rgw4_e5_rdis_n vrest rgw4_e5_rdis_n 0
rgw4_e5_rdis gw4_e5_vmd rgw4_e5_rdis_n 220000
ngw4_e5_rp gw4_e5_rt gw4_e5_qb vdd vsrc pch W=2e-06 L=1e-06
rgw4_e5_rrc gw4_e5_rt gw4_e5_rec 10000
cgw4_e5_rc gw4_e5_rec 0 1e-07
rgw4_e5_rr gw4_e5_rec 0 8.2e+06
ngw4_e5_sh1 gw4_e5_vm gw4_e5_rec gw4_e5_vms 0 nch W=2e-06 L=1e-06
va_ngw4_e5_sh2_s vrest ngw4_e5_sh2_s 0
ngw4_e5_sh2 gw4_e5_vms gw4_e5_qb ngw4_e5_sh2_s 0 nch W=2e-06 L=1e-06
ngw4_e5_porh gw4_e5_h por_hold vthe 0 nch W=2e-06 L=1e-06
va_ngw4_e5_porm_s vrest ngw4_e5_porm_s 0
ngw4_e5_porm gw4_e5_vm por_hold ngw4_e5_porm_s 0 nch W=2e-06 L=1e-06
ngw4_e5_ip gw4_e5_vm s4_ya vdd vsrc pch W=4e-06 L=4e-06
ngw4_e5_in gw4_e5_vm s4_zb 0 0 nch W=4e-06 L=4e-06
ngw4_b5_sw gw4_b5_t gw4_e5_qb vdd vsrc pch W=2e-06 L=1e-06
rgw4_b5_rc gw4_b5_t gw4_b5 10000
cgw4_b5_c gw4_b5 0 1e-07
rgw4_b5_rl gw4_b5 0 2.2e+07
ngw4_b5_sh1p gw4_b5_n gw4_b5 vdd vsrc pch W=2.4e-06 L=5e-07
ngw4_b5_sh1n gw4_b5_n gw4_b5 0 0 nch W=1.2e-06 L=5e-07
ngw4_b5_sh2p gw4_b5_q gw4_b5_n vdd vsrc pch W=2.4e-06 L=5e-07
ngw4_b5_sh2n gw4_b5_q gw4_b5_n 0 0 nch W=1.2e-06 L=5e-07
cgw4_e6_cm gw4_e6_vm 0 1e-07
va_rgw4_e6_rm_n vrest rgw4_e6_rm_n 0
rgw4_e6_rm gw4_e6_vm rgw4_e6_rm_n 1e+06
ngw4_e6_bias0 gw4_e6_vm istep_n 0 0 nch W=4e-06 L=4e-06
ngw4_e6_bias1 gw4_e6_vm istep_n 0 0 nch W=4e-06 L=4e-06
ngw4_e6_bias2 gw4_e6_vm istep_n 0 0 nch W=4e-06 L=4e-06
ngw4_e6_bias3 gw4_e6_vm istep_n 0 0 nch W=4e-06 L=4e-06
ngw4_e6_bias4 gw4_e6_vm istep_n 0 0 nch W=4e-06 L=4e-06
ngw4_e6_bias5 gw4_e6_vm istep_n 0 0 nch W=4e-06 L=4e-06
rgw4_e6_kb vdd gw4_e6_knb 1e+06
ngw4_e6_kmb gw4_e6_knb gw4_e6_knb 0 0 nch W=4e-06 L=4e-06
ngw4_e6_kmt gw4_e6_ktail gw4_e6_knb 0 0 nch W=4e-06 L=4e-06
ngw4_e6_km1 gw4_e6_kd1 gw4_e6_vm gw4_e6_ktail 0 nch W=4e-06 L=4e-06
ngw4_e6_km2 gw4_e6_ko1 gw4_e6_h gw4_e6_ktail 0 nch W=4e-06 L=4e-06
ngw4_e6_km3 gw4_e6_kd1 gw4_e6_kd1 vdd vsrc pch W=4e-06 L=4e-06
ngw4_e6_km4 gw4_e6_ko1 gw4_e6_kd1 vdd vsrc pch W=4e-06 L=4e-06
ngw4_e6_kporclamp gw4_e6_ko1 por_hold 0 0 nch W=4e-06 L=1e-06
ngw4_e6_ki1p gw4_e6_qb gw4_e6_ko1 vdd vsrc pch W=2.4e-06 L=5e-07
ngw4_e6_ki1n gw4_e6_qb gw4_e6_ko1 0 0 nch W=1.2e-06 L=5e-07
ngw4_e6_ki2p gw4_e6_q gw4_e6_qb vdd vsrc pch W=2.4e-06 L=5e-07
ngw4_e6_ki2n gw4_e6_q gw4_e6_qb 0 0 nch W=1.2e-06 L=5e-07
rgw4_e6_hra gw4_e6_h vthe 1e+06
rgw4_e6_hrf gw4_e6_h gw4_e6_qb 1.9e+07
cgw4_e6_hc gw4_e6_h 0 2.1e-09
ngw4_e6_dis gw4_e6_vm gw4_e6_q gw4_e6_vmd 0 nch W=4e-06 L=1e-06
va_rgw4_e6_rdis_n vrest rgw4_e6_rdis_n 0
rgw4_e6_rdis gw4_e6_vmd rgw4_e6_rdis_n 220000
ngw4_e6_rp gw4_e6_rt gw4_e6_qb vdd vsrc pch W=2e-06 L=1e-06
rgw4_e6_rrc gw4_e6_rt gw4_e6_rec 10000
cgw4_e6_rc gw4_e6_rec 0 1e-07
rgw4_e6_rr gw4_e6_rec 0 8.2e+06
ngw4_e6_sh1 gw4_e6_vm gw4_e6_rec gw4_e6_vms 0 nch W=2e-06 L=1e-06
va_ngw4_e6_sh2_s vrest ngw4_e6_sh2_s 0
ngw4_e6_sh2 gw4_e6_vms gw4_e6_qb ngw4_e6_sh2_s 0 nch W=2e-06 L=1e-06
ngw4_e6_porh gw4_e6_h por_hold vthe 0 nch W=2e-06 L=1e-06
va_ngw4_e6_porm_s vrest ngw4_e6_porm_s 0
ngw4_e6_porm gw4_e6_vm por_hold ngw4_e6_porm_s 0 nch W=2e-06 L=1e-06
ngw4_e6_ip gw4_e6_vm s4_ya vdd vsrc pch W=4e-06 L=4e-06
ngw4_e6_in gw4_e6_vm s4_zb 0 0 nch W=4e-06 L=4e-06
ngw4_b6_sw gw4_b6_t gw4_e6_qb vdd vsrc pch W=2e-06 L=1e-06
rgw4_b6_rc gw4_b6_t gw4_b6 10000
cgw4_b6_c gw4_b6 0 1e-07
rgw4_b6_rl gw4_b6 0 2.2e+07
ngw4_b6_sh1p gw4_b6_n gw4_b6 vdd vsrc pch W=2.4e-06 L=5e-07
ngw4_b6_sh1n gw4_b6_n gw4_b6 0 0 nch W=1.2e-06 L=5e-07
ngw4_b6_sh2p gw4_b6_q gw4_b6_n vdd vsrc pch W=2.4e-06 L=5e-07
ngw4_b6_sh2n gw4_b6_q gw4_b6_n 0 0 nch W=1.2e-06 L=5e-07
cgw4_e7_cm gw4_e7_vm 0 1e-07
va_rgw4_e7_rm_n vrest rgw4_e7_rm_n 0
rgw4_e7_rm gw4_e7_vm rgw4_e7_rm_n 1e+06
ngw4_e7_bias0 gw4_e7_vm istep_n 0 0 nch W=4e-06 L=4e-06
ngw4_e7_bias1 gw4_e7_vm istep_n 0 0 nch W=4e-06 L=4e-06
ngw4_e7_bias2 gw4_e7_vm istep_n 0 0 nch W=4e-06 L=4e-06
ngw4_e7_bias3 gw4_e7_vm istep_n 0 0 nch W=4e-06 L=4e-06
ngw4_e7_bias4 gw4_e7_vm istep_n 0 0 nch W=4e-06 L=4e-06
ngw4_e7_bias5 gw4_e7_vm istep_n 0 0 nch W=4e-06 L=4e-06
ngw4_e7_bias6 gw4_e7_vm istep_n 0 0 nch W=4e-06 L=4e-06
rgw4_e7_kb vdd gw4_e7_knb 1e+06
ngw4_e7_kmb gw4_e7_knb gw4_e7_knb 0 0 nch W=4e-06 L=4e-06
ngw4_e7_kmt gw4_e7_ktail gw4_e7_knb 0 0 nch W=4e-06 L=4e-06
ngw4_e7_km1 gw4_e7_kd1 gw4_e7_vm gw4_e7_ktail 0 nch W=4e-06 L=4e-06
ngw4_e7_km2 gw4_e7_ko1 gw4_e7_h gw4_e7_ktail 0 nch W=4e-06 L=4e-06
ngw4_e7_km3 gw4_e7_kd1 gw4_e7_kd1 vdd vsrc pch W=4e-06 L=4e-06
ngw4_e7_km4 gw4_e7_ko1 gw4_e7_kd1 vdd vsrc pch W=4e-06 L=4e-06
ngw4_e7_kporclamp gw4_e7_ko1 por_hold 0 0 nch W=4e-06 L=1e-06
ngw4_e7_ki1p gw4_e7_qb gw4_e7_ko1 vdd vsrc pch W=2.4e-06 L=5e-07
ngw4_e7_ki1n gw4_e7_qb gw4_e7_ko1 0 0 nch W=1.2e-06 L=5e-07
ngw4_e7_ki2p gw4_e7_q gw4_e7_qb vdd vsrc pch W=2.4e-06 L=5e-07
ngw4_e7_ki2n gw4_e7_q gw4_e7_qb 0 0 nch W=1.2e-06 L=5e-07
rgw4_e7_hra gw4_e7_h vthe 1e+06
rgw4_e7_hrf gw4_e7_h gw4_e7_qb 1.9e+07
cgw4_e7_hc gw4_e7_h 0 2.1e-09
ngw4_e7_dis gw4_e7_vm gw4_e7_q gw4_e7_vmd 0 nch W=4e-06 L=1e-06
va_rgw4_e7_rdis_n vrest rgw4_e7_rdis_n 0
rgw4_e7_rdis gw4_e7_vmd rgw4_e7_rdis_n 220000
ngw4_e7_rp gw4_e7_rt gw4_e7_qb vdd vsrc pch W=2e-06 L=1e-06
rgw4_e7_rrc gw4_e7_rt gw4_e7_rec 10000
cgw4_e7_rc gw4_e7_rec 0 1e-07
rgw4_e7_rr gw4_e7_rec 0 8.2e+06
ngw4_e7_sh1 gw4_e7_vm gw4_e7_rec gw4_e7_vms 0 nch W=2e-06 L=1e-06
va_ngw4_e7_sh2_s vrest ngw4_e7_sh2_s 0
ngw4_e7_sh2 gw4_e7_vms gw4_e7_qb ngw4_e7_sh2_s 0 nch W=2e-06 L=1e-06
ngw4_e7_porh gw4_e7_h por_hold vthe 0 nch W=2e-06 L=1e-06
va_ngw4_e7_porm_s vrest ngw4_e7_porm_s 0
ngw4_e7_porm gw4_e7_vm por_hold ngw4_e7_porm_s 0 nch W=2e-06 L=1e-06
ngw4_e7_ip gw4_e7_vm s4_ya vdd vsrc pch W=4e-06 L=4e-06
ngw4_e7_in gw4_e7_vm s4_zb 0 0 nch W=4e-06 L=4e-06
ngw4_b7_sw gw4_b7_t gw4_e7_qb vdd vsrc pch W=2e-06 L=1e-06
rgw4_b7_rc gw4_b7_t gw4_b7 10000
cgw4_b7_c gw4_b7 0 1e-07
rgw4_b7_rl gw4_b7 0 2.2e+07
ngw4_b7_sh1p gw4_b7_n gw4_b7 vdd vsrc pch W=2.4e-06 L=5e-07
ngw4_b7_sh1n gw4_b7_n gw4_b7 0 0 nch W=1.2e-06 L=5e-07
ngw4_b7_sh2p gw4_b7_q gw4_b7_n vdd vsrc pch W=2.4e-06 L=5e-07
ngw4_b7_sh2n gw4_b7_q gw4_b7_n 0 0 nch W=1.2e-06 L=5e-07
cgw4_e8_cm gw4_e8_vm 0 1e-07
va_rgw4_e8_rm_n vrest rgw4_e8_rm_n 0
rgw4_e8_rm gw4_e8_vm rgw4_e8_rm_n 1e+06
ngw4_e8_bias0 gw4_e8_vm istep_n 0 0 nch W=4e-06 L=4e-06
ngw4_e8_bias1 gw4_e8_vm istep_n 0 0 nch W=4e-06 L=4e-06
ngw4_e8_bias2 gw4_e8_vm istep_n 0 0 nch W=4e-06 L=4e-06
ngw4_e8_bias3 gw4_e8_vm istep_n 0 0 nch W=4e-06 L=4e-06
ngw4_e8_bias4 gw4_e8_vm istep_n 0 0 nch W=4e-06 L=4e-06
ngw4_e8_bias5 gw4_e8_vm istep_n 0 0 nch W=4e-06 L=4e-06
ngw4_e8_bias6 gw4_e8_vm istep_n 0 0 nch W=4e-06 L=4e-06
ngw4_e8_bias7 gw4_e8_vm istep_n 0 0 nch W=4e-06 L=4e-06
rgw4_e8_kb vdd gw4_e8_knb 1e+06
ngw4_e8_kmb gw4_e8_knb gw4_e8_knb 0 0 nch W=4e-06 L=4e-06
ngw4_e8_kmt gw4_e8_ktail gw4_e8_knb 0 0 nch W=4e-06 L=4e-06
ngw4_e8_km1 gw4_e8_kd1 gw4_e8_vm gw4_e8_ktail 0 nch W=4e-06 L=4e-06
ngw4_e8_km2 gw4_e8_ko1 gw4_e8_h gw4_e8_ktail 0 nch W=4e-06 L=4e-06
ngw4_e8_km3 gw4_e8_kd1 gw4_e8_kd1 vdd vsrc pch W=4e-06 L=4e-06
ngw4_e8_km4 gw4_e8_ko1 gw4_e8_kd1 vdd vsrc pch W=4e-06 L=4e-06
ngw4_e8_kporclamp gw4_e8_ko1 por_hold 0 0 nch W=4e-06 L=1e-06
ngw4_e8_ki1p gw4_e8_qb gw4_e8_ko1 vdd vsrc pch W=2.4e-06 L=5e-07
ngw4_e8_ki1n gw4_e8_qb gw4_e8_ko1 0 0 nch W=1.2e-06 L=5e-07
ngw4_e8_ki2p gw4_e8_q gw4_e8_qb vdd vsrc pch W=2.4e-06 L=5e-07
ngw4_e8_ki2n gw4_e8_q gw4_e8_qb 0 0 nch W=1.2e-06 L=5e-07
rgw4_e8_hra gw4_e8_h vthe 1e+06
rgw4_e8_hrf gw4_e8_h gw4_e8_qb 1.9e+07
cgw4_e8_hc gw4_e8_h 0 2.1e-09
ngw4_e8_dis gw4_e8_vm gw4_e8_q gw4_e8_vmd 0 nch W=4e-06 L=1e-06
va_rgw4_e8_rdis_n vrest rgw4_e8_rdis_n 0
rgw4_e8_rdis gw4_e8_vmd rgw4_e8_rdis_n 220000
ngw4_e8_rp gw4_e8_rt gw4_e8_qb vdd vsrc pch W=2e-06 L=1e-06
rgw4_e8_rrc gw4_e8_rt gw4_e8_rec 10000
cgw4_e8_rc gw4_e8_rec 0 1e-07
rgw4_e8_rr gw4_e8_rec 0 8.2e+06
ngw4_e8_sh1 gw4_e8_vm gw4_e8_rec gw4_e8_vms 0 nch W=2e-06 L=1e-06
va_ngw4_e8_sh2_s vrest ngw4_e8_sh2_s 0
ngw4_e8_sh2 gw4_e8_vms gw4_e8_qb ngw4_e8_sh2_s 0 nch W=2e-06 L=1e-06
ngw4_e8_porh gw4_e8_h por_hold vthe 0 nch W=2e-06 L=1e-06
va_ngw4_e8_porm_s vrest ngw4_e8_porm_s 0
ngw4_e8_porm gw4_e8_vm por_hold ngw4_e8_porm_s 0 nch W=2e-06 L=1e-06
ngw4_e8_ip gw4_e8_vm s4_ya vdd vsrc pch W=4e-06 L=4e-06
ngw4_e8_in gw4_e8_vm s4_zb 0 0 nch W=4e-06 L=4e-06
ngw4_b8_sw gw4_b8_t gw4_e8_qb vdd vsrc pch W=2e-06 L=1e-06
rgw4_b8_rc gw4_b8_t gw4_b8 10000
cgw4_b8_c gw4_b8 0 1e-07
rgw4_b8_rl gw4_b8 0 2.2e+07
ngw4_b8_sh1p gw4_b8_n gw4_b8 vdd vsrc pch W=2.4e-06 L=5e-07
ngw4_b8_sh1n gw4_b8_n gw4_b8 0 0 nch W=1.2e-06 L=5e-07
ngw4_b8_sh2p gw4_b8_q gw4_b8_n vdd vsrc pch W=2.4e-06 L=5e-07
ngw4_b8_sh2n gw4_b8_q gw4_b8_n 0 0 nch W=1.2e-06 L=5e-07
cgw4_e9_cm gw4_e9_vm 0 1e-07
va_rgw4_e9_rm_n vrest rgw4_e9_rm_n 0
rgw4_e9_rm gw4_e9_vm rgw4_e9_rm_n 1e+06
ngw4_e9_bias0 gw4_e9_vm istep_n 0 0 nch W=4e-06 L=4e-06
ngw4_e9_bias1 gw4_e9_vm istep_n 0 0 nch W=4e-06 L=4e-06
ngw4_e9_bias2 gw4_e9_vm istep_n 0 0 nch W=4e-06 L=4e-06
ngw4_e9_bias3 gw4_e9_vm istep_n 0 0 nch W=4e-06 L=4e-06
ngw4_e9_bias4 gw4_e9_vm istep_n 0 0 nch W=4e-06 L=4e-06
ngw4_e9_bias5 gw4_e9_vm istep_n 0 0 nch W=4e-06 L=4e-06
ngw4_e9_bias6 gw4_e9_vm istep_n 0 0 nch W=4e-06 L=4e-06
ngw4_e9_bias7 gw4_e9_vm istep_n 0 0 nch W=4e-06 L=4e-06
ngw4_e9_bias8 gw4_e9_vm istep_n 0 0 nch W=4e-06 L=4e-06
rgw4_e9_kb vdd gw4_e9_knb 1e+06
ngw4_e9_kmb gw4_e9_knb gw4_e9_knb 0 0 nch W=4e-06 L=4e-06
ngw4_e9_kmt gw4_e9_ktail gw4_e9_knb 0 0 nch W=4e-06 L=4e-06
ngw4_e9_km1 gw4_e9_kd1 gw4_e9_vm gw4_e9_ktail 0 nch W=4e-06 L=4e-06
ngw4_e9_km2 gw4_e9_ko1 gw4_e9_h gw4_e9_ktail 0 nch W=4e-06 L=4e-06
ngw4_e9_km3 gw4_e9_kd1 gw4_e9_kd1 vdd vsrc pch W=4e-06 L=4e-06
ngw4_e9_km4 gw4_e9_ko1 gw4_e9_kd1 vdd vsrc pch W=4e-06 L=4e-06
ngw4_e9_kporclamp gw4_e9_ko1 por_hold 0 0 nch W=4e-06 L=1e-06
ngw4_e9_ki1p gw4_e9_qb gw4_e9_ko1 vdd vsrc pch W=2.4e-06 L=5e-07
ngw4_e9_ki1n gw4_e9_qb gw4_e9_ko1 0 0 nch W=1.2e-06 L=5e-07
ngw4_e9_ki2p gw4_e9_q gw4_e9_qb vdd vsrc pch W=2.4e-06 L=5e-07
ngw4_e9_ki2n gw4_e9_q gw4_e9_qb 0 0 nch W=1.2e-06 L=5e-07
rgw4_e9_hra gw4_e9_h vthe 1e+06
rgw4_e9_hrf gw4_e9_h gw4_e9_qb 1.9e+07
cgw4_e9_hc gw4_e9_h 0 2.1e-09
ngw4_e9_dis gw4_e9_vm gw4_e9_q gw4_e9_vmd 0 nch W=4e-06 L=1e-06
va_rgw4_e9_rdis_n vrest rgw4_e9_rdis_n 0
rgw4_e9_rdis gw4_e9_vmd rgw4_e9_rdis_n 220000
ngw4_e9_rp gw4_e9_rt gw4_e9_qb vdd vsrc pch W=2e-06 L=1e-06
rgw4_e9_rrc gw4_e9_rt gw4_e9_rec 10000
cgw4_e9_rc gw4_e9_rec 0 1e-07
rgw4_e9_rr gw4_e9_rec 0 8.2e+06
ngw4_e9_sh1 gw4_e9_vm gw4_e9_rec gw4_e9_vms 0 nch W=2e-06 L=1e-06
va_ngw4_e9_sh2_s vrest ngw4_e9_sh2_s 0
ngw4_e9_sh2 gw4_e9_vms gw4_e9_qb ngw4_e9_sh2_s 0 nch W=2e-06 L=1e-06
ngw4_e9_porh gw4_e9_h por_hold vthe 0 nch W=2e-06 L=1e-06
va_ngw4_e9_porm_s vrest ngw4_e9_porm_s 0
ngw4_e9_porm gw4_e9_vm por_hold ngw4_e9_porm_s 0 nch W=2e-06 L=1e-06
ngw4_e9_ip gw4_e9_vm s4_ya vdd vsrc pch W=4e-06 L=4e-06
ngw4_e9_in gw4_e9_vm s4_zb 0 0 nch W=4e-06 L=4e-06
ngw4_b9_sw gw4_b9_t gw4_e9_qb vdd vsrc pch W=2e-06 L=1e-06
rgw4_b9_rc gw4_b9_t gw4_b9 10000
cgw4_b9_c gw4_b9 0 1e-07
rgw4_b9_rl gw4_b9 0 2.2e+07
ngw4_b9_sh1p gw4_b9_n gw4_b9 vdd vsrc pch W=2.4e-06 L=5e-07
ngw4_b9_sh1n gw4_b9_n gw4_b9 0 0 nch W=1.2e-06 L=5e-07
ngw4_b9_sh2p gw4_b9_q gw4_b9_n vdd vsrc pch W=2.4e-06 L=5e-07
ngw4_b9_sh2n gw4_b9_q gw4_b9_n 0 0 nch W=1.2e-06 L=5e-07
cgw4_e10_cm gw4_e10_vm 0 1e-07
va_rgw4_e10_rm_n vrest rgw4_e10_rm_n 0
rgw4_e10_rm gw4_e10_vm rgw4_e10_rm_n 1e+06
ngw4_e10_bias0 gw4_e10_vm istep_n 0 0 nch W=4e-06 L=4e-06
ngw4_e10_bias1 gw4_e10_vm istep_n 0 0 nch W=4e-06 L=4e-06
ngw4_e10_bias2 gw4_e10_vm istep_n 0 0 nch W=4e-06 L=4e-06
ngw4_e10_bias3 gw4_e10_vm istep_n 0 0 nch W=4e-06 L=4e-06
ngw4_e10_bias4 gw4_e10_vm istep_n 0 0 nch W=4e-06 L=4e-06
ngw4_e10_bias5 gw4_e10_vm istep_n 0 0 nch W=4e-06 L=4e-06
ngw4_e10_bias6 gw4_e10_vm istep_n 0 0 nch W=4e-06 L=4e-06
ngw4_e10_bias7 gw4_e10_vm istep_n 0 0 nch W=4e-06 L=4e-06
ngw4_e10_bias8 gw4_e10_vm istep_n 0 0 nch W=4e-06 L=4e-06
ngw4_e10_bias9 gw4_e10_vm istep_n 0 0 nch W=4e-06 L=4e-06
rgw4_e10_kb vdd gw4_e10_knb 1e+06
ngw4_e10_kmb gw4_e10_knb gw4_e10_knb 0 0 nch W=4e-06 L=4e-06
ngw4_e10_kmt gw4_e10_ktail gw4_e10_knb 0 0 nch W=4e-06 L=4e-06
ngw4_e10_km1 gw4_e10_kd1 gw4_e10_vm gw4_e10_ktail 0 nch W=4e-06 L=4e-06
ngw4_e10_km2 gw4_e10_ko1 gw4_e10_h gw4_e10_ktail 0 nch W=4e-06 L=4e-06
ngw4_e10_km3 gw4_e10_kd1 gw4_e10_kd1 vdd vsrc pch W=4e-06 L=4e-06
ngw4_e10_km4 gw4_e10_ko1 gw4_e10_kd1 vdd vsrc pch W=4e-06 L=4e-06
ngw4_e10_kporclamp gw4_e10_ko1 por_hold 0 0 nch W=4e-06 L=1e-06
ngw4_e10_ki1p gw4_e10_qb gw4_e10_ko1 vdd vsrc pch W=2.4e-06 L=5e-07
ngw4_e10_ki1n gw4_e10_qb gw4_e10_ko1 0 0 nch W=1.2e-06 L=5e-07
ngw4_e10_ki2p gw4_e10_q gw4_e10_qb vdd vsrc pch W=2.4e-06 L=5e-07
ngw4_e10_ki2n gw4_e10_q gw4_e10_qb 0 0 nch W=1.2e-06 L=5e-07
rgw4_e10_hra gw4_e10_h vthe 1e+06
rgw4_e10_hrf gw4_e10_h gw4_e10_qb 1.9e+07
cgw4_e10_hc gw4_e10_h 0 2.1e-09
ngw4_e10_dis gw4_e10_vm gw4_e10_q gw4_e10_vmd 0 nch W=4e-06 L=1e-06
va_rgw4_e10_rdis_n vrest rgw4_e10_rdis_n 0
rgw4_e10_rdis gw4_e10_vmd rgw4_e10_rdis_n 220000
ngw4_e10_rp gw4_e10_rt gw4_e10_qb vdd vsrc pch W=2e-06 L=1e-06
rgw4_e10_rrc gw4_e10_rt gw4_e10_rec 10000
cgw4_e10_rc gw4_e10_rec 0 1e-07
rgw4_e10_rr gw4_e10_rec 0 8.2e+06
ngw4_e10_sh1 gw4_e10_vm gw4_e10_rec gw4_e10_vms 0 nch W=2e-06 L=1e-06
va_ngw4_e10_sh2_s vrest ngw4_e10_sh2_s 0
ngw4_e10_sh2 gw4_e10_vms gw4_e10_qb ngw4_e10_sh2_s 0 nch W=2e-06 L=1e-06
ngw4_e10_porh gw4_e10_h por_hold vthe 0 nch W=2e-06 L=1e-06
va_ngw4_e10_porm_s vrest ngw4_e10_porm_s 0
ngw4_e10_porm gw4_e10_vm por_hold ngw4_e10_porm_s 0 nch W=2e-06 L=1e-06
ngw4_e10_ip gw4_e10_vm s4_ya vdd vsrc pch W=4e-06 L=4e-06
ngw4_e10_in gw4_e10_vm s4_zb 0 0 nch W=4e-06 L=4e-06
ngw4_b10_sw gw4_b10_t gw4_e10_qb vdd vsrc pch W=2e-06 L=1e-06
rgw4_b10_rc gw4_b10_t gw4_b10 10000
cgw4_b10_c gw4_b10 0 1e-07
rgw4_b10_rl gw4_b10 0 2.2e+07
ngw4_b10_sh1p gw4_b10_n gw4_b10 vdd vsrc pch W=2.4e-06 L=5e-07
ngw4_b10_sh1n gw4_b10_n gw4_b10 0 0 nch W=1.2e-06 L=5e-07
ngw4_b10_sh2p gw4_b10_q gw4_b10_n vdd vsrc pch W=2.4e-06 L=5e-07
ngw4_b10_sh2n gw4_b10_q gw4_b10_n 0 0 nch W=1.2e-06 L=5e-07
ngw4_and_a0_npa gw4_and_a0_nb gw4_b1_q vdd vsrc pch W=2.4e-06 L=5e-07
ngw4_and_a0_npb gw4_and_a0_nb gw4_b2_q vdd vsrc pch W=2.4e-06 L=5e-07
ngw4_and_a0_nna gw4_and_a0_nb gw4_b1_q gw4_and_a0_nx 0 nch W=2.4e-06 L=5e-07
ngw4_and_a0_nnb gw4_and_a0_nx gw4_b2_q 0 0 nch W=2.4e-06 L=5e-07
ngw4_and_a0_ip gw4_and_g0 gw4_and_a0_nb vdd vsrc pch W=2.4e-06 L=5e-07
ngw4_and_a0_in gw4_and_g0 gw4_and_a0_nb 0 0 nch W=1.2e-06 L=5e-07
ngw4_and_a1_npa gw4_and_a1_nb gw4_b3_q vdd vsrc pch W=2.4e-06 L=5e-07
ngw4_and_a1_npb gw4_and_a1_nb gw4_b4_q vdd vsrc pch W=2.4e-06 L=5e-07
ngw4_and_a1_nna gw4_and_a1_nb gw4_b3_q gw4_and_a1_nx 0 nch W=2.4e-06 L=5e-07
ngw4_and_a1_nnb gw4_and_a1_nx gw4_b4_q 0 0 nch W=2.4e-06 L=5e-07
ngw4_and_a1_ip gw4_and_g1 gw4_and_a1_nb vdd vsrc pch W=2.4e-06 L=5e-07
ngw4_and_a1_in gw4_and_g1 gw4_and_a1_nb 0 0 nch W=1.2e-06 L=5e-07
ngw4_and_a2_npa gw4_and_a2_nb gw4_b5_q vdd vsrc pch W=2.4e-06 L=5e-07
ngw4_and_a2_npb gw4_and_a2_nb gw4_b6_q vdd vsrc pch W=2.4e-06 L=5e-07
ngw4_and_a2_nna gw4_and_a2_nb gw4_b5_q gw4_and_a2_nx 0 nch W=2.4e-06 L=5e-07
ngw4_and_a2_nnb gw4_and_a2_nx gw4_b6_q 0 0 nch W=2.4e-06 L=5e-07
ngw4_and_a2_ip gw4_and_g2 gw4_and_a2_nb vdd vsrc pch W=2.4e-06 L=5e-07
ngw4_and_a2_in gw4_and_g2 gw4_and_a2_nb 0 0 nch W=1.2e-06 L=5e-07
ngw4_and_a3_npa gw4_and_a3_nb gw4_b7_q vdd vsrc pch W=2.4e-06 L=5e-07
ngw4_and_a3_npb gw4_and_a3_nb gw4_b8_q vdd vsrc pch W=2.4e-06 L=5e-07
ngw4_and_a3_nna gw4_and_a3_nb gw4_b7_q gw4_and_a3_nx 0 nch W=2.4e-06 L=5e-07
ngw4_and_a3_nnb gw4_and_a3_nx gw4_b8_q 0 0 nch W=2.4e-06 L=5e-07
ngw4_and_a3_ip gw4_and_g3 gw4_and_a3_nb vdd vsrc pch W=2.4e-06 L=5e-07
ngw4_and_a3_in gw4_and_g3 gw4_and_a3_nb 0 0 nch W=1.2e-06 L=5e-07
ngw4_and_a4_npa gw4_and_a4_nb gw4_b9_q vdd vsrc pch W=2.4e-06 L=5e-07
ngw4_and_a4_npb gw4_and_a4_nb gw4_b10_q vdd vsrc pch W=2.4e-06 L=5e-07
ngw4_and_a4_nna gw4_and_a4_nb gw4_b9_q gw4_and_a4_nx 0 nch W=2.4e-06 L=5e-07
ngw4_and_a4_nnb gw4_and_a4_nx gw4_b10_q 0 0 nch W=2.4e-06 L=5e-07
ngw4_and_a4_ip gw4_and_g4 gw4_and_a4_nb vdd vsrc pch W=2.4e-06 L=5e-07
ngw4_and_a4_in gw4_and_g4 gw4_and_a4_nb 0 0 nch W=1.2e-06 L=5e-07
ngw4_and_a5_npa gw4_and_a5_nb gw4_and_g0 vdd vsrc pch W=2.4e-06 L=5e-07
ngw4_and_a5_npb gw4_and_a5_nb gw4_and_g1 vdd vsrc pch W=2.4e-06 L=5e-07
ngw4_and_a5_nna gw4_and_a5_nb gw4_and_g0 gw4_and_a5_nx 0 nch W=2.4e-06 L=5e-07
ngw4_and_a5_nnb gw4_and_a5_nx gw4_and_g1 0 0 nch W=2.4e-06 L=5e-07
ngw4_and_a5_ip gw4_and_g5 gw4_and_a5_nb vdd vsrc pch W=2.4e-06 L=5e-07
ngw4_and_a5_in gw4_and_g5 gw4_and_a5_nb 0 0 nch W=1.2e-06 L=5e-07
ngw4_and_a6_npa gw4_and_a6_nb gw4_and_g2 vdd vsrc pch W=2.4e-06 L=5e-07
ngw4_and_a6_npb gw4_and_a6_nb gw4_and_g3 vdd vsrc pch W=2.4e-06 L=5e-07
ngw4_and_a6_nna gw4_and_a6_nb gw4_and_g2 gw4_and_a6_nx 0 nch W=2.4e-06 L=5e-07
ngw4_and_a6_nnb gw4_and_a6_nx gw4_and_g3 0 0 nch W=2.4e-06 L=5e-07
ngw4_and_a6_ip gw4_and_g6 gw4_and_a6_nb vdd vsrc pch W=2.4e-06 L=5e-07
ngw4_and_a6_in gw4_and_g6 gw4_and_a6_nb 0 0 nch W=1.2e-06 L=5e-07
ngw4_and_a7_npa gw4_and_a7_nb gw4_and_g5 vdd vsrc pch W=2.4e-06 L=5e-07
ngw4_and_a7_npb gw4_and_a7_nb gw4_and_g6 vdd vsrc pch W=2.4e-06 L=5e-07
ngw4_and_a7_nna gw4_and_a7_nb gw4_and_g5 gw4_and_a7_nx 0 nch W=2.4e-06 L=5e-07
ngw4_and_a7_nnb gw4_and_a7_nx gw4_and_g6 0 0 nch W=2.4e-06 L=5e-07
ngw4_and_a7_ip gw4_and_g7 gw4_and_a7_nb vdd vsrc pch W=2.4e-06 L=5e-07
ngw4_and_a7_in gw4_and_g7 gw4_and_a7_nb 0 0 nch W=1.2e-06 L=5e-07
ngw4_and_a8_npa gw4_and_a8_nb gw4_and_g7 vdd vsrc pch W=2.4e-06 L=5e-07
ngw4_and_a8_npb gw4_and_a8_nb gw4_and_g4 vdd vsrc pch W=2.4e-06 L=5e-07
ngw4_and_a8_nna gw4_and_a8_nb gw4_and_g7 gw4_and_a8_nx 0 nch W=2.4e-06 L=5e-07
ngw4_and_a8_nnb gw4_and_a8_nx gw4_and_g4 0 0 nch W=2.4e-06 L=5e-07
ngw4_and_a8_ip gw4_and_g8 gw4_and_a8_nb vdd vsrc pch W=2.4e-06 L=5e-07
ngw4_and_a8_in gw4_and_g8 gw4_and_a8_nb 0 0 nch W=1.2e-06 L=5e-07
ngw4_gip gw4_gb gw4_and_g8 vdd vsrc pch W=2.4e-06 L=5e-07
ngw4_gin gw4_gb gw4_and_g8 0 0 nch W=1.2e-06 L=5e-07
cgw4_col_cm gw4_col_vm 0 1e-07
va_rgw4_col_rm_n vrest rgw4_col_rm_n 0
rgw4_col_rm gw4_col_vm rgw4_col_rm_n 1e+06
rgw4_col_kb vdd gw4_col_knb 1e+06
ngw4_col_kmb gw4_col_knb gw4_col_knb 0 0 nch W=4e-06 L=4e-06
ngw4_col_kmt gw4_col_ktail gw4_col_knb 0 0 nch W=4e-06 L=4e-06
ngw4_col_km1 gw4_col_kd1 gw4_col_vm gw4_col_ktail 0 nch W=4e-06 L=4e-06
ngw4_col_km2 gw4_col_ko1 gw4_col_h gw4_col_ktail 0 nch W=4e-06 L=4e-06
ngw4_col_km3 gw4_col_kd1 gw4_col_kd1 vdd vsrc pch W=4e-06 L=4e-06
ngw4_col_km4 gw4_col_ko1 gw4_col_kd1 vdd vsrc pch W=4e-06 L=4e-06
ngw4_col_kporclamp gw4_col_ko1 por_hold 0 0 nch W=4e-06 L=1e-06
ngw4_col_ki1p gw4_col_qb gw4_col_ko1 vdd vsrc pch W=2.4e-06 L=5e-07
ngw4_col_ki1n gw4_col_qb gw4_col_ko1 0 0 nch W=1.2e-06 L=5e-07
ngw4_col_ki2p gw4_col_q gw4_col_qb vdd vsrc pch W=2.4e-06 L=5e-07
ngw4_col_ki2n gw4_col_q gw4_col_qb 0 0 nch W=1.2e-06 L=5e-07
rgw4_col_hra gw4_col_h vthe 1e+06
rgw4_col_hrf gw4_col_h gw4_col_qb 1.9e+07
cgw4_col_hc gw4_col_h 0 2.1e-09
ngw4_col_dis gw4_col_vm gw4_col_q gw4_col_vmd 0 nch W=4e-06 L=1e-06
va_rgw4_col_rdis_n vrest rgw4_col_rdis_n 0
rgw4_col_rdis gw4_col_vmd rgw4_col_rdis_n 220000
ngw4_col_rp gw4_col_rt gw4_col_qb vdd vsrc pch W=2e-06 L=1e-06
rgw4_col_rrc gw4_col_rt gw4_col_rec 10000
cgw4_col_rc gw4_col_rec 0 1e-07
rgw4_col_rr gw4_col_rec 0 8.2e+06
ngw4_col_sh1 gw4_col_vm gw4_col_rec gw4_col_vms 0 nch W=2e-06 L=1e-06
va_ngw4_col_sh2_s vrest ngw4_col_sh2_s 0
ngw4_col_sh2 gw4_col_vms gw4_col_qb ngw4_col_sh2_s 0 nch W=2e-06 L=1e-06
ngw4_col_porh gw4_col_h por_hold vthe 0 nch W=2e-06 L=1e-06
va_ngw4_col_porm_s vrest ngw4_col_porm_s 0
ngw4_col_porm gw4_col_vm por_hold ngw4_col_porm_s 0 nch W=2e-06 L=1e-06
ngw4_cin_eni_p gw4_cin_ena gw4_gb vdd vsrc pch W=2.4e-06 L=5e-07
ngw4_cin_eni_n gw4_cin_ena gw4_gb 0 0 nch W=1.2e-06 L=5e-07
ngw4_cin_cp gw4_col_vm gw4_cin_cg vdd vsrc pch W=4e-06 L=4e-06
ngw4_cin_bias ilimp_n gw4_gb gw4_cin_cg vsrc pch W=1.2e-06 L=1e-06
ngw4_cin_off gw4_cin_cg gw4_cin_ena vdd vsrc pch W=2.4e-06 L=1e-06
ngw4_op_tsw gw4_op_tt gw4_col_qb vdd vsrc pch W=2e-06 L=1e-06
rgw4_op_trc gw4_op_tt gw4_op_at 10000
cgw4_op_tc gw4_op_at 0 1e-07
rgw4_op_trl gw4_op_at 0 2.2e+07
ngw4_op_sh1p gw4_op_an gw4_op_at vdd vsrc pch W=2.4e-06 L=5e-07
ngw4_op_sh1n gw4_op_an gw4_op_at 0 0 nch W=1.2e-06 L=5e-07
ngw4_op_sh2p gw4_op_aq gw4_op_an vdd vsrc pch W=2.4e-06 L=5e-07
ngw4_op_sh2n gw4_op_aq gw4_op_an 0 0 nch W=1.2e-06 L=5e-07
ngw4_op_abp gw4_op_aqb gw4_op_aq vdd vsrc pch W=2.4e-06 L=5e-07
ngw4_op_abn gw4_op_aqb gw4_op_aq 0 0 nch W=1.2e-06 L=5e-07
rgw4_op_dr gw4_op_aq gw4_op_ad 1e+06
cgw4_op_dc gw4_op_ad 0 3.3e-07
ngw4_op_d2p gw4_op_adn gw4_op_ad vdd vsrc pch W=2.4e-06 L=5e-07
ngw4_op_d2n gw4_op_adn gw4_op_ad 0 0 nch W=1.2e-06 L=5e-07
ngw4_op_gpa gw4_op_pb gw4_op_aq vdd vsrc pch W=2.4e-06 L=5e-07
ngw4_op_gpb gw4_op_pb gw4_op_adn vdd vsrc pch W=2.4e-06 L=5e-07
ngw4_op_gna gw4_op_pb gw4_op_aq gw4_op_gx 0 nch W=2.4e-06 L=5e-07
ngw4_op_gnb gw4_op_gx gw4_op_adn 0 0 nch W=2.4e-06 L=5e-07
ngw4_op_op gw4_op_p gw4_op_pb vdd vsrc pch W=2.4e-06 L=5e-07
ngw4_op_on gw4_op_p gw4_op_pb 0 0 nch W=1.2e-06 L=5e-07
cgc4_e1_cm gc4_e1_vm 0 1e-07
va_rgc4_e1_rm_n vrest rgc4_e1_rm_n 0
rgc4_e1_rm gc4_e1_vm rgc4_e1_rm_n 1e+06
ngc4_e1_bias0 gc4_e1_vm istep_n 0 0 nch W=4e-06 L=4e-06
rgc4_e1_kb vdd gc4_e1_knb 1e+06
ngc4_e1_kmb gc4_e1_knb gc4_e1_knb 0 0 nch W=4e-06 L=4e-06
ngc4_e1_kmt gc4_e1_ktail gc4_e1_knb 0 0 nch W=4e-06 L=4e-06
ngc4_e1_km1 gc4_e1_kd1 gc4_e1_vm gc4_e1_ktail 0 nch W=4e-06 L=4e-06
ngc4_e1_km2 gc4_e1_ko1 gc4_e1_h gc4_e1_ktail 0 nch W=4e-06 L=4e-06
ngc4_e1_km3 gc4_e1_kd1 gc4_e1_kd1 vdd vsrc pch W=4e-06 L=4e-06
ngc4_e1_km4 gc4_e1_ko1 gc4_e1_kd1 vdd vsrc pch W=4e-06 L=4e-06
ngc4_e1_kporclamp gc4_e1_ko1 por_hold 0 0 nch W=4e-06 L=1e-06
ngc4_e1_ki1p gc4_e1_qb gc4_e1_ko1 vdd vsrc pch W=2.4e-06 L=5e-07
ngc4_e1_ki1n gc4_e1_qb gc4_e1_ko1 0 0 nch W=1.2e-06 L=5e-07
ngc4_e1_ki2p gc4_e1_q gc4_e1_qb vdd vsrc pch W=2.4e-06 L=5e-07
ngc4_e1_ki2n gc4_e1_q gc4_e1_qb 0 0 nch W=1.2e-06 L=5e-07
rgc4_e1_hra gc4_e1_h vthe 1e+06
rgc4_e1_hrf gc4_e1_h gc4_e1_qb 1.9e+07
cgc4_e1_hc gc4_e1_h 0 2.1e-09
ngc4_e1_dis gc4_e1_vm gc4_e1_q gc4_e1_vmd 0 nch W=4e-06 L=1e-06
va_rgc4_e1_rdis_n vrest rgc4_e1_rdis_n 0
rgc4_e1_rdis gc4_e1_vmd rgc4_e1_rdis_n 220000
ngc4_e1_rp gc4_e1_rt gc4_e1_qb vdd vsrc pch W=2e-06 L=1e-06
rgc4_e1_rrc gc4_e1_rt gc4_e1_rec 10000
cgc4_e1_rc gc4_e1_rec 0 1e-07
rgc4_e1_rr gc4_e1_rec 0 8.2e+06
ngc4_e1_sh1 gc4_e1_vm gc4_e1_rec gc4_e1_vms 0 nch W=2e-06 L=1e-06
va_ngc4_e1_sh2_s vrest ngc4_e1_sh2_s 0
ngc4_e1_sh2 gc4_e1_vms gc4_e1_qb ngc4_e1_sh2_s 0 nch W=2e-06 L=1e-06
ngc4_e1_porh gc4_e1_h por_hold vthe 0 nch W=2e-06 L=1e-06
va_ngc4_e1_porm_s vrest ngc4_e1_porm_s 0
ngc4_e1_porm gc4_e1_vm por_hold ngc4_e1_porm_s 0 nch W=2e-06 L=1e-06
ngc4_e1_ip gc4_e1_vm s4_yb vdd vsrc pch W=4e-06 L=4e-06
ngc4_e1_in gc4_e1_vm s4_za 0 0 nch W=4e-06 L=4e-06
ngc4_b1_sw gc4_b1_t gc4_e1_qb vdd vsrc pch W=2e-06 L=1e-06
rgc4_b1_rc gc4_b1_t gc4_b1 10000
cgc4_b1_c gc4_b1 0 1e-07
rgc4_b1_rl gc4_b1 0 2.2e+07
ngc4_b1_sh1p gc4_b1_n gc4_b1 vdd vsrc pch W=2.4e-06 L=5e-07
ngc4_b1_sh1n gc4_b1_n gc4_b1 0 0 nch W=1.2e-06 L=5e-07
ngc4_b1_sh2p gc4_b1_q gc4_b1_n vdd vsrc pch W=2.4e-06 L=5e-07
ngc4_b1_sh2n gc4_b1_q gc4_b1_n 0 0 nch W=1.2e-06 L=5e-07
cgc4_e2_cm gc4_e2_vm 0 1e-07
va_rgc4_e2_rm_n vrest rgc4_e2_rm_n 0
rgc4_e2_rm gc4_e2_vm rgc4_e2_rm_n 1e+06
ngc4_e2_bias0 gc4_e2_vm istep_n 0 0 nch W=4e-06 L=4e-06
ngc4_e2_bias1 gc4_e2_vm istep_n 0 0 nch W=4e-06 L=4e-06
rgc4_e2_kb vdd gc4_e2_knb 1e+06
ngc4_e2_kmb gc4_e2_knb gc4_e2_knb 0 0 nch W=4e-06 L=4e-06
ngc4_e2_kmt gc4_e2_ktail gc4_e2_knb 0 0 nch W=4e-06 L=4e-06
ngc4_e2_km1 gc4_e2_kd1 gc4_e2_vm gc4_e2_ktail 0 nch W=4e-06 L=4e-06
ngc4_e2_km2 gc4_e2_ko1 gc4_e2_h gc4_e2_ktail 0 nch W=4e-06 L=4e-06
ngc4_e2_km3 gc4_e2_kd1 gc4_e2_kd1 vdd vsrc pch W=4e-06 L=4e-06
ngc4_e2_km4 gc4_e2_ko1 gc4_e2_kd1 vdd vsrc pch W=4e-06 L=4e-06
ngc4_e2_kporclamp gc4_e2_ko1 por_hold 0 0 nch W=4e-06 L=1e-06
ngc4_e2_ki1p gc4_e2_qb gc4_e2_ko1 vdd vsrc pch W=2.4e-06 L=5e-07
ngc4_e2_ki1n gc4_e2_qb gc4_e2_ko1 0 0 nch W=1.2e-06 L=5e-07
ngc4_e2_ki2p gc4_e2_q gc4_e2_qb vdd vsrc pch W=2.4e-06 L=5e-07
ngc4_e2_ki2n gc4_e2_q gc4_e2_qb 0 0 nch W=1.2e-06 L=5e-07
rgc4_e2_hra gc4_e2_h vthe 1e+06
rgc4_e2_hrf gc4_e2_h gc4_e2_qb 1.9e+07
cgc4_e2_hc gc4_e2_h 0 2.1e-09
ngc4_e2_dis gc4_e2_vm gc4_e2_q gc4_e2_vmd 0 nch W=4e-06 L=1e-06
va_rgc4_e2_rdis_n vrest rgc4_e2_rdis_n 0
rgc4_e2_rdis gc4_e2_vmd rgc4_e2_rdis_n 220000
ngc4_e2_rp gc4_e2_rt gc4_e2_qb vdd vsrc pch W=2e-06 L=1e-06
rgc4_e2_rrc gc4_e2_rt gc4_e2_rec 10000
cgc4_e2_rc gc4_e2_rec 0 1e-07
rgc4_e2_rr gc4_e2_rec 0 8.2e+06
ngc4_e2_sh1 gc4_e2_vm gc4_e2_rec gc4_e2_vms 0 nch W=2e-06 L=1e-06
va_ngc4_e2_sh2_s vrest ngc4_e2_sh2_s 0
ngc4_e2_sh2 gc4_e2_vms gc4_e2_qb ngc4_e2_sh2_s 0 nch W=2e-06 L=1e-06
ngc4_e2_porh gc4_e2_h por_hold vthe 0 nch W=2e-06 L=1e-06
va_ngc4_e2_porm_s vrest ngc4_e2_porm_s 0
ngc4_e2_porm gc4_e2_vm por_hold ngc4_e2_porm_s 0 nch W=2e-06 L=1e-06
ngc4_e2_ip gc4_e2_vm s4_yb vdd vsrc pch W=4e-06 L=4e-06
ngc4_e2_in gc4_e2_vm s4_za 0 0 nch W=4e-06 L=4e-06
ngc4_b2_sw gc4_b2_t gc4_e2_qb vdd vsrc pch W=2e-06 L=1e-06
rgc4_b2_rc gc4_b2_t gc4_b2 10000
cgc4_b2_c gc4_b2 0 1e-07
rgc4_b2_rl gc4_b2 0 2.2e+07
ngc4_b2_sh1p gc4_b2_n gc4_b2 vdd vsrc pch W=2.4e-06 L=5e-07
ngc4_b2_sh1n gc4_b2_n gc4_b2 0 0 nch W=1.2e-06 L=5e-07
ngc4_b2_sh2p gc4_b2_q gc4_b2_n vdd vsrc pch W=2.4e-06 L=5e-07
ngc4_b2_sh2n gc4_b2_q gc4_b2_n 0 0 nch W=1.2e-06 L=5e-07
cgc4_e3_cm gc4_e3_vm 0 1e-07
va_rgc4_e3_rm_n vrest rgc4_e3_rm_n 0
rgc4_e3_rm gc4_e3_vm rgc4_e3_rm_n 1e+06
ngc4_e3_bias0 gc4_e3_vm istep_n 0 0 nch W=4e-06 L=4e-06
ngc4_e3_bias1 gc4_e3_vm istep_n 0 0 nch W=4e-06 L=4e-06
ngc4_e3_bias2 gc4_e3_vm istep_n 0 0 nch W=4e-06 L=4e-06
rgc4_e3_kb vdd gc4_e3_knb 1e+06
ngc4_e3_kmb gc4_e3_knb gc4_e3_knb 0 0 nch W=4e-06 L=4e-06
ngc4_e3_kmt gc4_e3_ktail gc4_e3_knb 0 0 nch W=4e-06 L=4e-06
ngc4_e3_km1 gc4_e3_kd1 gc4_e3_vm gc4_e3_ktail 0 nch W=4e-06 L=4e-06
ngc4_e3_km2 gc4_e3_ko1 gc4_e3_h gc4_e3_ktail 0 nch W=4e-06 L=4e-06
ngc4_e3_km3 gc4_e3_kd1 gc4_e3_kd1 vdd vsrc pch W=4e-06 L=4e-06
ngc4_e3_km4 gc4_e3_ko1 gc4_e3_kd1 vdd vsrc pch W=4e-06 L=4e-06
ngc4_e3_kporclamp gc4_e3_ko1 por_hold 0 0 nch W=4e-06 L=1e-06
ngc4_e3_ki1p gc4_e3_qb gc4_e3_ko1 vdd vsrc pch W=2.4e-06 L=5e-07
ngc4_e3_ki1n gc4_e3_qb gc4_e3_ko1 0 0 nch W=1.2e-06 L=5e-07
ngc4_e3_ki2p gc4_e3_q gc4_e3_qb vdd vsrc pch W=2.4e-06 L=5e-07
ngc4_e3_ki2n gc4_e3_q gc4_e3_qb 0 0 nch W=1.2e-06 L=5e-07
rgc4_e3_hra gc4_e3_h vthe 1e+06
rgc4_e3_hrf gc4_e3_h gc4_e3_qb 1.9e+07
cgc4_e3_hc gc4_e3_h 0 2.1e-09
ngc4_e3_dis gc4_e3_vm gc4_e3_q gc4_e3_vmd 0 nch W=4e-06 L=1e-06
va_rgc4_e3_rdis_n vrest rgc4_e3_rdis_n 0
rgc4_e3_rdis gc4_e3_vmd rgc4_e3_rdis_n 220000
ngc4_e3_rp gc4_e3_rt gc4_e3_qb vdd vsrc pch W=2e-06 L=1e-06
rgc4_e3_rrc gc4_e3_rt gc4_e3_rec 10000
cgc4_e3_rc gc4_e3_rec 0 1e-07
rgc4_e3_rr gc4_e3_rec 0 8.2e+06
ngc4_e3_sh1 gc4_e3_vm gc4_e3_rec gc4_e3_vms 0 nch W=2e-06 L=1e-06
va_ngc4_e3_sh2_s vrest ngc4_e3_sh2_s 0
ngc4_e3_sh2 gc4_e3_vms gc4_e3_qb ngc4_e3_sh2_s 0 nch W=2e-06 L=1e-06
ngc4_e3_porh gc4_e3_h por_hold vthe 0 nch W=2e-06 L=1e-06
va_ngc4_e3_porm_s vrest ngc4_e3_porm_s 0
ngc4_e3_porm gc4_e3_vm por_hold ngc4_e3_porm_s 0 nch W=2e-06 L=1e-06
ngc4_e3_ip gc4_e3_vm s4_yb vdd vsrc pch W=4e-06 L=4e-06
ngc4_e3_in gc4_e3_vm s4_za 0 0 nch W=4e-06 L=4e-06
ngc4_b3_sw gc4_b3_t gc4_e3_qb vdd vsrc pch W=2e-06 L=1e-06
rgc4_b3_rc gc4_b3_t gc4_b3 10000
cgc4_b3_c gc4_b3 0 1e-07
rgc4_b3_rl gc4_b3 0 2.2e+07
ngc4_b3_sh1p gc4_b3_n gc4_b3 vdd vsrc pch W=2.4e-06 L=5e-07
ngc4_b3_sh1n gc4_b3_n gc4_b3 0 0 nch W=1.2e-06 L=5e-07
ngc4_b3_sh2p gc4_b3_q gc4_b3_n vdd vsrc pch W=2.4e-06 L=5e-07
ngc4_b3_sh2n gc4_b3_q gc4_b3_n 0 0 nch W=1.2e-06 L=5e-07
cgc4_e4_cm gc4_e4_vm 0 1e-07
va_rgc4_e4_rm_n vrest rgc4_e4_rm_n 0
rgc4_e4_rm gc4_e4_vm rgc4_e4_rm_n 1e+06
ngc4_e4_bias0 gc4_e4_vm istep_n 0 0 nch W=4e-06 L=4e-06
ngc4_e4_bias1 gc4_e4_vm istep_n 0 0 nch W=4e-06 L=4e-06
ngc4_e4_bias2 gc4_e4_vm istep_n 0 0 nch W=4e-06 L=4e-06
ngc4_e4_bias3 gc4_e4_vm istep_n 0 0 nch W=4e-06 L=4e-06
rgc4_e4_kb vdd gc4_e4_knb 1e+06
ngc4_e4_kmb gc4_e4_knb gc4_e4_knb 0 0 nch W=4e-06 L=4e-06
ngc4_e4_kmt gc4_e4_ktail gc4_e4_knb 0 0 nch W=4e-06 L=4e-06
ngc4_e4_km1 gc4_e4_kd1 gc4_e4_vm gc4_e4_ktail 0 nch W=4e-06 L=4e-06
ngc4_e4_km2 gc4_e4_ko1 gc4_e4_h gc4_e4_ktail 0 nch W=4e-06 L=4e-06
ngc4_e4_km3 gc4_e4_kd1 gc4_e4_kd1 vdd vsrc pch W=4e-06 L=4e-06
ngc4_e4_km4 gc4_e4_ko1 gc4_e4_kd1 vdd vsrc pch W=4e-06 L=4e-06
ngc4_e4_kporclamp gc4_e4_ko1 por_hold 0 0 nch W=4e-06 L=1e-06
ngc4_e4_ki1p gc4_e4_qb gc4_e4_ko1 vdd vsrc pch W=2.4e-06 L=5e-07
ngc4_e4_ki1n gc4_e4_qb gc4_e4_ko1 0 0 nch W=1.2e-06 L=5e-07
ngc4_e4_ki2p gc4_e4_q gc4_e4_qb vdd vsrc pch W=2.4e-06 L=5e-07
ngc4_e4_ki2n gc4_e4_q gc4_e4_qb 0 0 nch W=1.2e-06 L=5e-07
rgc4_e4_hra gc4_e4_h vthe 1e+06
rgc4_e4_hrf gc4_e4_h gc4_e4_qb 1.9e+07
cgc4_e4_hc gc4_e4_h 0 2.1e-09
ngc4_e4_dis gc4_e4_vm gc4_e4_q gc4_e4_vmd 0 nch W=4e-06 L=1e-06
va_rgc4_e4_rdis_n vrest rgc4_e4_rdis_n 0
rgc4_e4_rdis gc4_e4_vmd rgc4_e4_rdis_n 220000
ngc4_e4_rp gc4_e4_rt gc4_e4_qb vdd vsrc pch W=2e-06 L=1e-06
rgc4_e4_rrc gc4_e4_rt gc4_e4_rec 10000
cgc4_e4_rc gc4_e4_rec 0 1e-07
rgc4_e4_rr gc4_e4_rec 0 8.2e+06
ngc4_e4_sh1 gc4_e4_vm gc4_e4_rec gc4_e4_vms 0 nch W=2e-06 L=1e-06
va_ngc4_e4_sh2_s vrest ngc4_e4_sh2_s 0
ngc4_e4_sh2 gc4_e4_vms gc4_e4_qb ngc4_e4_sh2_s 0 nch W=2e-06 L=1e-06
ngc4_e4_porh gc4_e4_h por_hold vthe 0 nch W=2e-06 L=1e-06
va_ngc4_e4_porm_s vrest ngc4_e4_porm_s 0
ngc4_e4_porm gc4_e4_vm por_hold ngc4_e4_porm_s 0 nch W=2e-06 L=1e-06
ngc4_e4_ip gc4_e4_vm s4_yb vdd vsrc pch W=4e-06 L=4e-06
ngc4_e4_in gc4_e4_vm s4_za 0 0 nch W=4e-06 L=4e-06
ngc4_b4_sw gc4_b4_t gc4_e4_qb vdd vsrc pch W=2e-06 L=1e-06
rgc4_b4_rc gc4_b4_t gc4_b4 10000
cgc4_b4_c gc4_b4 0 1e-07
rgc4_b4_rl gc4_b4 0 2.2e+07
ngc4_b4_sh1p gc4_b4_n gc4_b4 vdd vsrc pch W=2.4e-06 L=5e-07
ngc4_b4_sh1n gc4_b4_n gc4_b4 0 0 nch W=1.2e-06 L=5e-07
ngc4_b4_sh2p gc4_b4_q gc4_b4_n vdd vsrc pch W=2.4e-06 L=5e-07
ngc4_b4_sh2n gc4_b4_q gc4_b4_n 0 0 nch W=1.2e-06 L=5e-07
cgc4_e5_cm gc4_e5_vm 0 1e-07
va_rgc4_e5_rm_n vrest rgc4_e5_rm_n 0
rgc4_e5_rm gc4_e5_vm rgc4_e5_rm_n 1e+06
ngc4_e5_bias0 gc4_e5_vm istep_n 0 0 nch W=4e-06 L=4e-06
ngc4_e5_bias1 gc4_e5_vm istep_n 0 0 nch W=4e-06 L=4e-06
ngc4_e5_bias2 gc4_e5_vm istep_n 0 0 nch W=4e-06 L=4e-06
ngc4_e5_bias3 gc4_e5_vm istep_n 0 0 nch W=4e-06 L=4e-06
ngc4_e5_bias4 gc4_e5_vm istep_n 0 0 nch W=4e-06 L=4e-06
rgc4_e5_kb vdd gc4_e5_knb 1e+06
ngc4_e5_kmb gc4_e5_knb gc4_e5_knb 0 0 nch W=4e-06 L=4e-06
ngc4_e5_kmt gc4_e5_ktail gc4_e5_knb 0 0 nch W=4e-06 L=4e-06
ngc4_e5_km1 gc4_e5_kd1 gc4_e5_vm gc4_e5_ktail 0 nch W=4e-06 L=4e-06
ngc4_e5_km2 gc4_e5_ko1 gc4_e5_h gc4_e5_ktail 0 nch W=4e-06 L=4e-06
ngc4_e5_km3 gc4_e5_kd1 gc4_e5_kd1 vdd vsrc pch W=4e-06 L=4e-06
ngc4_e5_km4 gc4_e5_ko1 gc4_e5_kd1 vdd vsrc pch W=4e-06 L=4e-06
ngc4_e5_kporclamp gc4_e5_ko1 por_hold 0 0 nch W=4e-06 L=1e-06
ngc4_e5_ki1p gc4_e5_qb gc4_e5_ko1 vdd vsrc pch W=2.4e-06 L=5e-07
ngc4_e5_ki1n gc4_e5_qb gc4_e5_ko1 0 0 nch W=1.2e-06 L=5e-07
ngc4_e5_ki2p gc4_e5_q gc4_e5_qb vdd vsrc pch W=2.4e-06 L=5e-07
ngc4_e5_ki2n gc4_e5_q gc4_e5_qb 0 0 nch W=1.2e-06 L=5e-07
rgc4_e5_hra gc4_e5_h vthe 1e+06
rgc4_e5_hrf gc4_e5_h gc4_e5_qb 1.9e+07
cgc4_e5_hc gc4_e5_h 0 2.1e-09
ngc4_e5_dis gc4_e5_vm gc4_e5_q gc4_e5_vmd 0 nch W=4e-06 L=1e-06
va_rgc4_e5_rdis_n vrest rgc4_e5_rdis_n 0
rgc4_e5_rdis gc4_e5_vmd rgc4_e5_rdis_n 220000
ngc4_e5_rp gc4_e5_rt gc4_e5_qb vdd vsrc pch W=2e-06 L=1e-06
rgc4_e5_rrc gc4_e5_rt gc4_e5_rec 10000
cgc4_e5_rc gc4_e5_rec 0 1e-07
rgc4_e5_rr gc4_e5_rec 0 8.2e+06
ngc4_e5_sh1 gc4_e5_vm gc4_e5_rec gc4_e5_vms 0 nch W=2e-06 L=1e-06
va_ngc4_e5_sh2_s vrest ngc4_e5_sh2_s 0
ngc4_e5_sh2 gc4_e5_vms gc4_e5_qb ngc4_e5_sh2_s 0 nch W=2e-06 L=1e-06
ngc4_e5_porh gc4_e5_h por_hold vthe 0 nch W=2e-06 L=1e-06
va_ngc4_e5_porm_s vrest ngc4_e5_porm_s 0
ngc4_e5_porm gc4_e5_vm por_hold ngc4_e5_porm_s 0 nch W=2e-06 L=1e-06
ngc4_e5_ip gc4_e5_vm s4_yb vdd vsrc pch W=4e-06 L=4e-06
ngc4_e5_in gc4_e5_vm s4_za 0 0 nch W=4e-06 L=4e-06
ngc4_b5_sw gc4_b5_t gc4_e5_qb vdd vsrc pch W=2e-06 L=1e-06
rgc4_b5_rc gc4_b5_t gc4_b5 10000
cgc4_b5_c gc4_b5 0 1e-07
rgc4_b5_rl gc4_b5 0 2.2e+07
ngc4_b5_sh1p gc4_b5_n gc4_b5 vdd vsrc pch W=2.4e-06 L=5e-07
ngc4_b5_sh1n gc4_b5_n gc4_b5 0 0 nch W=1.2e-06 L=5e-07
ngc4_b5_sh2p gc4_b5_q gc4_b5_n vdd vsrc pch W=2.4e-06 L=5e-07
ngc4_b5_sh2n gc4_b5_q gc4_b5_n 0 0 nch W=1.2e-06 L=5e-07
cgc4_e6_cm gc4_e6_vm 0 1e-07
va_rgc4_e6_rm_n vrest rgc4_e6_rm_n 0
rgc4_e6_rm gc4_e6_vm rgc4_e6_rm_n 1e+06
ngc4_e6_bias0 gc4_e6_vm istep_n 0 0 nch W=4e-06 L=4e-06
ngc4_e6_bias1 gc4_e6_vm istep_n 0 0 nch W=4e-06 L=4e-06
ngc4_e6_bias2 gc4_e6_vm istep_n 0 0 nch W=4e-06 L=4e-06
ngc4_e6_bias3 gc4_e6_vm istep_n 0 0 nch W=4e-06 L=4e-06
ngc4_e6_bias4 gc4_e6_vm istep_n 0 0 nch W=4e-06 L=4e-06
ngc4_e6_bias5 gc4_e6_vm istep_n 0 0 nch W=4e-06 L=4e-06
rgc4_e6_kb vdd gc4_e6_knb 1e+06
ngc4_e6_kmb gc4_e6_knb gc4_e6_knb 0 0 nch W=4e-06 L=4e-06
ngc4_e6_kmt gc4_e6_ktail gc4_e6_knb 0 0 nch W=4e-06 L=4e-06
ngc4_e6_km1 gc4_e6_kd1 gc4_e6_vm gc4_e6_ktail 0 nch W=4e-06 L=4e-06
ngc4_e6_km2 gc4_e6_ko1 gc4_e6_h gc4_e6_ktail 0 nch W=4e-06 L=4e-06
ngc4_e6_km3 gc4_e6_kd1 gc4_e6_kd1 vdd vsrc pch W=4e-06 L=4e-06
ngc4_e6_km4 gc4_e6_ko1 gc4_e6_kd1 vdd vsrc pch W=4e-06 L=4e-06
ngc4_e6_kporclamp gc4_e6_ko1 por_hold 0 0 nch W=4e-06 L=1e-06
ngc4_e6_ki1p gc4_e6_qb gc4_e6_ko1 vdd vsrc pch W=2.4e-06 L=5e-07
ngc4_e6_ki1n gc4_e6_qb gc4_e6_ko1 0 0 nch W=1.2e-06 L=5e-07
ngc4_e6_ki2p gc4_e6_q gc4_e6_qb vdd vsrc pch W=2.4e-06 L=5e-07
ngc4_e6_ki2n gc4_e6_q gc4_e6_qb 0 0 nch W=1.2e-06 L=5e-07
rgc4_e6_hra gc4_e6_h vthe 1e+06
rgc4_e6_hrf gc4_e6_h gc4_e6_qb 1.9e+07
cgc4_e6_hc gc4_e6_h 0 2.1e-09
ngc4_e6_dis gc4_e6_vm gc4_e6_q gc4_e6_vmd 0 nch W=4e-06 L=1e-06
va_rgc4_e6_rdis_n vrest rgc4_e6_rdis_n 0
rgc4_e6_rdis gc4_e6_vmd rgc4_e6_rdis_n 220000
ngc4_e6_rp gc4_e6_rt gc4_e6_qb vdd vsrc pch W=2e-06 L=1e-06
rgc4_e6_rrc gc4_e6_rt gc4_e6_rec 10000
cgc4_e6_rc gc4_e6_rec 0 1e-07
rgc4_e6_rr gc4_e6_rec 0 8.2e+06
ngc4_e6_sh1 gc4_e6_vm gc4_e6_rec gc4_e6_vms 0 nch W=2e-06 L=1e-06
va_ngc4_e6_sh2_s vrest ngc4_e6_sh2_s 0
ngc4_e6_sh2 gc4_e6_vms gc4_e6_qb ngc4_e6_sh2_s 0 nch W=2e-06 L=1e-06
ngc4_e6_porh gc4_e6_h por_hold vthe 0 nch W=2e-06 L=1e-06
va_ngc4_e6_porm_s vrest ngc4_e6_porm_s 0
ngc4_e6_porm gc4_e6_vm por_hold ngc4_e6_porm_s 0 nch W=2e-06 L=1e-06
ngc4_e6_ip gc4_e6_vm s4_yb vdd vsrc pch W=4e-06 L=4e-06
ngc4_e6_in gc4_e6_vm s4_za 0 0 nch W=4e-06 L=4e-06
ngc4_b6_sw gc4_b6_t gc4_e6_qb vdd vsrc pch W=2e-06 L=1e-06
rgc4_b6_rc gc4_b6_t gc4_b6 10000
cgc4_b6_c gc4_b6 0 1e-07
rgc4_b6_rl gc4_b6 0 2.2e+07
ngc4_b6_sh1p gc4_b6_n gc4_b6 vdd vsrc pch W=2.4e-06 L=5e-07
ngc4_b6_sh1n gc4_b6_n gc4_b6 0 0 nch W=1.2e-06 L=5e-07
ngc4_b6_sh2p gc4_b6_q gc4_b6_n vdd vsrc pch W=2.4e-06 L=5e-07
ngc4_b6_sh2n gc4_b6_q gc4_b6_n 0 0 nch W=1.2e-06 L=5e-07
cgc4_e7_cm gc4_e7_vm 0 1e-07
va_rgc4_e7_rm_n vrest rgc4_e7_rm_n 0
rgc4_e7_rm gc4_e7_vm rgc4_e7_rm_n 1e+06
ngc4_e7_bias0 gc4_e7_vm istep_n 0 0 nch W=4e-06 L=4e-06
ngc4_e7_bias1 gc4_e7_vm istep_n 0 0 nch W=4e-06 L=4e-06
ngc4_e7_bias2 gc4_e7_vm istep_n 0 0 nch W=4e-06 L=4e-06
ngc4_e7_bias3 gc4_e7_vm istep_n 0 0 nch W=4e-06 L=4e-06
ngc4_e7_bias4 gc4_e7_vm istep_n 0 0 nch W=4e-06 L=4e-06
ngc4_e7_bias5 gc4_e7_vm istep_n 0 0 nch W=4e-06 L=4e-06
ngc4_e7_bias6 gc4_e7_vm istep_n 0 0 nch W=4e-06 L=4e-06
rgc4_e7_kb vdd gc4_e7_knb 1e+06
ngc4_e7_kmb gc4_e7_knb gc4_e7_knb 0 0 nch W=4e-06 L=4e-06
ngc4_e7_kmt gc4_e7_ktail gc4_e7_knb 0 0 nch W=4e-06 L=4e-06
ngc4_e7_km1 gc4_e7_kd1 gc4_e7_vm gc4_e7_ktail 0 nch W=4e-06 L=4e-06
ngc4_e7_km2 gc4_e7_ko1 gc4_e7_h gc4_e7_ktail 0 nch W=4e-06 L=4e-06
ngc4_e7_km3 gc4_e7_kd1 gc4_e7_kd1 vdd vsrc pch W=4e-06 L=4e-06
ngc4_e7_km4 gc4_e7_ko1 gc4_e7_kd1 vdd vsrc pch W=4e-06 L=4e-06
ngc4_e7_kporclamp gc4_e7_ko1 por_hold 0 0 nch W=4e-06 L=1e-06
ngc4_e7_ki1p gc4_e7_qb gc4_e7_ko1 vdd vsrc pch W=2.4e-06 L=5e-07
ngc4_e7_ki1n gc4_e7_qb gc4_e7_ko1 0 0 nch W=1.2e-06 L=5e-07
ngc4_e7_ki2p gc4_e7_q gc4_e7_qb vdd vsrc pch W=2.4e-06 L=5e-07
ngc4_e7_ki2n gc4_e7_q gc4_e7_qb 0 0 nch W=1.2e-06 L=5e-07
rgc4_e7_hra gc4_e7_h vthe 1e+06
rgc4_e7_hrf gc4_e7_h gc4_e7_qb 1.9e+07
cgc4_e7_hc gc4_e7_h 0 2.1e-09
ngc4_e7_dis gc4_e7_vm gc4_e7_q gc4_e7_vmd 0 nch W=4e-06 L=1e-06
va_rgc4_e7_rdis_n vrest rgc4_e7_rdis_n 0
rgc4_e7_rdis gc4_e7_vmd rgc4_e7_rdis_n 220000
ngc4_e7_rp gc4_e7_rt gc4_e7_qb vdd vsrc pch W=2e-06 L=1e-06
rgc4_e7_rrc gc4_e7_rt gc4_e7_rec 10000
cgc4_e7_rc gc4_e7_rec 0 1e-07
rgc4_e7_rr gc4_e7_rec 0 8.2e+06
ngc4_e7_sh1 gc4_e7_vm gc4_e7_rec gc4_e7_vms 0 nch W=2e-06 L=1e-06
va_ngc4_e7_sh2_s vrest ngc4_e7_sh2_s 0
ngc4_e7_sh2 gc4_e7_vms gc4_e7_qb ngc4_e7_sh2_s 0 nch W=2e-06 L=1e-06
ngc4_e7_porh gc4_e7_h por_hold vthe 0 nch W=2e-06 L=1e-06
va_ngc4_e7_porm_s vrest ngc4_e7_porm_s 0
ngc4_e7_porm gc4_e7_vm por_hold ngc4_e7_porm_s 0 nch W=2e-06 L=1e-06
ngc4_e7_ip gc4_e7_vm s4_yb vdd vsrc pch W=4e-06 L=4e-06
ngc4_e7_in gc4_e7_vm s4_za 0 0 nch W=4e-06 L=4e-06
ngc4_b7_sw gc4_b7_t gc4_e7_qb vdd vsrc pch W=2e-06 L=1e-06
rgc4_b7_rc gc4_b7_t gc4_b7 10000
cgc4_b7_c gc4_b7 0 1e-07
rgc4_b7_rl gc4_b7 0 2.2e+07
ngc4_b7_sh1p gc4_b7_n gc4_b7 vdd vsrc pch W=2.4e-06 L=5e-07
ngc4_b7_sh1n gc4_b7_n gc4_b7 0 0 nch W=1.2e-06 L=5e-07
ngc4_b7_sh2p gc4_b7_q gc4_b7_n vdd vsrc pch W=2.4e-06 L=5e-07
ngc4_b7_sh2n gc4_b7_q gc4_b7_n 0 0 nch W=1.2e-06 L=5e-07
cgc4_e8_cm gc4_e8_vm 0 1e-07
va_rgc4_e8_rm_n vrest rgc4_e8_rm_n 0
rgc4_e8_rm gc4_e8_vm rgc4_e8_rm_n 1e+06
ngc4_e8_bias0 gc4_e8_vm istep_n 0 0 nch W=4e-06 L=4e-06
ngc4_e8_bias1 gc4_e8_vm istep_n 0 0 nch W=4e-06 L=4e-06
ngc4_e8_bias2 gc4_e8_vm istep_n 0 0 nch W=4e-06 L=4e-06
ngc4_e8_bias3 gc4_e8_vm istep_n 0 0 nch W=4e-06 L=4e-06
ngc4_e8_bias4 gc4_e8_vm istep_n 0 0 nch W=4e-06 L=4e-06
ngc4_e8_bias5 gc4_e8_vm istep_n 0 0 nch W=4e-06 L=4e-06
ngc4_e8_bias6 gc4_e8_vm istep_n 0 0 nch W=4e-06 L=4e-06
ngc4_e8_bias7 gc4_e8_vm istep_n 0 0 nch W=4e-06 L=4e-06
rgc4_e8_kb vdd gc4_e8_knb 1e+06
ngc4_e8_kmb gc4_e8_knb gc4_e8_knb 0 0 nch W=4e-06 L=4e-06
ngc4_e8_kmt gc4_e8_ktail gc4_e8_knb 0 0 nch W=4e-06 L=4e-06
ngc4_e8_km1 gc4_e8_kd1 gc4_e8_vm gc4_e8_ktail 0 nch W=4e-06 L=4e-06
ngc4_e8_km2 gc4_e8_ko1 gc4_e8_h gc4_e8_ktail 0 nch W=4e-06 L=4e-06
ngc4_e8_km3 gc4_e8_kd1 gc4_e8_kd1 vdd vsrc pch W=4e-06 L=4e-06
ngc4_e8_km4 gc4_e8_ko1 gc4_e8_kd1 vdd vsrc pch W=4e-06 L=4e-06
ngc4_e8_kporclamp gc4_e8_ko1 por_hold 0 0 nch W=4e-06 L=1e-06
ngc4_e8_ki1p gc4_e8_qb gc4_e8_ko1 vdd vsrc pch W=2.4e-06 L=5e-07
ngc4_e8_ki1n gc4_e8_qb gc4_e8_ko1 0 0 nch W=1.2e-06 L=5e-07
ngc4_e8_ki2p gc4_e8_q gc4_e8_qb vdd vsrc pch W=2.4e-06 L=5e-07
ngc4_e8_ki2n gc4_e8_q gc4_e8_qb 0 0 nch W=1.2e-06 L=5e-07
rgc4_e8_hra gc4_e8_h vthe 1e+06
rgc4_e8_hrf gc4_e8_h gc4_e8_qb 1.9e+07
cgc4_e8_hc gc4_e8_h 0 2.1e-09
ngc4_e8_dis gc4_e8_vm gc4_e8_q gc4_e8_vmd 0 nch W=4e-06 L=1e-06
va_rgc4_e8_rdis_n vrest rgc4_e8_rdis_n 0
rgc4_e8_rdis gc4_e8_vmd rgc4_e8_rdis_n 220000
ngc4_e8_rp gc4_e8_rt gc4_e8_qb vdd vsrc pch W=2e-06 L=1e-06
rgc4_e8_rrc gc4_e8_rt gc4_e8_rec 10000
cgc4_e8_rc gc4_e8_rec 0 1e-07
rgc4_e8_rr gc4_e8_rec 0 8.2e+06
ngc4_e8_sh1 gc4_e8_vm gc4_e8_rec gc4_e8_vms 0 nch W=2e-06 L=1e-06
va_ngc4_e8_sh2_s vrest ngc4_e8_sh2_s 0
ngc4_e8_sh2 gc4_e8_vms gc4_e8_qb ngc4_e8_sh2_s 0 nch W=2e-06 L=1e-06
ngc4_e8_porh gc4_e8_h por_hold vthe 0 nch W=2e-06 L=1e-06
va_ngc4_e8_porm_s vrest ngc4_e8_porm_s 0
ngc4_e8_porm gc4_e8_vm por_hold ngc4_e8_porm_s 0 nch W=2e-06 L=1e-06
ngc4_e8_ip gc4_e8_vm s4_yb vdd vsrc pch W=4e-06 L=4e-06
ngc4_e8_in gc4_e8_vm s4_za 0 0 nch W=4e-06 L=4e-06
ngc4_b8_sw gc4_b8_t gc4_e8_qb vdd vsrc pch W=2e-06 L=1e-06
rgc4_b8_rc gc4_b8_t gc4_b8 10000
cgc4_b8_c gc4_b8 0 1e-07
rgc4_b8_rl gc4_b8 0 2.2e+07
ngc4_b8_sh1p gc4_b8_n gc4_b8 vdd vsrc pch W=2.4e-06 L=5e-07
ngc4_b8_sh1n gc4_b8_n gc4_b8 0 0 nch W=1.2e-06 L=5e-07
ngc4_b8_sh2p gc4_b8_q gc4_b8_n vdd vsrc pch W=2.4e-06 L=5e-07
ngc4_b8_sh2n gc4_b8_q gc4_b8_n 0 0 nch W=1.2e-06 L=5e-07
cgc4_e9_cm gc4_e9_vm 0 1e-07
va_rgc4_e9_rm_n vrest rgc4_e9_rm_n 0
rgc4_e9_rm gc4_e9_vm rgc4_e9_rm_n 1e+06
ngc4_e9_bias0 gc4_e9_vm istep_n 0 0 nch W=4e-06 L=4e-06
ngc4_e9_bias1 gc4_e9_vm istep_n 0 0 nch W=4e-06 L=4e-06
ngc4_e9_bias2 gc4_e9_vm istep_n 0 0 nch W=4e-06 L=4e-06
ngc4_e9_bias3 gc4_e9_vm istep_n 0 0 nch W=4e-06 L=4e-06
ngc4_e9_bias4 gc4_e9_vm istep_n 0 0 nch W=4e-06 L=4e-06
ngc4_e9_bias5 gc4_e9_vm istep_n 0 0 nch W=4e-06 L=4e-06
ngc4_e9_bias6 gc4_e9_vm istep_n 0 0 nch W=4e-06 L=4e-06
ngc4_e9_bias7 gc4_e9_vm istep_n 0 0 nch W=4e-06 L=4e-06
ngc4_e9_bias8 gc4_e9_vm istep_n 0 0 nch W=4e-06 L=4e-06
rgc4_e9_kb vdd gc4_e9_knb 1e+06
ngc4_e9_kmb gc4_e9_knb gc4_e9_knb 0 0 nch W=4e-06 L=4e-06
ngc4_e9_kmt gc4_e9_ktail gc4_e9_knb 0 0 nch W=4e-06 L=4e-06
ngc4_e9_km1 gc4_e9_kd1 gc4_e9_vm gc4_e9_ktail 0 nch W=4e-06 L=4e-06
ngc4_e9_km2 gc4_e9_ko1 gc4_e9_h gc4_e9_ktail 0 nch W=4e-06 L=4e-06
ngc4_e9_km3 gc4_e9_kd1 gc4_e9_kd1 vdd vsrc pch W=4e-06 L=4e-06
ngc4_e9_km4 gc4_e9_ko1 gc4_e9_kd1 vdd vsrc pch W=4e-06 L=4e-06
ngc4_e9_kporclamp gc4_e9_ko1 por_hold 0 0 nch W=4e-06 L=1e-06
ngc4_e9_ki1p gc4_e9_qb gc4_e9_ko1 vdd vsrc pch W=2.4e-06 L=5e-07
ngc4_e9_ki1n gc4_e9_qb gc4_e9_ko1 0 0 nch W=1.2e-06 L=5e-07
ngc4_e9_ki2p gc4_e9_q gc4_e9_qb vdd vsrc pch W=2.4e-06 L=5e-07
ngc4_e9_ki2n gc4_e9_q gc4_e9_qb 0 0 nch W=1.2e-06 L=5e-07
rgc4_e9_hra gc4_e9_h vthe 1e+06
rgc4_e9_hrf gc4_e9_h gc4_e9_qb 1.9e+07
cgc4_e9_hc gc4_e9_h 0 2.1e-09
ngc4_e9_dis gc4_e9_vm gc4_e9_q gc4_e9_vmd 0 nch W=4e-06 L=1e-06
va_rgc4_e9_rdis_n vrest rgc4_e9_rdis_n 0
rgc4_e9_rdis gc4_e9_vmd rgc4_e9_rdis_n 220000
ngc4_e9_rp gc4_e9_rt gc4_e9_qb vdd vsrc pch W=2e-06 L=1e-06
rgc4_e9_rrc gc4_e9_rt gc4_e9_rec 10000
cgc4_e9_rc gc4_e9_rec 0 1e-07
rgc4_e9_rr gc4_e9_rec 0 8.2e+06
ngc4_e9_sh1 gc4_e9_vm gc4_e9_rec gc4_e9_vms 0 nch W=2e-06 L=1e-06
va_ngc4_e9_sh2_s vrest ngc4_e9_sh2_s 0
ngc4_e9_sh2 gc4_e9_vms gc4_e9_qb ngc4_e9_sh2_s 0 nch W=2e-06 L=1e-06
ngc4_e9_porh gc4_e9_h por_hold vthe 0 nch W=2e-06 L=1e-06
va_ngc4_e9_porm_s vrest ngc4_e9_porm_s 0
ngc4_e9_porm gc4_e9_vm por_hold ngc4_e9_porm_s 0 nch W=2e-06 L=1e-06
ngc4_e9_ip gc4_e9_vm s4_yb vdd vsrc pch W=4e-06 L=4e-06
ngc4_e9_in gc4_e9_vm s4_za 0 0 nch W=4e-06 L=4e-06
ngc4_b9_sw gc4_b9_t gc4_e9_qb vdd vsrc pch W=2e-06 L=1e-06
rgc4_b9_rc gc4_b9_t gc4_b9 10000
cgc4_b9_c gc4_b9 0 1e-07
rgc4_b9_rl gc4_b9 0 2.2e+07
ngc4_b9_sh1p gc4_b9_n gc4_b9 vdd vsrc pch W=2.4e-06 L=5e-07
ngc4_b9_sh1n gc4_b9_n gc4_b9 0 0 nch W=1.2e-06 L=5e-07
ngc4_b9_sh2p gc4_b9_q gc4_b9_n vdd vsrc pch W=2.4e-06 L=5e-07
ngc4_b9_sh2n gc4_b9_q gc4_b9_n 0 0 nch W=1.2e-06 L=5e-07
cgc4_e10_cm gc4_e10_vm 0 1e-07
va_rgc4_e10_rm_n vrest rgc4_e10_rm_n 0
rgc4_e10_rm gc4_e10_vm rgc4_e10_rm_n 1e+06
ngc4_e10_bias0 gc4_e10_vm istep_n 0 0 nch W=4e-06 L=4e-06
ngc4_e10_bias1 gc4_e10_vm istep_n 0 0 nch W=4e-06 L=4e-06
ngc4_e10_bias2 gc4_e10_vm istep_n 0 0 nch W=4e-06 L=4e-06
ngc4_e10_bias3 gc4_e10_vm istep_n 0 0 nch W=4e-06 L=4e-06
ngc4_e10_bias4 gc4_e10_vm istep_n 0 0 nch W=4e-06 L=4e-06
ngc4_e10_bias5 gc4_e10_vm istep_n 0 0 nch W=4e-06 L=4e-06
ngc4_e10_bias6 gc4_e10_vm istep_n 0 0 nch W=4e-06 L=4e-06
ngc4_e10_bias7 gc4_e10_vm istep_n 0 0 nch W=4e-06 L=4e-06
ngc4_e10_bias8 gc4_e10_vm istep_n 0 0 nch W=4e-06 L=4e-06
ngc4_e10_bias9 gc4_e10_vm istep_n 0 0 nch W=4e-06 L=4e-06
rgc4_e10_kb vdd gc4_e10_knb 1e+06
ngc4_e10_kmb gc4_e10_knb gc4_e10_knb 0 0 nch W=4e-06 L=4e-06
ngc4_e10_kmt gc4_e10_ktail gc4_e10_knb 0 0 nch W=4e-06 L=4e-06
ngc4_e10_km1 gc4_e10_kd1 gc4_e10_vm gc4_e10_ktail 0 nch W=4e-06 L=4e-06
ngc4_e10_km2 gc4_e10_ko1 gc4_e10_h gc4_e10_ktail 0 nch W=4e-06 L=4e-06
ngc4_e10_km3 gc4_e10_kd1 gc4_e10_kd1 vdd vsrc pch W=4e-06 L=4e-06
ngc4_e10_km4 gc4_e10_ko1 gc4_e10_kd1 vdd vsrc pch W=4e-06 L=4e-06
ngc4_e10_kporclamp gc4_e10_ko1 por_hold 0 0 nch W=4e-06 L=1e-06
ngc4_e10_ki1p gc4_e10_qb gc4_e10_ko1 vdd vsrc pch W=2.4e-06 L=5e-07
ngc4_e10_ki1n gc4_e10_qb gc4_e10_ko1 0 0 nch W=1.2e-06 L=5e-07
ngc4_e10_ki2p gc4_e10_q gc4_e10_qb vdd vsrc pch W=2.4e-06 L=5e-07
ngc4_e10_ki2n gc4_e10_q gc4_e10_qb 0 0 nch W=1.2e-06 L=5e-07
rgc4_e10_hra gc4_e10_h vthe 1e+06
rgc4_e10_hrf gc4_e10_h gc4_e10_qb 1.9e+07
cgc4_e10_hc gc4_e10_h 0 2.1e-09
ngc4_e10_dis gc4_e10_vm gc4_e10_q gc4_e10_vmd 0 nch W=4e-06 L=1e-06
va_rgc4_e10_rdis_n vrest rgc4_e10_rdis_n 0
rgc4_e10_rdis gc4_e10_vmd rgc4_e10_rdis_n 220000
ngc4_e10_rp gc4_e10_rt gc4_e10_qb vdd vsrc pch W=2e-06 L=1e-06
rgc4_e10_rrc gc4_e10_rt gc4_e10_rec 10000
cgc4_e10_rc gc4_e10_rec 0 1e-07
rgc4_e10_rr gc4_e10_rec 0 8.2e+06
ngc4_e10_sh1 gc4_e10_vm gc4_e10_rec gc4_e10_vms 0 nch W=2e-06 L=1e-06
va_ngc4_e10_sh2_s vrest ngc4_e10_sh2_s 0
ngc4_e10_sh2 gc4_e10_vms gc4_e10_qb ngc4_e10_sh2_s 0 nch W=2e-06 L=1e-06
ngc4_e10_porh gc4_e10_h por_hold vthe 0 nch W=2e-06 L=1e-06
va_ngc4_e10_porm_s vrest ngc4_e10_porm_s 0
ngc4_e10_porm gc4_e10_vm por_hold ngc4_e10_porm_s 0 nch W=2e-06 L=1e-06
ngc4_e10_ip gc4_e10_vm s4_yb vdd vsrc pch W=4e-06 L=4e-06
ngc4_e10_in gc4_e10_vm s4_za 0 0 nch W=4e-06 L=4e-06
ngc4_b10_sw gc4_b10_t gc4_e10_qb vdd vsrc pch W=2e-06 L=1e-06
rgc4_b10_rc gc4_b10_t gc4_b10 10000
cgc4_b10_c gc4_b10 0 1e-07
rgc4_b10_rl gc4_b10 0 2.2e+07
ngc4_b10_sh1p gc4_b10_n gc4_b10 vdd vsrc pch W=2.4e-06 L=5e-07
ngc4_b10_sh1n gc4_b10_n gc4_b10 0 0 nch W=1.2e-06 L=5e-07
ngc4_b10_sh2p gc4_b10_q gc4_b10_n vdd vsrc pch W=2.4e-06 L=5e-07
ngc4_b10_sh2n gc4_b10_q gc4_b10_n 0 0 nch W=1.2e-06 L=5e-07
ngc4_and_a0_npa gc4_and_a0_nb gc4_b1_q vdd vsrc pch W=2.4e-06 L=5e-07
ngc4_and_a0_npb gc4_and_a0_nb gc4_b2_q vdd vsrc pch W=2.4e-06 L=5e-07
ngc4_and_a0_nna gc4_and_a0_nb gc4_b1_q gc4_and_a0_nx 0 nch W=2.4e-06 L=5e-07
ngc4_and_a0_nnb gc4_and_a0_nx gc4_b2_q 0 0 nch W=2.4e-06 L=5e-07
ngc4_and_a0_ip gc4_and_g0 gc4_and_a0_nb vdd vsrc pch W=2.4e-06 L=5e-07
ngc4_and_a0_in gc4_and_g0 gc4_and_a0_nb 0 0 nch W=1.2e-06 L=5e-07
ngc4_and_a1_npa gc4_and_a1_nb gc4_b3_q vdd vsrc pch W=2.4e-06 L=5e-07
ngc4_and_a1_npb gc4_and_a1_nb gc4_b4_q vdd vsrc pch W=2.4e-06 L=5e-07
ngc4_and_a1_nna gc4_and_a1_nb gc4_b3_q gc4_and_a1_nx 0 nch W=2.4e-06 L=5e-07
ngc4_and_a1_nnb gc4_and_a1_nx gc4_b4_q 0 0 nch W=2.4e-06 L=5e-07
ngc4_and_a1_ip gc4_and_g1 gc4_and_a1_nb vdd vsrc pch W=2.4e-06 L=5e-07
ngc4_and_a1_in gc4_and_g1 gc4_and_a1_nb 0 0 nch W=1.2e-06 L=5e-07
ngc4_and_a2_npa gc4_and_a2_nb gc4_b5_q vdd vsrc pch W=2.4e-06 L=5e-07
ngc4_and_a2_npb gc4_and_a2_nb gc4_b6_q vdd vsrc pch W=2.4e-06 L=5e-07
ngc4_and_a2_nna gc4_and_a2_nb gc4_b5_q gc4_and_a2_nx 0 nch W=2.4e-06 L=5e-07
ngc4_and_a2_nnb gc4_and_a2_nx gc4_b6_q 0 0 nch W=2.4e-06 L=5e-07
ngc4_and_a2_ip gc4_and_g2 gc4_and_a2_nb vdd vsrc pch W=2.4e-06 L=5e-07
ngc4_and_a2_in gc4_and_g2 gc4_and_a2_nb 0 0 nch W=1.2e-06 L=5e-07
ngc4_and_a3_npa gc4_and_a3_nb gc4_b7_q vdd vsrc pch W=2.4e-06 L=5e-07
ngc4_and_a3_npb gc4_and_a3_nb gc4_b8_q vdd vsrc pch W=2.4e-06 L=5e-07
ngc4_and_a3_nna gc4_and_a3_nb gc4_b7_q gc4_and_a3_nx 0 nch W=2.4e-06 L=5e-07
ngc4_and_a3_nnb gc4_and_a3_nx gc4_b8_q 0 0 nch W=2.4e-06 L=5e-07
ngc4_and_a3_ip gc4_and_g3 gc4_and_a3_nb vdd vsrc pch W=2.4e-06 L=5e-07
ngc4_and_a3_in gc4_and_g3 gc4_and_a3_nb 0 0 nch W=1.2e-06 L=5e-07
ngc4_and_a4_npa gc4_and_a4_nb gc4_b9_q vdd vsrc pch W=2.4e-06 L=5e-07
ngc4_and_a4_npb gc4_and_a4_nb gc4_b10_q vdd vsrc pch W=2.4e-06 L=5e-07
ngc4_and_a4_nna gc4_and_a4_nb gc4_b9_q gc4_and_a4_nx 0 nch W=2.4e-06 L=5e-07
ngc4_and_a4_nnb gc4_and_a4_nx gc4_b10_q 0 0 nch W=2.4e-06 L=5e-07
ngc4_and_a4_ip gc4_and_g4 gc4_and_a4_nb vdd vsrc pch W=2.4e-06 L=5e-07
ngc4_and_a4_in gc4_and_g4 gc4_and_a4_nb 0 0 nch W=1.2e-06 L=5e-07
ngc4_and_a5_npa gc4_and_a5_nb gc4_and_g0 vdd vsrc pch W=2.4e-06 L=5e-07
ngc4_and_a5_npb gc4_and_a5_nb gc4_and_g1 vdd vsrc pch W=2.4e-06 L=5e-07
ngc4_and_a5_nna gc4_and_a5_nb gc4_and_g0 gc4_and_a5_nx 0 nch W=2.4e-06 L=5e-07
ngc4_and_a5_nnb gc4_and_a5_nx gc4_and_g1 0 0 nch W=2.4e-06 L=5e-07
ngc4_and_a5_ip gc4_and_g5 gc4_and_a5_nb vdd vsrc pch W=2.4e-06 L=5e-07
ngc4_and_a5_in gc4_and_g5 gc4_and_a5_nb 0 0 nch W=1.2e-06 L=5e-07
ngc4_and_a6_npa gc4_and_a6_nb gc4_and_g2 vdd vsrc pch W=2.4e-06 L=5e-07
ngc4_and_a6_npb gc4_and_a6_nb gc4_and_g3 vdd vsrc pch W=2.4e-06 L=5e-07
ngc4_and_a6_nna gc4_and_a6_nb gc4_and_g2 gc4_and_a6_nx 0 nch W=2.4e-06 L=5e-07
ngc4_and_a6_nnb gc4_and_a6_nx gc4_and_g3 0 0 nch W=2.4e-06 L=5e-07
ngc4_and_a6_ip gc4_and_g6 gc4_and_a6_nb vdd vsrc pch W=2.4e-06 L=5e-07
ngc4_and_a6_in gc4_and_g6 gc4_and_a6_nb 0 0 nch W=1.2e-06 L=5e-07
ngc4_and_a7_npa gc4_and_a7_nb gc4_and_g5 vdd vsrc pch W=2.4e-06 L=5e-07
ngc4_and_a7_npb gc4_and_a7_nb gc4_and_g6 vdd vsrc pch W=2.4e-06 L=5e-07
ngc4_and_a7_nna gc4_and_a7_nb gc4_and_g5 gc4_and_a7_nx 0 nch W=2.4e-06 L=5e-07
ngc4_and_a7_nnb gc4_and_a7_nx gc4_and_g6 0 0 nch W=2.4e-06 L=5e-07
ngc4_and_a7_ip gc4_and_g7 gc4_and_a7_nb vdd vsrc pch W=2.4e-06 L=5e-07
ngc4_and_a7_in gc4_and_g7 gc4_and_a7_nb 0 0 nch W=1.2e-06 L=5e-07
ngc4_and_a8_npa gc4_and_a8_nb gc4_and_g7 vdd vsrc pch W=2.4e-06 L=5e-07
ngc4_and_a8_npb gc4_and_a8_nb gc4_and_g4 vdd vsrc pch W=2.4e-06 L=5e-07
ngc4_and_a8_nna gc4_and_a8_nb gc4_and_g7 gc4_and_a8_nx 0 nch W=2.4e-06 L=5e-07
ngc4_and_a8_nnb gc4_and_a8_nx gc4_and_g4 0 0 nch W=2.4e-06 L=5e-07
ngc4_and_a8_ip gc4_and_g8 gc4_and_a8_nb vdd vsrc pch W=2.4e-06 L=5e-07
ngc4_and_a8_in gc4_and_g8 gc4_and_a8_nb 0 0 nch W=1.2e-06 L=5e-07
ngc4_gip gc4_gb gc4_and_g8 vdd vsrc pch W=2.4e-06 L=5e-07
ngc4_gin gc4_gb gc4_and_g8 0 0 nch W=1.2e-06 L=5e-07
cgc4_col_cm gc4_col_vm 0 1e-07
va_rgc4_col_rm_n vrest rgc4_col_rm_n 0
rgc4_col_rm gc4_col_vm rgc4_col_rm_n 1e+06
rgc4_col_kb vdd gc4_col_knb 1e+06
ngc4_col_kmb gc4_col_knb gc4_col_knb 0 0 nch W=4e-06 L=4e-06
ngc4_col_kmt gc4_col_ktail gc4_col_knb 0 0 nch W=4e-06 L=4e-06
ngc4_col_km1 gc4_col_kd1 gc4_col_vm gc4_col_ktail 0 nch W=4e-06 L=4e-06
ngc4_col_km2 gc4_col_ko1 gc4_col_h gc4_col_ktail 0 nch W=4e-06 L=4e-06
ngc4_col_km3 gc4_col_kd1 gc4_col_kd1 vdd vsrc pch W=4e-06 L=4e-06
ngc4_col_km4 gc4_col_ko1 gc4_col_kd1 vdd vsrc pch W=4e-06 L=4e-06
ngc4_col_kporclamp gc4_col_ko1 por_hold 0 0 nch W=4e-06 L=1e-06
ngc4_col_ki1p gc4_col_qb gc4_col_ko1 vdd vsrc pch W=2.4e-06 L=5e-07
ngc4_col_ki1n gc4_col_qb gc4_col_ko1 0 0 nch W=1.2e-06 L=5e-07
ngc4_col_ki2p gc4_col_q gc4_col_qb vdd vsrc pch W=2.4e-06 L=5e-07
ngc4_col_ki2n gc4_col_q gc4_col_qb 0 0 nch W=1.2e-06 L=5e-07
rgc4_col_hra gc4_col_h vthe 1e+06
rgc4_col_hrf gc4_col_h gc4_col_qb 1.9e+07
cgc4_col_hc gc4_col_h 0 2.1e-09
ngc4_col_dis gc4_col_vm gc4_col_q gc4_col_vmd 0 nch W=4e-06 L=1e-06
va_rgc4_col_rdis_n vrest rgc4_col_rdis_n 0
rgc4_col_rdis gc4_col_vmd rgc4_col_rdis_n 220000
ngc4_col_rp gc4_col_rt gc4_col_qb vdd vsrc pch W=2e-06 L=1e-06
rgc4_col_rrc gc4_col_rt gc4_col_rec 10000
cgc4_col_rc gc4_col_rec 0 1e-07
rgc4_col_rr gc4_col_rec 0 8.2e+06
ngc4_col_sh1 gc4_col_vm gc4_col_rec gc4_col_vms 0 nch W=2e-06 L=1e-06
va_ngc4_col_sh2_s vrest ngc4_col_sh2_s 0
ngc4_col_sh2 gc4_col_vms gc4_col_qb ngc4_col_sh2_s 0 nch W=2e-06 L=1e-06
ngc4_col_porh gc4_col_h por_hold vthe 0 nch W=2e-06 L=1e-06
va_ngc4_col_porm_s vrest ngc4_col_porm_s 0
ngc4_col_porm gc4_col_vm por_hold ngc4_col_porm_s 0 nch W=2e-06 L=1e-06
ngc4_cin_eni_p gc4_cin_ena gc4_gb vdd vsrc pch W=2.4e-06 L=5e-07
ngc4_cin_eni_n gc4_cin_ena gc4_gb 0 0 nch W=1.2e-06 L=5e-07
ngc4_cin_cp gc4_col_vm gc4_cin_cg vdd vsrc pch W=4e-06 L=4e-06
ngc4_cin_bias ilimp_n gc4_gb gc4_cin_cg vsrc pch W=1.2e-06 L=1e-06
ngc4_cin_off gc4_cin_cg gc4_cin_ena vdd vsrc pch W=2.4e-06 L=1e-06
ngc4_op_tsw gc4_op_tt gc4_col_qb vdd vsrc pch W=2e-06 L=1e-06
rgc4_op_trc gc4_op_tt gc4_op_at 10000
cgc4_op_tc gc4_op_at 0 1e-07
rgc4_op_trl gc4_op_at 0 2.2e+07
ngc4_op_sh1p gc4_op_an gc4_op_at vdd vsrc pch W=2.4e-06 L=5e-07
ngc4_op_sh1n gc4_op_an gc4_op_at 0 0 nch W=1.2e-06 L=5e-07
ngc4_op_sh2p gc4_op_aq gc4_op_an vdd vsrc pch W=2.4e-06 L=5e-07
ngc4_op_sh2n gc4_op_aq gc4_op_an 0 0 nch W=1.2e-06 L=5e-07
ngc4_op_abp gc4_op_aqb gc4_op_aq vdd vsrc pch W=2.4e-06 L=5e-07
ngc4_op_abn gc4_op_aqb gc4_op_aq 0 0 nch W=1.2e-06 L=5e-07
rgc4_op_dr gc4_op_aq gc4_op_ad 1e+06
cgc4_op_dc gc4_op_ad 0 3.3e-07
ngc4_op_d2p gc4_op_adn gc4_op_ad vdd vsrc pch W=2.4e-06 L=5e-07
ngc4_op_d2n gc4_op_adn gc4_op_ad 0 0 nch W=1.2e-06 L=5e-07
ngc4_op_gpa gc4_op_pb gc4_op_aq vdd vsrc pch W=2.4e-06 L=5e-07
ngc4_op_gpb gc4_op_pb gc4_op_adn vdd vsrc pch W=2.4e-06 L=5e-07
ngc4_op_gna gc4_op_pb gc4_op_aq gc4_op_gx 0 nch W=2.4e-06 L=5e-07
ngc4_op_gnb gc4_op_gx gc4_op_adn 0 0 nch W=2.4e-06 L=5e-07
ngc4_op_op gc4_op_p gc4_op_pb vdd vsrc pch W=2.4e-06 L=5e-07
ngc4_op_on gc4_op_p gc4_op_pb 0 0 nch W=1.2e-06 L=5e-07
nhsw1_sw hsw1_sd gw1_col_qb vdd vsrc pch W=4e-06 L=5e-07
rhsw1_rr hsw1_sd hsw1_h1 100000
chsw1_c1 hsw1_h1 0 1e-06
rhsw1_r2 hsw1_h1 hw1 1e+06
chsw1_c2 hw1 0 4.7e-07
rhsw1_rl hw1 0 4.7e+06
nhsw2_sw hsw2_sd gw2_col_qb vdd vsrc pch W=4e-06 L=5e-07
rhsw2_rr hsw2_sd hsw2_h1 100000
chsw2_c1 hsw2_h1 0 1e-06
rhsw2_r2 hsw2_h1 hw2 1e+06
chsw2_c2 hw2 0 4.7e-07
rhsw2_rl hw2 0 4.7e+06
nthw12f_st_mh thw12f_mi hw1 thw12f_st_x 0 nch W=2e-06 L=4e-06
nthw12f_st_mp thw12f_st_x gw2_op_aq 0 0 nch W=4e-06 L=1e-06
cthw12f_cm thw12f_vm 0 1.5e-06
va_rthw12f_rm_n vrest rthw12f_rm_n 0
rthw12f_rm thw12f_vm rthw12f_rm_n 1e+06
rthw12f_kb vdd thw12f_knb 1e+06
nthw12f_kmb thw12f_knb thw12f_knb 0 0 nch W=4e-06 L=4e-06
nthw12f_kmt thw12f_ktail thw12f_knb 0 0 nch W=4e-06 L=4e-06
nthw12f_km1 thw12f_kd1 thw12f_vm thw12f_ktail 0 nch W=4e-06 L=4e-06
nthw12f_km2 thw12f_ko1 thw12f_h thw12f_ktail 0 nch W=4e-06 L=4e-06
nthw12f_km3 thw12f_kd1 thw12f_kd1 vdd vsrc pch W=4e-06 L=4e-06
nthw12f_km4 thw12f_ko1 thw12f_kd1 vdd vsrc pch W=4e-06 L=4e-06
nthw12f_kporclamp thw12f_ko1 por_hold 0 0 nch W=4e-06 L=1e-06
nthw12f_ki1p thw12f_qb thw12f_ko1 vdd vsrc pch W=2.4e-06 L=5e-07
nthw12f_ki1n thw12f_qb thw12f_ko1 0 0 nch W=1.2e-06 L=5e-07
nthw12f_ki2p thw12f_q thw12f_qb vdd vsrc pch W=2.4e-06 L=5e-07
nthw12f_ki2n thw12f_q thw12f_qb 0 0 nch W=1.2e-06 L=5e-07
rthw12f_hra thw12f_h vthr 1e+06
rthw12f_hrf thw12f_h thw12f_qb 1.9e+07
cthw12f_hc thw12f_h 0 2.1e-09
nthw12f_dis thw12f_vm thw12f_q thw12f_vmd 0 nch W=4e-06 L=1e-06
va_rthw12f_rdis_n vrest rthw12f_rdis_n 0
rthw12f_rdis thw12f_vmd rthw12f_rdis_n 12000
nthw12f_rp thw12f_rt thw12f_qb vdd vsrc pch W=2e-06 L=1e-06
rthw12f_rrc thw12f_rt thw12f_rec 10000
cthw12f_rc thw12f_rec 0 1e-07
rthw12f_rr thw12f_rec 0 8.2e+06
nthw12f_sh1 thw12f_vm thw12f_rec thw12f_vms 0 nch W=2e-06 L=1e-06
va_nthw12f_sh2_s vrest nthw12f_sh2_s 0
nthw12f_sh2 thw12f_vms thw12f_qb nthw12f_sh2_s 0 nch W=2e-06 L=1e-06
nthw12f_porh thw12f_h por_hold vthr 0 nch W=2e-06 L=1e-06
va_nthw12f_porm_s vrest nthw12f_porm_s 0
nthw12f_porm thw12f_vm por_hold nthw12f_porm_s 0 nch W=2e-06 L=1e-06
nthw12f_op_tsw thw12f_op_tt thw12f_qb vdd vsrc pch W=2e-06 L=1e-06
rthw12f_op_trc thw12f_op_tt thw12f_op_at 10000
cthw12f_op_tc thw12f_op_at 0 1e-07
rthw12f_op_trl thw12f_op_at 0 2.2e+07
nthw12f_op_sh1p thw12f_op_an thw12f_op_at vdd vsrc pch W=2.4e-06 L=5e-07
nthw12f_op_sh1n thw12f_op_an thw12f_op_at 0 0 nch W=1.2e-06 L=5e-07
nthw12f_op_sh2p thw12f_op_aq thw12f_op_an vdd vsrc pch W=2.4e-06 L=5e-07
nthw12f_op_sh2n thw12f_op_aq thw12f_op_an 0 0 nch W=1.2e-06 L=5e-07
nthw12f_op_abp thw12f_op_aqb thw12f_op_aq vdd vsrc pch W=2.4e-06 L=5e-07
nthw12f_op_abn thw12f_op_aqb thw12f_op_aq 0 0 nch W=1.2e-06 L=5e-07
rthw12f_op_dr thw12f_op_aq thw12f_op_ad 1e+06
cthw12f_op_dc thw12f_op_ad 0 3.3e-07
nthw12f_op_d2p thw12f_op_adn thw12f_op_ad vdd vsrc pch W=2.4e-06 L=5e-07
nthw12f_op_d2n thw12f_op_adn thw12f_op_ad 0 0 nch W=1.2e-06 L=5e-07
nthw12f_op_gpa thw12f_op_pb thw12f_op_aq vdd vsrc pch W=2.4e-06 L=5e-07
nthw12f_op_gpb thw12f_op_pb thw12f_op_adn vdd vsrc pch W=2.4e-06 L=5e-07
nthw12f_op_gna thw12f_op_pb thw12f_op_aq thw12f_op_gx 0 nch W=2.4e-06 L=5e-07
nthw12f_op_gnb thw12f_op_gx thw12f_op_adn 0 0 nch W=2.4e-06 L=5e-07
nthw12f_op_op thw12f_op_p thw12f_op_pb vdd vsrc pch W=2.4e-06 L=5e-07
nthw12f_op_on thw12f_op_p thw12f_op_pb 0 0 nch W=1.2e-06 L=5e-07
nthw12f_rm_md thw12f_mi thw12f_mi vdd vsrc pch W=4e-06 L=2e-06
nthw12f_rm_mo thw12f_vm thw12f_mi vdd vsrc pch W=1e-06 L=8e-06
nthw12r_st_mh thw12r_mi hw2 thw12r_st_x 0 nch W=2e-06 L=4e-06
nthw12r_st_mp thw12r_st_x gw1_op_aq 0 0 nch W=4e-06 L=1e-06
cthw12r_cm thw12r_vm 0 1.5e-06
va_rthw12r_rm_n vrest rthw12r_rm_n 0
rthw12r_rm thw12r_vm rthw12r_rm_n 1e+06
rthw12r_kb vdd thw12r_knb 1e+06
nthw12r_kmb thw12r_knb thw12r_knb 0 0 nch W=4e-06 L=4e-06
nthw12r_kmt thw12r_ktail thw12r_knb 0 0 nch W=4e-06 L=4e-06
nthw12r_km1 thw12r_kd1 thw12r_vm thw12r_ktail 0 nch W=4e-06 L=4e-06
nthw12r_km2 thw12r_ko1 thw12r_h thw12r_ktail 0 nch W=4e-06 L=4e-06
nthw12r_km3 thw12r_kd1 thw12r_kd1 vdd vsrc pch W=4e-06 L=4e-06
nthw12r_km4 thw12r_ko1 thw12r_kd1 vdd vsrc pch W=4e-06 L=4e-06
nthw12r_kporclamp thw12r_ko1 por_hold 0 0 nch W=4e-06 L=1e-06
nthw12r_ki1p thw12r_qb thw12r_ko1 vdd vsrc pch W=2.4e-06 L=5e-07
nthw12r_ki1n thw12r_qb thw12r_ko1 0 0 nch W=1.2e-06 L=5e-07
nthw12r_ki2p thw12r_q thw12r_qb vdd vsrc pch W=2.4e-06 L=5e-07
nthw12r_ki2n thw12r_q thw12r_qb 0 0 nch W=1.2e-06 L=5e-07
rthw12r_hra thw12r_h vthr 1e+06
rthw12r_hrf thw12r_h thw12r_qb 1.9e+07
cthw12r_hc thw12r_h 0 2.1e-09
nthw12r_dis thw12r_vm thw12r_q thw12r_vmd 0 nch W=4e-06 L=1e-06
va_rthw12r_rdis_n vrest rthw12r_rdis_n 0
rthw12r_rdis thw12r_vmd rthw12r_rdis_n 12000
nthw12r_rp thw12r_rt thw12r_qb vdd vsrc pch W=2e-06 L=1e-06
rthw12r_rrc thw12r_rt thw12r_rec 10000
cthw12r_rc thw12r_rec 0 1e-07
rthw12r_rr thw12r_rec 0 8.2e+06
nthw12r_sh1 thw12r_vm thw12r_rec thw12r_vms 0 nch W=2e-06 L=1e-06
va_nthw12r_sh2_s vrest nthw12r_sh2_s 0
nthw12r_sh2 thw12r_vms thw12r_qb nthw12r_sh2_s 0 nch W=2e-06 L=1e-06
nthw12r_porh thw12r_h por_hold vthr 0 nch W=2e-06 L=1e-06
va_nthw12r_porm_s vrest nthw12r_porm_s 0
nthw12r_porm thw12r_vm por_hold nthw12r_porm_s 0 nch W=2e-06 L=1e-06
nthw12r_op_tsw thw12r_op_tt thw12r_qb vdd vsrc pch W=2e-06 L=1e-06
rthw12r_op_trc thw12r_op_tt thw12r_op_at 10000
cthw12r_op_tc thw12r_op_at 0 1e-07
rthw12r_op_trl thw12r_op_at 0 2.2e+07
nthw12r_op_sh1p thw12r_op_an thw12r_op_at vdd vsrc pch W=2.4e-06 L=5e-07
nthw12r_op_sh1n thw12r_op_an thw12r_op_at 0 0 nch W=1.2e-06 L=5e-07
nthw12r_op_sh2p thw12r_op_aq thw12r_op_an vdd vsrc pch W=2.4e-06 L=5e-07
nthw12r_op_sh2n thw12r_op_aq thw12r_op_an 0 0 nch W=1.2e-06 L=5e-07
nthw12r_op_abp thw12r_op_aqb thw12r_op_aq vdd vsrc pch W=2.4e-06 L=5e-07
nthw12r_op_abn thw12r_op_aqb thw12r_op_aq 0 0 nch W=1.2e-06 L=5e-07
rthw12r_op_dr thw12r_op_aq thw12r_op_ad 1e+06
cthw12r_op_dc thw12r_op_ad 0 3.3e-07
nthw12r_op_d2p thw12r_op_adn thw12r_op_ad vdd vsrc pch W=2.4e-06 L=5e-07
nthw12r_op_d2n thw12r_op_adn thw12r_op_ad 0 0 nch W=1.2e-06 L=5e-07
nthw12r_op_gpa thw12r_op_pb thw12r_op_aq vdd vsrc pch W=2.4e-06 L=5e-07
nthw12r_op_gpb thw12r_op_pb thw12r_op_adn vdd vsrc pch W=2.4e-06 L=5e-07
nthw12r_op_gna thw12r_op_pb thw12r_op_aq thw12r_op_gx 0 nch W=2.4e-06 L=5e-07
nthw12r_op_gnb thw12r_op_gx thw12r_op_adn 0 0 nch W=2.4e-06 L=5e-07
nthw12r_op_op thw12r_op_p thw12r_op_pb vdd vsrc pch W=2.4e-06 L=5e-07
nthw12r_op_on thw12r_op_p thw12r_op_pb 0 0 nch W=1.2e-06 L=5e-07
nthw12r_rm_md thw12r_mi thw12r_mi vdd vsrc pch W=4e-06 L=2e-06
nthw12r_rm_mo thw12r_vm thw12r_mi vdd vsrc pch W=1e-06 L=8e-06
nhsw3_sw hsw3_sd gw3_col_qb vdd vsrc pch W=4e-06 L=5e-07
rhsw3_rr hsw3_sd hsw3_h1 100000
chsw3_c1 hsw3_h1 0 1e-06
rhsw3_r2 hsw3_h1 hw3 1e+06
chsw3_c2 hw3 0 4.7e-07
rhsw3_rl hw3 0 4.7e+06
nthw23f_st_mh thw23f_mi hw2 thw23f_st_x 0 nch W=2e-06 L=4e-06
nthw23f_st_mp thw23f_st_x gw3_op_aq 0 0 nch W=4e-06 L=1e-06
cthw23f_cm thw23f_vm 0 1.5e-06
va_rthw23f_rm_n vrest rthw23f_rm_n 0
rthw23f_rm thw23f_vm rthw23f_rm_n 1e+06
rthw23f_kb vdd thw23f_knb 1e+06
nthw23f_kmb thw23f_knb thw23f_knb 0 0 nch W=4e-06 L=4e-06
nthw23f_kmt thw23f_ktail thw23f_knb 0 0 nch W=4e-06 L=4e-06
nthw23f_km1 thw23f_kd1 thw23f_vm thw23f_ktail 0 nch W=4e-06 L=4e-06
nthw23f_km2 thw23f_ko1 thw23f_h thw23f_ktail 0 nch W=4e-06 L=4e-06
nthw23f_km3 thw23f_kd1 thw23f_kd1 vdd vsrc pch W=4e-06 L=4e-06
nthw23f_km4 thw23f_ko1 thw23f_kd1 vdd vsrc pch W=4e-06 L=4e-06
nthw23f_kporclamp thw23f_ko1 por_hold 0 0 nch W=4e-06 L=1e-06
nthw23f_ki1p thw23f_qb thw23f_ko1 vdd vsrc pch W=2.4e-06 L=5e-07
nthw23f_ki1n thw23f_qb thw23f_ko1 0 0 nch W=1.2e-06 L=5e-07
nthw23f_ki2p thw23f_q thw23f_qb vdd vsrc pch W=2.4e-06 L=5e-07
nthw23f_ki2n thw23f_q thw23f_qb 0 0 nch W=1.2e-06 L=5e-07
rthw23f_hra thw23f_h vthr 1e+06
rthw23f_hrf thw23f_h thw23f_qb 1.9e+07
cthw23f_hc thw23f_h 0 2.1e-09
nthw23f_dis thw23f_vm thw23f_q thw23f_vmd 0 nch W=4e-06 L=1e-06
va_rthw23f_rdis_n vrest rthw23f_rdis_n 0
rthw23f_rdis thw23f_vmd rthw23f_rdis_n 12000
nthw23f_rp thw23f_rt thw23f_qb vdd vsrc pch W=2e-06 L=1e-06
rthw23f_rrc thw23f_rt thw23f_rec 10000
cthw23f_rc thw23f_rec 0 1e-07
rthw23f_rr thw23f_rec 0 8.2e+06
nthw23f_sh1 thw23f_vm thw23f_rec thw23f_vms 0 nch W=2e-06 L=1e-06
va_nthw23f_sh2_s vrest nthw23f_sh2_s 0
nthw23f_sh2 thw23f_vms thw23f_qb nthw23f_sh2_s 0 nch W=2e-06 L=1e-06
nthw23f_porh thw23f_h por_hold vthr 0 nch W=2e-06 L=1e-06
va_nthw23f_porm_s vrest nthw23f_porm_s 0
nthw23f_porm thw23f_vm por_hold nthw23f_porm_s 0 nch W=2e-06 L=1e-06
nthw23f_op_tsw thw23f_op_tt thw23f_qb vdd vsrc pch W=2e-06 L=1e-06
rthw23f_op_trc thw23f_op_tt thw23f_op_at 10000
cthw23f_op_tc thw23f_op_at 0 1e-07
rthw23f_op_trl thw23f_op_at 0 2.2e+07
nthw23f_op_sh1p thw23f_op_an thw23f_op_at vdd vsrc pch W=2.4e-06 L=5e-07
nthw23f_op_sh1n thw23f_op_an thw23f_op_at 0 0 nch W=1.2e-06 L=5e-07
nthw23f_op_sh2p thw23f_op_aq thw23f_op_an vdd vsrc pch W=2.4e-06 L=5e-07
nthw23f_op_sh2n thw23f_op_aq thw23f_op_an 0 0 nch W=1.2e-06 L=5e-07
nthw23f_op_abp thw23f_op_aqb thw23f_op_aq vdd vsrc pch W=2.4e-06 L=5e-07
nthw23f_op_abn thw23f_op_aqb thw23f_op_aq 0 0 nch W=1.2e-06 L=5e-07
rthw23f_op_dr thw23f_op_aq thw23f_op_ad 1e+06
cthw23f_op_dc thw23f_op_ad 0 3.3e-07
nthw23f_op_d2p thw23f_op_adn thw23f_op_ad vdd vsrc pch W=2.4e-06 L=5e-07
nthw23f_op_d2n thw23f_op_adn thw23f_op_ad 0 0 nch W=1.2e-06 L=5e-07
nthw23f_op_gpa thw23f_op_pb thw23f_op_aq vdd vsrc pch W=2.4e-06 L=5e-07
nthw23f_op_gpb thw23f_op_pb thw23f_op_adn vdd vsrc pch W=2.4e-06 L=5e-07
nthw23f_op_gna thw23f_op_pb thw23f_op_aq thw23f_op_gx 0 nch W=2.4e-06 L=5e-07
nthw23f_op_gnb thw23f_op_gx thw23f_op_adn 0 0 nch W=2.4e-06 L=5e-07
nthw23f_op_op thw23f_op_p thw23f_op_pb vdd vsrc pch W=2.4e-06 L=5e-07
nthw23f_op_on thw23f_op_p thw23f_op_pb 0 0 nch W=1.2e-06 L=5e-07
nthw23f_rm_md thw23f_mi thw23f_mi vdd vsrc pch W=4e-06 L=2e-06
nthw23f_rm_mo thw23f_vm thw23f_mi vdd vsrc pch W=1e-06 L=8e-06
nthw23r_st_mh thw23r_mi hw3 thw23r_st_x 0 nch W=2e-06 L=4e-06
nthw23r_st_mp thw23r_st_x gw2_op_aq 0 0 nch W=4e-06 L=1e-06
cthw23r_cm thw23r_vm 0 1.5e-06
va_rthw23r_rm_n vrest rthw23r_rm_n 0
rthw23r_rm thw23r_vm rthw23r_rm_n 1e+06
rthw23r_kb vdd thw23r_knb 1e+06
nthw23r_kmb thw23r_knb thw23r_knb 0 0 nch W=4e-06 L=4e-06
nthw23r_kmt thw23r_ktail thw23r_knb 0 0 nch W=4e-06 L=4e-06
nthw23r_km1 thw23r_kd1 thw23r_vm thw23r_ktail 0 nch W=4e-06 L=4e-06
nthw23r_km2 thw23r_ko1 thw23r_h thw23r_ktail 0 nch W=4e-06 L=4e-06
nthw23r_km3 thw23r_kd1 thw23r_kd1 vdd vsrc pch W=4e-06 L=4e-06
nthw23r_km4 thw23r_ko1 thw23r_kd1 vdd vsrc pch W=4e-06 L=4e-06
nthw23r_kporclamp thw23r_ko1 por_hold 0 0 nch W=4e-06 L=1e-06
nthw23r_ki1p thw23r_qb thw23r_ko1 vdd vsrc pch W=2.4e-06 L=5e-07
nthw23r_ki1n thw23r_qb thw23r_ko1 0 0 nch W=1.2e-06 L=5e-07
nthw23r_ki2p thw23r_q thw23r_qb vdd vsrc pch W=2.4e-06 L=5e-07
nthw23r_ki2n thw23r_q thw23r_qb 0 0 nch W=1.2e-06 L=5e-07
rthw23r_hra thw23r_h vthr 1e+06
rthw23r_hrf thw23r_h thw23r_qb 1.9e+07
cthw23r_hc thw23r_h 0 2.1e-09
nthw23r_dis thw23r_vm thw23r_q thw23r_vmd 0 nch W=4e-06 L=1e-06
va_rthw23r_rdis_n vrest rthw23r_rdis_n 0
rthw23r_rdis thw23r_vmd rthw23r_rdis_n 12000
nthw23r_rp thw23r_rt thw23r_qb vdd vsrc pch W=2e-06 L=1e-06
rthw23r_rrc thw23r_rt thw23r_rec 10000
cthw23r_rc thw23r_rec 0 1e-07
rthw23r_rr thw23r_rec 0 8.2e+06
nthw23r_sh1 thw23r_vm thw23r_rec thw23r_vms 0 nch W=2e-06 L=1e-06
va_nthw23r_sh2_s vrest nthw23r_sh2_s 0
nthw23r_sh2 thw23r_vms thw23r_qb nthw23r_sh2_s 0 nch W=2e-06 L=1e-06
nthw23r_porh thw23r_h por_hold vthr 0 nch W=2e-06 L=1e-06
va_nthw23r_porm_s vrest nthw23r_porm_s 0
nthw23r_porm thw23r_vm por_hold nthw23r_porm_s 0 nch W=2e-06 L=1e-06
nthw23r_op_tsw thw23r_op_tt thw23r_qb vdd vsrc pch W=2e-06 L=1e-06
rthw23r_op_trc thw23r_op_tt thw23r_op_at 10000
cthw23r_op_tc thw23r_op_at 0 1e-07
rthw23r_op_trl thw23r_op_at 0 2.2e+07
nthw23r_op_sh1p thw23r_op_an thw23r_op_at vdd vsrc pch W=2.4e-06 L=5e-07
nthw23r_op_sh1n thw23r_op_an thw23r_op_at 0 0 nch W=1.2e-06 L=5e-07
nthw23r_op_sh2p thw23r_op_aq thw23r_op_an vdd vsrc pch W=2.4e-06 L=5e-07
nthw23r_op_sh2n thw23r_op_aq thw23r_op_an 0 0 nch W=1.2e-06 L=5e-07
nthw23r_op_abp thw23r_op_aqb thw23r_op_aq vdd vsrc pch W=2.4e-06 L=5e-07
nthw23r_op_abn thw23r_op_aqb thw23r_op_aq 0 0 nch W=1.2e-06 L=5e-07
rthw23r_op_dr thw23r_op_aq thw23r_op_ad 1e+06
cthw23r_op_dc thw23r_op_ad 0 3.3e-07
nthw23r_op_d2p thw23r_op_adn thw23r_op_ad vdd vsrc pch W=2.4e-06 L=5e-07
nthw23r_op_d2n thw23r_op_adn thw23r_op_ad 0 0 nch W=1.2e-06 L=5e-07
nthw23r_op_gpa thw23r_op_pb thw23r_op_aq vdd vsrc pch W=2.4e-06 L=5e-07
nthw23r_op_gpb thw23r_op_pb thw23r_op_adn vdd vsrc pch W=2.4e-06 L=5e-07
nthw23r_op_gna thw23r_op_pb thw23r_op_aq thw23r_op_gx 0 nch W=2.4e-06 L=5e-07
nthw23r_op_gnb thw23r_op_gx thw23r_op_adn 0 0 nch W=2.4e-06 L=5e-07
nthw23r_op_op thw23r_op_p thw23r_op_pb vdd vsrc pch W=2.4e-06 L=5e-07
nthw23r_op_on thw23r_op_p thw23r_op_pb 0 0 nch W=1.2e-06 L=5e-07
nthw23r_rm_md thw23r_mi thw23r_mi vdd vsrc pch W=4e-06 L=2e-06
nthw23r_rm_mo thw23r_vm thw23r_mi vdd vsrc pch W=1e-06 L=8e-06
nhsw4_sw hsw4_sd gw4_col_qb vdd vsrc pch W=4e-06 L=5e-07
rhsw4_rr hsw4_sd hsw4_h1 100000
chsw4_c1 hsw4_h1 0 1e-06
rhsw4_r2 hsw4_h1 hw4 1e+06
chsw4_c2 hw4 0 4.7e-07
rhsw4_rl hw4 0 4.7e+06
nthw34f_st_mh thw34f_mi hw3 thw34f_st_x 0 nch W=2e-06 L=4e-06
nthw34f_st_mp thw34f_st_x gw4_op_aq 0 0 nch W=4e-06 L=1e-06
cthw34f_cm thw34f_vm 0 1.5e-06
va_rthw34f_rm_n vrest rthw34f_rm_n 0
rthw34f_rm thw34f_vm rthw34f_rm_n 1e+06
rthw34f_kb vdd thw34f_knb 1e+06
nthw34f_kmb thw34f_knb thw34f_knb 0 0 nch W=4e-06 L=4e-06
nthw34f_kmt thw34f_ktail thw34f_knb 0 0 nch W=4e-06 L=4e-06
nthw34f_km1 thw34f_kd1 thw34f_vm thw34f_ktail 0 nch W=4e-06 L=4e-06
nthw34f_km2 thw34f_ko1 thw34f_h thw34f_ktail 0 nch W=4e-06 L=4e-06
nthw34f_km3 thw34f_kd1 thw34f_kd1 vdd vsrc pch W=4e-06 L=4e-06
nthw34f_km4 thw34f_ko1 thw34f_kd1 vdd vsrc pch W=4e-06 L=4e-06
nthw34f_kporclamp thw34f_ko1 por_hold 0 0 nch W=4e-06 L=1e-06
nthw34f_ki1p thw34f_qb thw34f_ko1 vdd vsrc pch W=2.4e-06 L=5e-07
nthw34f_ki1n thw34f_qb thw34f_ko1 0 0 nch W=1.2e-06 L=5e-07
nthw34f_ki2p thw34f_q thw34f_qb vdd vsrc pch W=2.4e-06 L=5e-07
nthw34f_ki2n thw34f_q thw34f_qb 0 0 nch W=1.2e-06 L=5e-07
rthw34f_hra thw34f_h vthr 1e+06
rthw34f_hrf thw34f_h thw34f_qb 1.9e+07
cthw34f_hc thw34f_h 0 2.1e-09
nthw34f_dis thw34f_vm thw34f_q thw34f_vmd 0 nch W=4e-06 L=1e-06
va_rthw34f_rdis_n vrest rthw34f_rdis_n 0
rthw34f_rdis thw34f_vmd rthw34f_rdis_n 12000
nthw34f_rp thw34f_rt thw34f_qb vdd vsrc pch W=2e-06 L=1e-06
rthw34f_rrc thw34f_rt thw34f_rec 10000
cthw34f_rc thw34f_rec 0 1e-07
rthw34f_rr thw34f_rec 0 8.2e+06
nthw34f_sh1 thw34f_vm thw34f_rec thw34f_vms 0 nch W=2e-06 L=1e-06
va_nthw34f_sh2_s vrest nthw34f_sh2_s 0
nthw34f_sh2 thw34f_vms thw34f_qb nthw34f_sh2_s 0 nch W=2e-06 L=1e-06
nthw34f_porh thw34f_h por_hold vthr 0 nch W=2e-06 L=1e-06
va_nthw34f_porm_s vrest nthw34f_porm_s 0
nthw34f_porm thw34f_vm por_hold nthw34f_porm_s 0 nch W=2e-06 L=1e-06
nthw34f_op_tsw thw34f_op_tt thw34f_qb vdd vsrc pch W=2e-06 L=1e-06
rthw34f_op_trc thw34f_op_tt thw34f_op_at 10000
cthw34f_op_tc thw34f_op_at 0 1e-07
rthw34f_op_trl thw34f_op_at 0 2.2e+07
nthw34f_op_sh1p thw34f_op_an thw34f_op_at vdd vsrc pch W=2.4e-06 L=5e-07
nthw34f_op_sh1n thw34f_op_an thw34f_op_at 0 0 nch W=1.2e-06 L=5e-07
nthw34f_op_sh2p thw34f_op_aq thw34f_op_an vdd vsrc pch W=2.4e-06 L=5e-07
nthw34f_op_sh2n thw34f_op_aq thw34f_op_an 0 0 nch W=1.2e-06 L=5e-07
nthw34f_op_abp thw34f_op_aqb thw34f_op_aq vdd vsrc pch W=2.4e-06 L=5e-07
nthw34f_op_abn thw34f_op_aqb thw34f_op_aq 0 0 nch W=1.2e-06 L=5e-07
rthw34f_op_dr thw34f_op_aq thw34f_op_ad 1e+06
cthw34f_op_dc thw34f_op_ad 0 3.3e-07
nthw34f_op_d2p thw34f_op_adn thw34f_op_ad vdd vsrc pch W=2.4e-06 L=5e-07
nthw34f_op_d2n thw34f_op_adn thw34f_op_ad 0 0 nch W=1.2e-06 L=5e-07
nthw34f_op_gpa thw34f_op_pb thw34f_op_aq vdd vsrc pch W=2.4e-06 L=5e-07
nthw34f_op_gpb thw34f_op_pb thw34f_op_adn vdd vsrc pch W=2.4e-06 L=5e-07
nthw34f_op_gna thw34f_op_pb thw34f_op_aq thw34f_op_gx 0 nch W=2.4e-06 L=5e-07
nthw34f_op_gnb thw34f_op_gx thw34f_op_adn 0 0 nch W=2.4e-06 L=5e-07
nthw34f_op_op thw34f_op_p thw34f_op_pb vdd vsrc pch W=2.4e-06 L=5e-07
nthw34f_op_on thw34f_op_p thw34f_op_pb 0 0 nch W=1.2e-06 L=5e-07
nthw34f_rm_md thw34f_mi thw34f_mi vdd vsrc pch W=4e-06 L=2e-06
nthw34f_rm_mo thw34f_vm thw34f_mi vdd vsrc pch W=1e-06 L=8e-06
nthw34r_st_mh thw34r_mi hw4 thw34r_st_x 0 nch W=2e-06 L=4e-06
nthw34r_st_mp thw34r_st_x gw3_op_aq 0 0 nch W=4e-06 L=1e-06
cthw34r_cm thw34r_vm 0 1.5e-06
va_rthw34r_rm_n vrest rthw34r_rm_n 0
rthw34r_rm thw34r_vm rthw34r_rm_n 1e+06
rthw34r_kb vdd thw34r_knb 1e+06
nthw34r_kmb thw34r_knb thw34r_knb 0 0 nch W=4e-06 L=4e-06
nthw34r_kmt thw34r_ktail thw34r_knb 0 0 nch W=4e-06 L=4e-06
nthw34r_km1 thw34r_kd1 thw34r_vm thw34r_ktail 0 nch W=4e-06 L=4e-06
nthw34r_km2 thw34r_ko1 thw34r_h thw34r_ktail 0 nch W=4e-06 L=4e-06
nthw34r_km3 thw34r_kd1 thw34r_kd1 vdd vsrc pch W=4e-06 L=4e-06
nthw34r_km4 thw34r_ko1 thw34r_kd1 vdd vsrc pch W=4e-06 L=4e-06
nthw34r_kporclamp thw34r_ko1 por_hold 0 0 nch W=4e-06 L=1e-06
nthw34r_ki1p thw34r_qb thw34r_ko1 vdd vsrc pch W=2.4e-06 L=5e-07
nthw34r_ki1n thw34r_qb thw34r_ko1 0 0 nch W=1.2e-06 L=5e-07
nthw34r_ki2p thw34r_q thw34r_qb vdd vsrc pch W=2.4e-06 L=5e-07
nthw34r_ki2n thw34r_q thw34r_qb 0 0 nch W=1.2e-06 L=5e-07
rthw34r_hra thw34r_h vthr 1e+06
rthw34r_hrf thw34r_h thw34r_qb 1.9e+07
cthw34r_hc thw34r_h 0 2.1e-09
nthw34r_dis thw34r_vm thw34r_q thw34r_vmd 0 nch W=4e-06 L=1e-06
va_rthw34r_rdis_n vrest rthw34r_rdis_n 0
rthw34r_rdis thw34r_vmd rthw34r_rdis_n 12000
nthw34r_rp thw34r_rt thw34r_qb vdd vsrc pch W=2e-06 L=1e-06
rthw34r_rrc thw34r_rt thw34r_rec 10000
cthw34r_rc thw34r_rec 0 1e-07
rthw34r_rr thw34r_rec 0 8.2e+06
nthw34r_sh1 thw34r_vm thw34r_rec thw34r_vms 0 nch W=2e-06 L=1e-06
va_nthw34r_sh2_s vrest nthw34r_sh2_s 0
nthw34r_sh2 thw34r_vms thw34r_qb nthw34r_sh2_s 0 nch W=2e-06 L=1e-06
nthw34r_porh thw34r_h por_hold vthr 0 nch W=2e-06 L=1e-06
va_nthw34r_porm_s vrest nthw34r_porm_s 0
nthw34r_porm thw34r_vm por_hold nthw34r_porm_s 0 nch W=2e-06 L=1e-06
nthw34r_op_tsw thw34r_op_tt thw34r_qb vdd vsrc pch W=2e-06 L=1e-06
rthw34r_op_trc thw34r_op_tt thw34r_op_at 10000
cthw34r_op_tc thw34r_op_at 0 1e-07
rthw34r_op_trl thw34r_op_at 0 2.2e+07
nthw34r_op_sh1p thw34r_op_an thw34r_op_at vdd vsrc pch W=2.4e-06 L=5e-07
nthw34r_op_sh1n thw34r_op_an thw34r_op_at 0 0 nch W=1.2e-06 L=5e-07
nthw34r_op_sh2p thw34r_op_aq thw34r_op_an vdd vsrc pch W=2.4e-06 L=5e-07
nthw34r_op_sh2n thw34r_op_aq thw34r_op_an 0 0 nch W=1.2e-06 L=5e-07
nthw34r_op_abp thw34r_op_aqb thw34r_op_aq vdd vsrc pch W=2.4e-06 L=5e-07
nthw34r_op_abn thw34r_op_aqb thw34r_op_aq 0 0 nch W=1.2e-06 L=5e-07
rthw34r_op_dr thw34r_op_aq thw34r_op_ad 1e+06
cthw34r_op_dc thw34r_op_ad 0 3.3e-07
nthw34r_op_d2p thw34r_op_adn thw34r_op_ad vdd vsrc pch W=2.4e-06 L=5e-07
nthw34r_op_d2n thw34r_op_adn thw34r_op_ad 0 0 nch W=1.2e-06 L=5e-07
nthw34r_op_gpa thw34r_op_pb thw34r_op_aq vdd vsrc pch W=2.4e-06 L=5e-07
nthw34r_op_gpb thw34r_op_pb thw34r_op_adn vdd vsrc pch W=2.4e-06 L=5e-07
nthw34r_op_gna thw34r_op_pb thw34r_op_aq thw34r_op_gx 0 nch W=2.4e-06 L=5e-07
nthw34r_op_gnb thw34r_op_gx thw34r_op_adn 0 0 nch W=2.4e-06 L=5e-07
nthw34r_op_op thw34r_op_p thw34r_op_pb vdd vsrc pch W=2.4e-06 L=5e-07
nthw34r_op_on thw34r_op_p thw34r_op_pb 0 0 nch W=1.2e-06 L=5e-07
nthw34r_rm_md thw34r_mi thw34r_mi vdd vsrc pch W=4e-06 L=2e-06
nthw34r_rm_mo thw34r_vm thw34r_mi vdd vsrc pch W=1e-06 L=8e-06
cspwc1 spw1 0 1e-07
rspwl1 spw1 vmid 1e+06
nspwi1_eni_p spwi1_ena gw1_op_aqb vdd vsrc pch W=2.4e-06 L=5e-07
nspwi1_eni_n spwi1_ena gw1_op_aqb 0 0 nch W=1.2e-06 L=5e-07
nspwi1_cp spw1 spwi1_cg vdd vsrc pch W=2e-06 L=4e-06
nspwi1_bias irefp_n gw1_op_aqb spwi1_cg vsrc pch W=1.2e-06 L=1e-06
nspwi1_off spwi1_cg spwi1_ena vdd vsrc pch W=2.4e-06 L=1e-06
cspwc2 spw2 0 1e-07
rspwl2 spw2 vmid 1e+06
nspwi2_eni_p spwi2_ena gw2_op_aqb vdd vsrc pch W=2.4e-06 L=5e-07
nspwi2_eni_n spwi2_ena gw2_op_aqb 0 0 nch W=1.2e-06 L=5e-07
nspwi2_cp spw2 spwi2_cg vdd vsrc pch W=2e-06 L=4e-06
nspwi2_bias irefp_n gw2_op_aqb spwi2_cg vsrc pch W=1.2e-06 L=1e-06
nspwi2_off spwi2_cg spwi2_ena vdd vsrc pch W=2.4e-06 L=1e-06
cspwc3 spw3 0 1e-07
rspwl3 spw3 vmid 1e+06
nspwi3_eni_p spwi3_ena gw3_op_aqb vdd vsrc pch W=2.4e-06 L=5e-07
nspwi3_eni_n spwi3_ena gw3_op_aqb 0 0 nch W=1.2e-06 L=5e-07
nspwi3_cp spw3 spwi3_cg vdd vsrc pch W=2e-06 L=4e-06
nspwi3_bias irefp_n gw3_op_aqb spwi3_cg vsrc pch W=1.2e-06 L=1e-06
nspwi3_off spwi3_cg spwi3_ena vdd vsrc pch W=2.4e-06 L=1e-06
cspwc4 spw4 0 1e-07
rspwl4 spw4 vmid 1e+06
nspwi4_eni_p spwi4_ena gw4_op_aqb vdd vsrc pch W=2.4e-06 L=5e-07
nspwi4_eni_n spwi4_ena gw4_op_aqb 0 0 nch W=1.2e-06 L=5e-07
nspwi4_cp spw4 spwi4_cg vdd vsrc pch W=2e-06 L=4e-06
nspwi4_bias irefp_n gw4_op_aqb spwi4_cg vsrc pch W=1.2e-06 L=1e-06
nspwi4_off spwi4_cg spwi4_ena vdd vsrc pch W=2.4e-06 L=1e-06
rspwrs12 spw1 spws12 200000
cspwcs12 spws12 0 1e-12
rspwrt12 spws12 spw2 800000
rspwrs23 spw2 spws23 200000
cspwcs23 spws23 0 1e-12
rspwrt23 spws23 spw3 800000
rspwrs34 spw3 spws34 200000
cspwcs34 spws34 0 1e-12
rspwrt34 spws34 spw4 800000
csgw12f_cm sgw12f_vm 0 1e-07
va_rsgw12f_rm_n vrest rsgw12f_rm_n 0
rsgw12f_rm sgw12f_vm rsgw12f_rm_n 1e+06
rsgw12f_kb vdd sgw12f_knb 1e+06
nsgw12f_kmb sgw12f_knb sgw12f_knb 0 0 nch W=4e-06 L=4e-06
nsgw12f_kmt sgw12f_ktail sgw12f_knb 0 0 nch W=4e-06 L=4e-06
nsgw12f_km1 sgw12f_kd1 sgw12f_vm sgw12f_ktail 0 nch W=4e-06 L=4e-06
nsgw12f_km2 sgw12f_ko1 sgw12f_h sgw12f_ktail 0 nch W=4e-06 L=4e-06
nsgw12f_km3 sgw12f_kd1 sgw12f_kd1 vdd vsrc pch W=4e-06 L=4e-06
nsgw12f_km4 sgw12f_ko1 sgw12f_kd1 vdd vsrc pch W=4e-06 L=4e-06
nsgw12f_kporclamp sgw12f_ko1 por_hold 0 0 nch W=4e-06 L=1e-06
nsgw12f_ki1p sgw12f_qb sgw12f_ko1 vdd vsrc pch W=2.4e-06 L=5e-07
nsgw12f_ki1n sgw12f_qb sgw12f_ko1 0 0 nch W=1.2e-06 L=5e-07
nsgw12f_ki2p sgw12f_q sgw12f_qb vdd vsrc pch W=2.4e-06 L=5e-07
nsgw12f_ki2n sgw12f_q sgw12f_qb 0 0 nch W=1.2e-06 L=5e-07
rsgw12f_hra sgw12f_h vthr 1e+06
rsgw12f_hrf sgw12f_h sgw12f_qb 1.9e+07
csgw12f_hc sgw12f_h 0 2.1e-09
nsgw12f_dis sgw12f_vm sgw12f_q sgw12f_vmd 0 nch W=4e-06 L=1e-06
va_rsgw12f_rdis_n vrest rsgw12f_rdis_n 0
rsgw12f_rdis sgw12f_vmd rsgw12f_rdis_n 75000
nsgw12f_rp sgw12f_rt sgw12f_qb vdd vsrc pch W=2e-06 L=1e-06
rsgw12f_rrc sgw12f_rt sgw12f_rec 10000
csgw12f_rc sgw12f_rec 0 1e-07
rsgw12f_rr sgw12f_rec 0 8.2e+06
nsgw12f_sh1 sgw12f_vm sgw12f_rec sgw12f_vms 0 nch W=2e-06 L=1e-06
va_nsgw12f_sh2_s vrest nsgw12f_sh2_s 0
nsgw12f_sh2 sgw12f_vms sgw12f_qb nsgw12f_sh2_s 0 nch W=2e-06 L=1e-06
nsgw12f_porh sgw12f_h por_hold vthr 0 nch W=2e-06 L=1e-06
va_nsgw12f_porm_s vrest nsgw12f_porm_s 0
nsgw12f_porm sgw12f_vm por_hold nsgw12f_porm_s 0 nch W=2e-06 L=1e-06
nsgw12f_op_tsw sgw12f_op_tt sgw12f_qb vdd vsrc pch W=2e-06 L=1e-06
rsgw12f_op_trc sgw12f_op_tt sgw12f_op_at 10000
csgw12f_op_tc sgw12f_op_at 0 1e-07
rsgw12f_op_trl sgw12f_op_at 0 2.2e+07
nsgw12f_op_sh1p sgw12f_op_an sgw12f_op_at vdd vsrc pch W=2.4e-06 L=5e-07
nsgw12f_op_sh1n sgw12f_op_an sgw12f_op_at 0 0 nch W=1.2e-06 L=5e-07
nsgw12f_op_sh2p sgw12f_op_aq sgw12f_op_an vdd vsrc pch W=2.4e-06 L=5e-07
nsgw12f_op_sh2n sgw12f_op_aq sgw12f_op_an 0 0 nch W=1.2e-06 L=5e-07
nsgw12f_op_abp sgw12f_op_aqb sgw12f_op_aq vdd vsrc pch W=2.4e-06 L=5e-07
nsgw12f_op_abn sgw12f_op_aqb sgw12f_op_aq 0 0 nch W=1.2e-06 L=5e-07
rsgw12f_op_dr sgw12f_op_aq sgw12f_op_ad 1e+06
csgw12f_op_dc sgw12f_op_ad 0 3.3e-07
nsgw12f_op_d2p sgw12f_op_adn sgw12f_op_ad vdd vsrc pch W=2.4e-06 L=5e-07
nsgw12f_op_d2n sgw12f_op_adn sgw12f_op_ad 0 0 nch W=1.2e-06 L=5e-07
nsgw12f_op_gpa sgw12f_op_pb sgw12f_op_aq vdd vsrc pch W=2.4e-06 L=5e-07
nsgw12f_op_gpb sgw12f_op_pb sgw12f_op_adn vdd vsrc pch W=2.4e-06 L=5e-07
nsgw12f_op_gna sgw12f_op_pb sgw12f_op_aq sgw12f_op_gx 0 nch W=2.4e-06 L=5e-07
nsgw12f_op_gnb sgw12f_op_gx sgw12f_op_adn 0 0 nch W=2.4e-06 L=5e-07
nsgw12f_op_op sgw12f_op_p sgw12f_op_pb vdd vsrc pch W=2.4e-06 L=5e-07
nsgw12f_op_on sgw12f_op_p sgw12f_op_pb 0 0 nch W=1.2e-06 L=5e-07
rsgw12f_ota_b vdd sgw12f_ota_nb 3.3e+06
nsgw12f_ota_mb sgw12f_ota_nb sgw12f_ota_nb 0 0 nch W=4e-06 L=4e-06
nsgw12f_ota_mt sgw12f_ota_tail sgw12f_ota_nb 0 0 nch W=4e-06 L=4e-06
nsgw12f_ota_m1 sgw12f_ota_d1 spw1 sgw12f_ota_tail 0 nch W=1e-05 L=2e-06
nsgw12f_ota_m2 sgw12f_vm spws12 sgw12f_ota_tail 0 nch W=1e-05 L=2e-06
nsgw12f_ota_m3 sgw12f_ota_d1 sgw12f_ota_d1 vdd vsrc pch W=1e-05 L=2e-06
nsgw12f_ota_m4 sgw12f_vm sgw12f_ota_d1 vdd vsrc pch W=1e-05 L=2e-06
csgw12r_cm sgw12r_vm 0 1e-07
va_rsgw12r_rm_n vrest rsgw12r_rm_n 0
rsgw12r_rm sgw12r_vm rsgw12r_rm_n 1e+06
rsgw12r_kb vdd sgw12r_knb 1e+06
nsgw12r_kmb sgw12r_knb sgw12r_knb 0 0 nch W=4e-06 L=4e-06
nsgw12r_kmt sgw12r_ktail sgw12r_knb 0 0 nch W=4e-06 L=4e-06
nsgw12r_km1 sgw12r_kd1 sgw12r_vm sgw12r_ktail 0 nch W=4e-06 L=4e-06
nsgw12r_km2 sgw12r_ko1 sgw12r_h sgw12r_ktail 0 nch W=4e-06 L=4e-06
nsgw12r_km3 sgw12r_kd1 sgw12r_kd1 vdd vsrc pch W=4e-06 L=4e-06
nsgw12r_km4 sgw12r_ko1 sgw12r_kd1 vdd vsrc pch W=4e-06 L=4e-06
nsgw12r_kporclamp sgw12r_ko1 por_hold 0 0 nch W=4e-06 L=1e-06
nsgw12r_ki1p sgw12r_qb sgw12r_ko1 vdd vsrc pch W=2.4e-06 L=5e-07
nsgw12r_ki1n sgw12r_qb sgw12r_ko1 0 0 nch W=1.2e-06 L=5e-07
nsgw12r_ki2p sgw12r_q sgw12r_qb vdd vsrc pch W=2.4e-06 L=5e-07
nsgw12r_ki2n sgw12r_q sgw12r_qb 0 0 nch W=1.2e-06 L=5e-07
rsgw12r_hra sgw12r_h vthr 1e+06
rsgw12r_hrf sgw12r_h sgw12r_qb 1.9e+07
csgw12r_hc sgw12r_h 0 2.1e-09
nsgw12r_dis sgw12r_vm sgw12r_q sgw12r_vmd 0 nch W=4e-06 L=1e-06
va_rsgw12r_rdis_n vrest rsgw12r_rdis_n 0
rsgw12r_rdis sgw12r_vmd rsgw12r_rdis_n 75000
nsgw12r_rp sgw12r_rt sgw12r_qb vdd vsrc pch W=2e-06 L=1e-06
rsgw12r_rrc sgw12r_rt sgw12r_rec 10000
csgw12r_rc sgw12r_rec 0 1e-07
rsgw12r_rr sgw12r_rec 0 8.2e+06
nsgw12r_sh1 sgw12r_vm sgw12r_rec sgw12r_vms 0 nch W=2e-06 L=1e-06
va_nsgw12r_sh2_s vrest nsgw12r_sh2_s 0
nsgw12r_sh2 sgw12r_vms sgw12r_qb nsgw12r_sh2_s 0 nch W=2e-06 L=1e-06
nsgw12r_porh sgw12r_h por_hold vthr 0 nch W=2e-06 L=1e-06
va_nsgw12r_porm_s vrest nsgw12r_porm_s 0
nsgw12r_porm sgw12r_vm por_hold nsgw12r_porm_s 0 nch W=2e-06 L=1e-06
nsgw12r_op_tsw sgw12r_op_tt sgw12r_qb vdd vsrc pch W=2e-06 L=1e-06
rsgw12r_op_trc sgw12r_op_tt sgw12r_op_at 10000
csgw12r_op_tc sgw12r_op_at 0 1e-07
rsgw12r_op_trl sgw12r_op_at 0 2.2e+07
nsgw12r_op_sh1p sgw12r_op_an sgw12r_op_at vdd vsrc pch W=2.4e-06 L=5e-07
nsgw12r_op_sh1n sgw12r_op_an sgw12r_op_at 0 0 nch W=1.2e-06 L=5e-07
nsgw12r_op_sh2p sgw12r_op_aq sgw12r_op_an vdd vsrc pch W=2.4e-06 L=5e-07
nsgw12r_op_sh2n sgw12r_op_aq sgw12r_op_an 0 0 nch W=1.2e-06 L=5e-07
nsgw12r_op_abp sgw12r_op_aqb sgw12r_op_aq vdd vsrc pch W=2.4e-06 L=5e-07
nsgw12r_op_abn sgw12r_op_aqb sgw12r_op_aq 0 0 nch W=1.2e-06 L=5e-07
rsgw12r_op_dr sgw12r_op_aq sgw12r_op_ad 1e+06
csgw12r_op_dc sgw12r_op_ad 0 3.3e-07
nsgw12r_op_d2p sgw12r_op_adn sgw12r_op_ad vdd vsrc pch W=2.4e-06 L=5e-07
nsgw12r_op_d2n sgw12r_op_adn sgw12r_op_ad 0 0 nch W=1.2e-06 L=5e-07
nsgw12r_op_gpa sgw12r_op_pb sgw12r_op_aq vdd vsrc pch W=2.4e-06 L=5e-07
nsgw12r_op_gpb sgw12r_op_pb sgw12r_op_adn vdd vsrc pch W=2.4e-06 L=5e-07
nsgw12r_op_gna sgw12r_op_pb sgw12r_op_aq sgw12r_op_gx 0 nch W=2.4e-06 L=5e-07
nsgw12r_op_gnb sgw12r_op_gx sgw12r_op_adn 0 0 nch W=2.4e-06 L=5e-07
nsgw12r_op_op sgw12r_op_p sgw12r_op_pb vdd vsrc pch W=2.4e-06 L=5e-07
nsgw12r_op_on sgw12r_op_p sgw12r_op_pb 0 0 nch W=1.2e-06 L=5e-07
rsgw12r_ota_b vdd sgw12r_ota_nb 3.3e+06
nsgw12r_ota_mb sgw12r_ota_nb sgw12r_ota_nb 0 0 nch W=4e-06 L=4e-06
nsgw12r_ota_mt sgw12r_ota_tail sgw12r_ota_nb 0 0 nch W=4e-06 L=4e-06
nsgw12r_ota_m1 sgw12r_ota_d1 spws12 sgw12r_ota_tail 0 nch W=1e-05 L=2e-06
nsgw12r_ota_m2 sgw12r_vm spw1 sgw12r_ota_tail 0 nch W=1e-05 L=2e-06
nsgw12r_ota_m3 sgw12r_ota_d1 sgw12r_ota_d1 vdd vsrc pch W=1e-05 L=2e-06
nsgw12r_ota_m4 sgw12r_vm sgw12r_ota_d1 vdd vsrc pch W=1e-05 L=2e-06
csgw23f_cm sgw23f_vm 0 1e-07
va_rsgw23f_rm_n vrest rsgw23f_rm_n 0
rsgw23f_rm sgw23f_vm rsgw23f_rm_n 1e+06
rsgw23f_kb vdd sgw23f_knb 1e+06
nsgw23f_kmb sgw23f_knb sgw23f_knb 0 0 nch W=4e-06 L=4e-06
nsgw23f_kmt sgw23f_ktail sgw23f_knb 0 0 nch W=4e-06 L=4e-06
nsgw23f_km1 sgw23f_kd1 sgw23f_vm sgw23f_ktail 0 nch W=4e-06 L=4e-06
nsgw23f_km2 sgw23f_ko1 sgw23f_h sgw23f_ktail 0 nch W=4e-06 L=4e-06
nsgw23f_km3 sgw23f_kd1 sgw23f_kd1 vdd vsrc pch W=4e-06 L=4e-06
nsgw23f_km4 sgw23f_ko1 sgw23f_kd1 vdd vsrc pch W=4e-06 L=4e-06
nsgw23f_kporclamp sgw23f_ko1 por_hold 0 0 nch W=4e-06 L=1e-06
nsgw23f_ki1p sgw23f_qb sgw23f_ko1 vdd vsrc pch W=2.4e-06 L=5e-07
nsgw23f_ki1n sgw23f_qb sgw23f_ko1 0 0 nch W=1.2e-06 L=5e-07
nsgw23f_ki2p sgw23f_q sgw23f_qb vdd vsrc pch W=2.4e-06 L=5e-07
nsgw23f_ki2n sgw23f_q sgw23f_qb 0 0 nch W=1.2e-06 L=5e-07
rsgw23f_hra sgw23f_h vthr 1e+06
rsgw23f_hrf sgw23f_h sgw23f_qb 1.9e+07
csgw23f_hc sgw23f_h 0 2.1e-09
nsgw23f_dis sgw23f_vm sgw23f_q sgw23f_vmd 0 nch W=4e-06 L=1e-06
va_rsgw23f_rdis_n vrest rsgw23f_rdis_n 0
rsgw23f_rdis sgw23f_vmd rsgw23f_rdis_n 75000
nsgw23f_rp sgw23f_rt sgw23f_qb vdd vsrc pch W=2e-06 L=1e-06
rsgw23f_rrc sgw23f_rt sgw23f_rec 10000
csgw23f_rc sgw23f_rec 0 1e-07
rsgw23f_rr sgw23f_rec 0 8.2e+06
nsgw23f_sh1 sgw23f_vm sgw23f_rec sgw23f_vms 0 nch W=2e-06 L=1e-06
va_nsgw23f_sh2_s vrest nsgw23f_sh2_s 0
nsgw23f_sh2 sgw23f_vms sgw23f_qb nsgw23f_sh2_s 0 nch W=2e-06 L=1e-06
nsgw23f_porh sgw23f_h por_hold vthr 0 nch W=2e-06 L=1e-06
va_nsgw23f_porm_s vrest nsgw23f_porm_s 0
nsgw23f_porm sgw23f_vm por_hold nsgw23f_porm_s 0 nch W=2e-06 L=1e-06
nsgw23f_op_tsw sgw23f_op_tt sgw23f_qb vdd vsrc pch W=2e-06 L=1e-06
rsgw23f_op_trc sgw23f_op_tt sgw23f_op_at 10000
csgw23f_op_tc sgw23f_op_at 0 1e-07
rsgw23f_op_trl sgw23f_op_at 0 2.2e+07
nsgw23f_op_sh1p sgw23f_op_an sgw23f_op_at vdd vsrc pch W=2.4e-06 L=5e-07
nsgw23f_op_sh1n sgw23f_op_an sgw23f_op_at 0 0 nch W=1.2e-06 L=5e-07
nsgw23f_op_sh2p sgw23f_op_aq sgw23f_op_an vdd vsrc pch W=2.4e-06 L=5e-07
nsgw23f_op_sh2n sgw23f_op_aq sgw23f_op_an 0 0 nch W=1.2e-06 L=5e-07
nsgw23f_op_abp sgw23f_op_aqb sgw23f_op_aq vdd vsrc pch W=2.4e-06 L=5e-07
nsgw23f_op_abn sgw23f_op_aqb sgw23f_op_aq 0 0 nch W=1.2e-06 L=5e-07
rsgw23f_op_dr sgw23f_op_aq sgw23f_op_ad 1e+06
csgw23f_op_dc sgw23f_op_ad 0 3.3e-07
nsgw23f_op_d2p sgw23f_op_adn sgw23f_op_ad vdd vsrc pch W=2.4e-06 L=5e-07
nsgw23f_op_d2n sgw23f_op_adn sgw23f_op_ad 0 0 nch W=1.2e-06 L=5e-07
nsgw23f_op_gpa sgw23f_op_pb sgw23f_op_aq vdd vsrc pch W=2.4e-06 L=5e-07
nsgw23f_op_gpb sgw23f_op_pb sgw23f_op_adn vdd vsrc pch W=2.4e-06 L=5e-07
nsgw23f_op_gna sgw23f_op_pb sgw23f_op_aq sgw23f_op_gx 0 nch W=2.4e-06 L=5e-07
nsgw23f_op_gnb sgw23f_op_gx sgw23f_op_adn 0 0 nch W=2.4e-06 L=5e-07
nsgw23f_op_op sgw23f_op_p sgw23f_op_pb vdd vsrc pch W=2.4e-06 L=5e-07
nsgw23f_op_on sgw23f_op_p sgw23f_op_pb 0 0 nch W=1.2e-06 L=5e-07
rsgw23f_ota_b vdd sgw23f_ota_nb 3.3e+06
nsgw23f_ota_mb sgw23f_ota_nb sgw23f_ota_nb 0 0 nch W=4e-06 L=4e-06
nsgw23f_ota_mt sgw23f_ota_tail sgw23f_ota_nb 0 0 nch W=4e-06 L=4e-06
nsgw23f_ota_m1 sgw23f_ota_d1 spw2 sgw23f_ota_tail 0 nch W=1e-05 L=2e-06
nsgw23f_ota_m2 sgw23f_vm spws23 sgw23f_ota_tail 0 nch W=1e-05 L=2e-06
nsgw23f_ota_m3 sgw23f_ota_d1 sgw23f_ota_d1 vdd vsrc pch W=1e-05 L=2e-06
nsgw23f_ota_m4 sgw23f_vm sgw23f_ota_d1 vdd vsrc pch W=1e-05 L=2e-06
csgw23r_cm sgw23r_vm 0 1e-07
va_rsgw23r_rm_n vrest rsgw23r_rm_n 0
rsgw23r_rm sgw23r_vm rsgw23r_rm_n 1e+06
rsgw23r_kb vdd sgw23r_knb 1e+06
nsgw23r_kmb sgw23r_knb sgw23r_knb 0 0 nch W=4e-06 L=4e-06
nsgw23r_kmt sgw23r_ktail sgw23r_knb 0 0 nch W=4e-06 L=4e-06
nsgw23r_km1 sgw23r_kd1 sgw23r_vm sgw23r_ktail 0 nch W=4e-06 L=4e-06
nsgw23r_km2 sgw23r_ko1 sgw23r_h sgw23r_ktail 0 nch W=4e-06 L=4e-06
nsgw23r_km3 sgw23r_kd1 sgw23r_kd1 vdd vsrc pch W=4e-06 L=4e-06
nsgw23r_km4 sgw23r_ko1 sgw23r_kd1 vdd vsrc pch W=4e-06 L=4e-06
nsgw23r_kporclamp sgw23r_ko1 por_hold 0 0 nch W=4e-06 L=1e-06
nsgw23r_ki1p sgw23r_qb sgw23r_ko1 vdd vsrc pch W=2.4e-06 L=5e-07
nsgw23r_ki1n sgw23r_qb sgw23r_ko1 0 0 nch W=1.2e-06 L=5e-07
nsgw23r_ki2p sgw23r_q sgw23r_qb vdd vsrc pch W=2.4e-06 L=5e-07
nsgw23r_ki2n sgw23r_q sgw23r_qb 0 0 nch W=1.2e-06 L=5e-07
rsgw23r_hra sgw23r_h vthr 1e+06
rsgw23r_hrf sgw23r_h sgw23r_qb 1.9e+07
csgw23r_hc sgw23r_h 0 2.1e-09
nsgw23r_dis sgw23r_vm sgw23r_q sgw23r_vmd 0 nch W=4e-06 L=1e-06
va_rsgw23r_rdis_n vrest rsgw23r_rdis_n 0
rsgw23r_rdis sgw23r_vmd rsgw23r_rdis_n 75000
nsgw23r_rp sgw23r_rt sgw23r_qb vdd vsrc pch W=2e-06 L=1e-06
rsgw23r_rrc sgw23r_rt sgw23r_rec 10000
csgw23r_rc sgw23r_rec 0 1e-07
rsgw23r_rr sgw23r_rec 0 8.2e+06
nsgw23r_sh1 sgw23r_vm sgw23r_rec sgw23r_vms 0 nch W=2e-06 L=1e-06
va_nsgw23r_sh2_s vrest nsgw23r_sh2_s 0
nsgw23r_sh2 sgw23r_vms sgw23r_qb nsgw23r_sh2_s 0 nch W=2e-06 L=1e-06
nsgw23r_porh sgw23r_h por_hold vthr 0 nch W=2e-06 L=1e-06
va_nsgw23r_porm_s vrest nsgw23r_porm_s 0
nsgw23r_porm sgw23r_vm por_hold nsgw23r_porm_s 0 nch W=2e-06 L=1e-06
nsgw23r_op_tsw sgw23r_op_tt sgw23r_qb vdd vsrc pch W=2e-06 L=1e-06
rsgw23r_op_trc sgw23r_op_tt sgw23r_op_at 10000
csgw23r_op_tc sgw23r_op_at 0 1e-07
rsgw23r_op_trl sgw23r_op_at 0 2.2e+07
nsgw23r_op_sh1p sgw23r_op_an sgw23r_op_at vdd vsrc pch W=2.4e-06 L=5e-07
nsgw23r_op_sh1n sgw23r_op_an sgw23r_op_at 0 0 nch W=1.2e-06 L=5e-07
nsgw23r_op_sh2p sgw23r_op_aq sgw23r_op_an vdd vsrc pch W=2.4e-06 L=5e-07
nsgw23r_op_sh2n sgw23r_op_aq sgw23r_op_an 0 0 nch W=1.2e-06 L=5e-07
nsgw23r_op_abp sgw23r_op_aqb sgw23r_op_aq vdd vsrc pch W=2.4e-06 L=5e-07
nsgw23r_op_abn sgw23r_op_aqb sgw23r_op_aq 0 0 nch W=1.2e-06 L=5e-07
rsgw23r_op_dr sgw23r_op_aq sgw23r_op_ad 1e+06
csgw23r_op_dc sgw23r_op_ad 0 3.3e-07
nsgw23r_op_d2p sgw23r_op_adn sgw23r_op_ad vdd vsrc pch W=2.4e-06 L=5e-07
nsgw23r_op_d2n sgw23r_op_adn sgw23r_op_ad 0 0 nch W=1.2e-06 L=5e-07
nsgw23r_op_gpa sgw23r_op_pb sgw23r_op_aq vdd vsrc pch W=2.4e-06 L=5e-07
nsgw23r_op_gpb sgw23r_op_pb sgw23r_op_adn vdd vsrc pch W=2.4e-06 L=5e-07
nsgw23r_op_gna sgw23r_op_pb sgw23r_op_aq sgw23r_op_gx 0 nch W=2.4e-06 L=5e-07
nsgw23r_op_gnb sgw23r_op_gx sgw23r_op_adn 0 0 nch W=2.4e-06 L=5e-07
nsgw23r_op_op sgw23r_op_p sgw23r_op_pb vdd vsrc pch W=2.4e-06 L=5e-07
nsgw23r_op_on sgw23r_op_p sgw23r_op_pb 0 0 nch W=1.2e-06 L=5e-07
rsgw23r_ota_b vdd sgw23r_ota_nb 3.3e+06
nsgw23r_ota_mb sgw23r_ota_nb sgw23r_ota_nb 0 0 nch W=4e-06 L=4e-06
nsgw23r_ota_mt sgw23r_ota_tail sgw23r_ota_nb 0 0 nch W=4e-06 L=4e-06
nsgw23r_ota_m1 sgw23r_ota_d1 spws23 sgw23r_ota_tail 0 nch W=1e-05 L=2e-06
nsgw23r_ota_m2 sgw23r_vm spw2 sgw23r_ota_tail 0 nch W=1e-05 L=2e-06
nsgw23r_ota_m3 sgw23r_ota_d1 sgw23r_ota_d1 vdd vsrc pch W=1e-05 L=2e-06
nsgw23r_ota_m4 sgw23r_vm sgw23r_ota_d1 vdd vsrc pch W=1e-05 L=2e-06
csgw34f_cm sgw34f_vm 0 1e-07
va_rsgw34f_rm_n vrest rsgw34f_rm_n 0
rsgw34f_rm sgw34f_vm rsgw34f_rm_n 1e+06
rsgw34f_kb vdd sgw34f_knb 1e+06
nsgw34f_kmb sgw34f_knb sgw34f_knb 0 0 nch W=4e-06 L=4e-06
nsgw34f_kmt sgw34f_ktail sgw34f_knb 0 0 nch W=4e-06 L=4e-06
nsgw34f_km1 sgw34f_kd1 sgw34f_vm sgw34f_ktail 0 nch W=4e-06 L=4e-06
nsgw34f_km2 sgw34f_ko1 sgw34f_h sgw34f_ktail 0 nch W=4e-06 L=4e-06
nsgw34f_km3 sgw34f_kd1 sgw34f_kd1 vdd vsrc pch W=4e-06 L=4e-06
nsgw34f_km4 sgw34f_ko1 sgw34f_kd1 vdd vsrc pch W=4e-06 L=4e-06
nsgw34f_kporclamp sgw34f_ko1 por_hold 0 0 nch W=4e-06 L=1e-06
nsgw34f_ki1p sgw34f_qb sgw34f_ko1 vdd vsrc pch W=2.4e-06 L=5e-07
nsgw34f_ki1n sgw34f_qb sgw34f_ko1 0 0 nch W=1.2e-06 L=5e-07
nsgw34f_ki2p sgw34f_q sgw34f_qb vdd vsrc pch W=2.4e-06 L=5e-07
nsgw34f_ki2n sgw34f_q sgw34f_qb 0 0 nch W=1.2e-06 L=5e-07
rsgw34f_hra sgw34f_h vthr 1e+06
rsgw34f_hrf sgw34f_h sgw34f_qb 1.9e+07
csgw34f_hc sgw34f_h 0 2.1e-09
nsgw34f_dis sgw34f_vm sgw34f_q sgw34f_vmd 0 nch W=4e-06 L=1e-06
va_rsgw34f_rdis_n vrest rsgw34f_rdis_n 0
rsgw34f_rdis sgw34f_vmd rsgw34f_rdis_n 75000
nsgw34f_rp sgw34f_rt sgw34f_qb vdd vsrc pch W=2e-06 L=1e-06
rsgw34f_rrc sgw34f_rt sgw34f_rec 10000
csgw34f_rc sgw34f_rec 0 1e-07
rsgw34f_rr sgw34f_rec 0 8.2e+06
nsgw34f_sh1 sgw34f_vm sgw34f_rec sgw34f_vms 0 nch W=2e-06 L=1e-06
va_nsgw34f_sh2_s vrest nsgw34f_sh2_s 0
nsgw34f_sh2 sgw34f_vms sgw34f_qb nsgw34f_sh2_s 0 nch W=2e-06 L=1e-06
nsgw34f_porh sgw34f_h por_hold vthr 0 nch W=2e-06 L=1e-06
va_nsgw34f_porm_s vrest nsgw34f_porm_s 0
nsgw34f_porm sgw34f_vm por_hold nsgw34f_porm_s 0 nch W=2e-06 L=1e-06
nsgw34f_op_tsw sgw34f_op_tt sgw34f_qb vdd vsrc pch W=2e-06 L=1e-06
rsgw34f_op_trc sgw34f_op_tt sgw34f_op_at 10000
csgw34f_op_tc sgw34f_op_at 0 1e-07
rsgw34f_op_trl sgw34f_op_at 0 2.2e+07
nsgw34f_op_sh1p sgw34f_op_an sgw34f_op_at vdd vsrc pch W=2.4e-06 L=5e-07
nsgw34f_op_sh1n sgw34f_op_an sgw34f_op_at 0 0 nch W=1.2e-06 L=5e-07
nsgw34f_op_sh2p sgw34f_op_aq sgw34f_op_an vdd vsrc pch W=2.4e-06 L=5e-07
nsgw34f_op_sh2n sgw34f_op_aq sgw34f_op_an 0 0 nch W=1.2e-06 L=5e-07
nsgw34f_op_abp sgw34f_op_aqb sgw34f_op_aq vdd vsrc pch W=2.4e-06 L=5e-07
nsgw34f_op_abn sgw34f_op_aqb sgw34f_op_aq 0 0 nch W=1.2e-06 L=5e-07
rsgw34f_op_dr sgw34f_op_aq sgw34f_op_ad 1e+06
csgw34f_op_dc sgw34f_op_ad 0 3.3e-07
nsgw34f_op_d2p sgw34f_op_adn sgw34f_op_ad vdd vsrc pch W=2.4e-06 L=5e-07
nsgw34f_op_d2n sgw34f_op_adn sgw34f_op_ad 0 0 nch W=1.2e-06 L=5e-07
nsgw34f_op_gpa sgw34f_op_pb sgw34f_op_aq vdd vsrc pch W=2.4e-06 L=5e-07
nsgw34f_op_gpb sgw34f_op_pb sgw34f_op_adn vdd vsrc pch W=2.4e-06 L=5e-07
nsgw34f_op_gna sgw34f_op_pb sgw34f_op_aq sgw34f_op_gx 0 nch W=2.4e-06 L=5e-07
nsgw34f_op_gnb sgw34f_op_gx sgw34f_op_adn 0 0 nch W=2.4e-06 L=5e-07
nsgw34f_op_op sgw34f_op_p sgw34f_op_pb vdd vsrc pch W=2.4e-06 L=5e-07
nsgw34f_op_on sgw34f_op_p sgw34f_op_pb 0 0 nch W=1.2e-06 L=5e-07
rsgw34f_ota_b vdd sgw34f_ota_nb 3.3e+06
nsgw34f_ota_mb sgw34f_ota_nb sgw34f_ota_nb 0 0 nch W=4e-06 L=4e-06
nsgw34f_ota_mt sgw34f_ota_tail sgw34f_ota_nb 0 0 nch W=4e-06 L=4e-06
nsgw34f_ota_m1 sgw34f_ota_d1 spw3 sgw34f_ota_tail 0 nch W=1e-05 L=2e-06
nsgw34f_ota_m2 sgw34f_vm spws34 sgw34f_ota_tail 0 nch W=1e-05 L=2e-06
nsgw34f_ota_m3 sgw34f_ota_d1 sgw34f_ota_d1 vdd vsrc pch W=1e-05 L=2e-06
nsgw34f_ota_m4 sgw34f_vm sgw34f_ota_d1 vdd vsrc pch W=1e-05 L=2e-06
csgw34r_cm sgw34r_vm 0 1e-07
va_rsgw34r_rm_n vrest rsgw34r_rm_n 0
rsgw34r_rm sgw34r_vm rsgw34r_rm_n 1e+06
rsgw34r_kb vdd sgw34r_knb 1e+06
nsgw34r_kmb sgw34r_knb sgw34r_knb 0 0 nch W=4e-06 L=4e-06
nsgw34r_kmt sgw34r_ktail sgw34r_knb 0 0 nch W=4e-06 L=4e-06
nsgw34r_km1 sgw34r_kd1 sgw34r_vm sgw34r_ktail 0 nch W=4e-06 L=4e-06
nsgw34r_km2 sgw34r_ko1 sgw34r_h sgw34r_ktail 0 nch W=4e-06 L=4e-06
nsgw34r_km3 sgw34r_kd1 sgw34r_kd1 vdd vsrc pch W=4e-06 L=4e-06
nsgw34r_km4 sgw34r_ko1 sgw34r_kd1 vdd vsrc pch W=4e-06 L=4e-06
nsgw34r_kporclamp sgw34r_ko1 por_hold 0 0 nch W=4e-06 L=1e-06
nsgw34r_ki1p sgw34r_qb sgw34r_ko1 vdd vsrc pch W=2.4e-06 L=5e-07
nsgw34r_ki1n sgw34r_qb sgw34r_ko1 0 0 nch W=1.2e-06 L=5e-07
nsgw34r_ki2p sgw34r_q sgw34r_qb vdd vsrc pch W=2.4e-06 L=5e-07
nsgw34r_ki2n sgw34r_q sgw34r_qb 0 0 nch W=1.2e-06 L=5e-07
rsgw34r_hra sgw34r_h vthr 1e+06
rsgw34r_hrf sgw34r_h sgw34r_qb 1.9e+07
csgw34r_hc sgw34r_h 0 2.1e-09
nsgw34r_dis sgw34r_vm sgw34r_q sgw34r_vmd 0 nch W=4e-06 L=1e-06
va_rsgw34r_rdis_n vrest rsgw34r_rdis_n 0
rsgw34r_rdis sgw34r_vmd rsgw34r_rdis_n 75000
nsgw34r_rp sgw34r_rt sgw34r_qb vdd vsrc pch W=2e-06 L=1e-06
rsgw34r_rrc sgw34r_rt sgw34r_rec 10000
csgw34r_rc sgw34r_rec 0 1e-07
rsgw34r_rr sgw34r_rec 0 8.2e+06
nsgw34r_sh1 sgw34r_vm sgw34r_rec sgw34r_vms 0 nch W=2e-06 L=1e-06
va_nsgw34r_sh2_s vrest nsgw34r_sh2_s 0
nsgw34r_sh2 sgw34r_vms sgw34r_qb nsgw34r_sh2_s 0 nch W=2e-06 L=1e-06
nsgw34r_porh sgw34r_h por_hold vthr 0 nch W=2e-06 L=1e-06
va_nsgw34r_porm_s vrest nsgw34r_porm_s 0
nsgw34r_porm sgw34r_vm por_hold nsgw34r_porm_s 0 nch W=2e-06 L=1e-06
nsgw34r_op_tsw sgw34r_op_tt sgw34r_qb vdd vsrc pch W=2e-06 L=1e-06
rsgw34r_op_trc sgw34r_op_tt sgw34r_op_at 10000
csgw34r_op_tc sgw34r_op_at 0 1e-07
rsgw34r_op_trl sgw34r_op_at 0 2.2e+07
nsgw34r_op_sh1p sgw34r_op_an sgw34r_op_at vdd vsrc pch W=2.4e-06 L=5e-07
nsgw34r_op_sh1n sgw34r_op_an sgw34r_op_at 0 0 nch W=1.2e-06 L=5e-07
nsgw34r_op_sh2p sgw34r_op_aq sgw34r_op_an vdd vsrc pch W=2.4e-06 L=5e-07
nsgw34r_op_sh2n sgw34r_op_aq sgw34r_op_an 0 0 nch W=1.2e-06 L=5e-07
nsgw34r_op_abp sgw34r_op_aqb sgw34r_op_aq vdd vsrc pch W=2.4e-06 L=5e-07
nsgw34r_op_abn sgw34r_op_aqb sgw34r_op_aq 0 0 nch W=1.2e-06 L=5e-07
rsgw34r_op_dr sgw34r_op_aq sgw34r_op_ad 1e+06
csgw34r_op_dc sgw34r_op_ad 0 3.3e-07
nsgw34r_op_d2p sgw34r_op_adn sgw34r_op_ad vdd vsrc pch W=2.4e-06 L=5e-07
nsgw34r_op_d2n sgw34r_op_adn sgw34r_op_ad 0 0 nch W=1.2e-06 L=5e-07
nsgw34r_op_gpa sgw34r_op_pb sgw34r_op_aq vdd vsrc pch W=2.4e-06 L=5e-07
nsgw34r_op_gpb sgw34r_op_pb sgw34r_op_adn vdd vsrc pch W=2.4e-06 L=5e-07
nsgw34r_op_gna sgw34r_op_pb sgw34r_op_aq sgw34r_op_gx 0 nch W=2.4e-06 L=5e-07
nsgw34r_op_gnb sgw34r_op_gx sgw34r_op_adn 0 0 nch W=2.4e-06 L=5e-07
nsgw34r_op_op sgw34r_op_p sgw34r_op_pb vdd vsrc pch W=2.4e-06 L=5e-07
nsgw34r_op_on sgw34r_op_p sgw34r_op_pb 0 0 nch W=1.2e-06 L=5e-07
rsgw34r_ota_b vdd sgw34r_ota_nb 3.3e+06
nsgw34r_ota_mb sgw34r_ota_nb sgw34r_ota_nb 0 0 nch W=4e-06 L=4e-06
nsgw34r_ota_mt sgw34r_ota_tail sgw34r_ota_nb 0 0 nch W=4e-06 L=4e-06
nsgw34r_ota_m1 sgw34r_ota_d1 spws34 sgw34r_ota_tail 0 nch W=1e-05 L=2e-06
nsgw34r_ota_m2 sgw34r_vm spw3 sgw34r_ota_tail 0 nch W=1e-05 L=2e-06
nsgw34r_ota_m3 sgw34r_ota_d1 sgw34r_ota_d1 vdd vsrc pch W=1e-05 L=2e-06
nsgw34r_ota_m4 sgw34r_vm sgw34r_ota_d1 vdd vsrc pch W=1e-05 L=2e-06
ncdw12f_hsf_sw cdw12f_hsf_sd sgw12f_op_aqb vdd vsrc pch W=4e-06 L=5e-07
rcdw12f_hsf_rr cdw12f_hsf_sd cdw12f_hsf_h1 100000
ccdw12f_hsf_c1 cdw12f_hsf_h1 0 1e-06
rcdw12f_hsf_r2 cdw12f_hsf_h1 cdw12f_hs 1e+06
ccdw12f_hsf_c2 cdw12f_hs 0 4.7e-07
rcdw12f_hsf_rl cdw12f_hs 0 4.7e+06
ncdw12f_hcf_sw cdw12f_hcf_sd sgw12r_op_aqb vdd vsrc pch W=4e-06 L=5e-07
rcdw12f_hcf_rr cdw12f_hcf_sd cdw12f_hcf_h1 100000
ccdw12f_hcf_c1 cdw12f_hcf_h1 0 1e-06
rcdw12f_hcf_r2 cdw12f_hcf_h1 cdw12f_hc 1e+06
ccdw12f_hcf_c2 cdw12f_hc 0 4.7e-07
rcdw12f_hcf_rl cdw12f_hc 0 4.7e+06
ccdw12f_cm cdw12f_vm 0 1.5e-06
va_rcdw12f_rm_n vrest rcdw12f_rm_n 0
rcdw12f_rm cdw12f_vm rcdw12f_rm_n 1e+06
rcdw12f_kb vdd cdw12f_knb 1e+06
ncdw12f_kmb cdw12f_knb cdw12f_knb 0 0 nch W=4e-06 L=4e-06
ncdw12f_kmt cdw12f_ktail cdw12f_knb 0 0 nch W=4e-06 L=4e-06
ncdw12f_km1 cdw12f_kd1 cdw12f_vm cdw12f_ktail 0 nch W=4e-06 L=4e-06
ncdw12f_km2 cdw12f_ko1 cdw12f_h cdw12f_ktail 0 nch W=4e-06 L=4e-06
ncdw12f_km3 cdw12f_kd1 cdw12f_kd1 vdd vsrc pch W=4e-06 L=4e-06
ncdw12f_km4 cdw12f_ko1 cdw12f_kd1 vdd vsrc pch W=4e-06 L=4e-06
ncdw12f_kporclamp cdw12f_ko1 por_hold 0 0 nch W=4e-06 L=1e-06
ncdw12f_ki1p cdw12f_qb cdw12f_ko1 vdd vsrc pch W=2.4e-06 L=5e-07
ncdw12f_ki1n cdw12f_qb cdw12f_ko1 0 0 nch W=1.2e-06 L=5e-07
ncdw12f_ki2p cdw12f_q cdw12f_qb vdd vsrc pch W=2.4e-06 L=5e-07
ncdw12f_ki2n cdw12f_q cdw12f_qb 0 0 nch W=1.2e-06 L=5e-07
rcdw12f_hra cdw12f_h vthr 1e+06
rcdw12f_hrf cdw12f_h cdw12f_qb 1.9e+07
ccdw12f_hc cdw12f_h 0 2.1e-09
ncdw12f_dis cdw12f_vm cdw12f_q cdw12f_vmd 0 nch W=4e-06 L=1e-06
va_rcdw12f_rdis_n vrest rcdw12f_rdis_n 0
rcdw12f_rdis cdw12f_vmd rcdw12f_rdis_n 12000
ncdw12f_rp cdw12f_rt cdw12f_qb vdd vsrc pch W=2e-06 L=1e-06
rcdw12f_rrc cdw12f_rt cdw12f_rec 10000
ccdw12f_rc cdw12f_rec 0 1e-07
rcdw12f_rr cdw12f_rec 0 8.2e+06
ncdw12f_sh1 cdw12f_vm cdw12f_rec cdw12f_vms 0 nch W=2e-06 L=1e-06
va_ncdw12f_sh2_s vrest ncdw12f_sh2_s 0
ncdw12f_sh2 cdw12f_vms cdw12f_qb ncdw12f_sh2_s 0 nch W=2e-06 L=1e-06
ncdw12f_porh cdw12f_h por_hold vthr 0 nch W=2e-06 L=1e-06
va_ncdw12f_porm_s vrest ncdw12f_porm_s 0
ncdw12f_porm cdw12f_vm por_hold ncdw12f_porm_s 0 nch W=2e-06 L=1e-06
ncdw12f_op_tsw cdw12f_op_tt cdw12f_qb vdd vsrc pch W=2e-06 L=1e-06
rcdw12f_op_trc cdw12f_op_tt cdw12f_op_at 10000
ccdw12f_op_tc cdw12f_op_at 0 1e-07
rcdw12f_op_trl cdw12f_op_at 0 2.2e+07
ncdw12f_op_sh1p cdw12f_op_an cdw12f_op_at vdd vsrc pch W=2.4e-06 L=5e-07
ncdw12f_op_sh1n cdw12f_op_an cdw12f_op_at 0 0 nch W=1.2e-06 L=5e-07
ncdw12f_op_sh2p cdw12f_op_aq cdw12f_op_an vdd vsrc pch W=2.4e-06 L=5e-07
ncdw12f_op_sh2n cdw12f_op_aq cdw12f_op_an 0 0 nch W=1.2e-06 L=5e-07
ncdw12f_op_abp cdw12f_op_aqb cdw12f_op_aq vdd vsrc pch W=2.4e-06 L=5e-07
ncdw12f_op_abn cdw12f_op_aqb cdw12f_op_aq 0 0 nch W=1.2e-06 L=5e-07
rcdw12f_op_dr cdw12f_op_aq cdw12f_op_ad 1e+06
ccdw12f_op_dc cdw12f_op_ad 0 3.3e-07
ncdw12f_op_d2p cdw12f_op_adn cdw12f_op_ad vdd vsrc pch W=2.4e-06 L=5e-07
ncdw12f_op_d2n cdw12f_op_adn cdw12f_op_ad 0 0 nch W=1.2e-06 L=5e-07
ncdw12f_op_gpa cdw12f_op_pb cdw12f_op_aq vdd vsrc pch W=2.4e-06 L=5e-07
ncdw12f_op_gpb cdw12f_op_pb cdw12f_op_adn vdd vsrc pch W=2.4e-06 L=5e-07
ncdw12f_op_gna cdw12f_op_pb cdw12f_op_aq cdw12f_op_gx 0 nch W=2.4e-06 L=5e-07
ncdw12f_op_gnb cdw12f_op_gx cdw12f_op_adn 0 0 nch W=2.4e-06 L=5e-07
ncdw12f_op_op cdw12f_op_p cdw12f_op_pb vdd vsrc pch W=2.4e-06 L=5e-07
ncdw12f_op_on cdw12f_op_p cdw12f_op_pb 0 0 nch W=1.2e-06 L=5e-07
ncdw12f_st_mh cdw12f_mi cdw12f_hs cdw12f_st_x 0 nch W=2e-06 L=4e-06
ncdw12f_st_mp cdw12f_st_x thw12f_op_aq 0 0 nch W=4e-06 L=1e-06
ncdw12f_rm_md cdw12f_mi cdw12f_mi vdd vsrc pch W=4e-06 L=2e-06
ncdw12f_rm_mo cdw12f_vm cdw12f_mi vdd vsrc pch W=1e-06 L=8e-06
ncdw12f_kh cdw12f_vm cdw12f_hc cdw12f_kx 0 nch W=2e-06 L=4e-06
va_ncdw12f_kp_s vrest ncdw12f_kp_s 0
ncdw12f_kp cdw12f_kx thw12f_op_aq ncdw12f_kp_s 0 nch W=4e-06 L=1e-06
ncdw12r_hsf_sw cdw12r_hsf_sd sgw12r_op_aqb vdd vsrc pch W=4e-06 L=5e-07
rcdw12r_hsf_rr cdw12r_hsf_sd cdw12r_hsf_h1 100000
ccdw12r_hsf_c1 cdw12r_hsf_h1 0 1e-06
rcdw12r_hsf_r2 cdw12r_hsf_h1 cdw12r_hs 1e+06
ccdw12r_hsf_c2 cdw12r_hs 0 4.7e-07
rcdw12r_hsf_rl cdw12r_hs 0 4.7e+06
ncdw12r_hcf_sw cdw12r_hcf_sd sgw12f_op_aqb vdd vsrc pch W=4e-06 L=5e-07
rcdw12r_hcf_rr cdw12r_hcf_sd cdw12r_hcf_h1 100000
ccdw12r_hcf_c1 cdw12r_hcf_h1 0 1e-06
rcdw12r_hcf_r2 cdw12r_hcf_h1 cdw12r_hc 1e+06
ccdw12r_hcf_c2 cdw12r_hc 0 4.7e-07
rcdw12r_hcf_rl cdw12r_hc 0 4.7e+06
ccdw12r_cm cdw12r_vm 0 1.5e-06
va_rcdw12r_rm_n vrest rcdw12r_rm_n 0
rcdw12r_rm cdw12r_vm rcdw12r_rm_n 1e+06
rcdw12r_kb vdd cdw12r_knb 1e+06
ncdw12r_kmb cdw12r_knb cdw12r_knb 0 0 nch W=4e-06 L=4e-06
ncdw12r_kmt cdw12r_ktail cdw12r_knb 0 0 nch W=4e-06 L=4e-06
ncdw12r_km1 cdw12r_kd1 cdw12r_vm cdw12r_ktail 0 nch W=4e-06 L=4e-06
ncdw12r_km2 cdw12r_ko1 cdw12r_h cdw12r_ktail 0 nch W=4e-06 L=4e-06
ncdw12r_km3 cdw12r_kd1 cdw12r_kd1 vdd vsrc pch W=4e-06 L=4e-06
ncdw12r_km4 cdw12r_ko1 cdw12r_kd1 vdd vsrc pch W=4e-06 L=4e-06
ncdw12r_kporclamp cdw12r_ko1 por_hold 0 0 nch W=4e-06 L=1e-06
ncdw12r_ki1p cdw12r_qb cdw12r_ko1 vdd vsrc pch W=2.4e-06 L=5e-07
ncdw12r_ki1n cdw12r_qb cdw12r_ko1 0 0 nch W=1.2e-06 L=5e-07
ncdw12r_ki2p cdw12r_q cdw12r_qb vdd vsrc pch W=2.4e-06 L=5e-07
ncdw12r_ki2n cdw12r_q cdw12r_qb 0 0 nch W=1.2e-06 L=5e-07
rcdw12r_hra cdw12r_h vthr 1e+06
rcdw12r_hrf cdw12r_h cdw12r_qb 1.9e+07
ccdw12r_hc cdw12r_h 0 2.1e-09
ncdw12r_dis cdw12r_vm cdw12r_q cdw12r_vmd 0 nch W=4e-06 L=1e-06
va_rcdw12r_rdis_n vrest rcdw12r_rdis_n 0
rcdw12r_rdis cdw12r_vmd rcdw12r_rdis_n 12000
ncdw12r_rp cdw12r_rt cdw12r_qb vdd vsrc pch W=2e-06 L=1e-06
rcdw12r_rrc cdw12r_rt cdw12r_rec 10000
ccdw12r_rc cdw12r_rec 0 1e-07
rcdw12r_rr cdw12r_rec 0 8.2e+06
ncdw12r_sh1 cdw12r_vm cdw12r_rec cdw12r_vms 0 nch W=2e-06 L=1e-06
va_ncdw12r_sh2_s vrest ncdw12r_sh2_s 0
ncdw12r_sh2 cdw12r_vms cdw12r_qb ncdw12r_sh2_s 0 nch W=2e-06 L=1e-06
ncdw12r_porh cdw12r_h por_hold vthr 0 nch W=2e-06 L=1e-06
va_ncdw12r_porm_s vrest ncdw12r_porm_s 0
ncdw12r_porm cdw12r_vm por_hold ncdw12r_porm_s 0 nch W=2e-06 L=1e-06
ncdw12r_op_tsw cdw12r_op_tt cdw12r_qb vdd vsrc pch W=2e-06 L=1e-06
rcdw12r_op_trc cdw12r_op_tt cdw12r_op_at 10000
ccdw12r_op_tc cdw12r_op_at 0 1e-07
rcdw12r_op_trl cdw12r_op_at 0 2.2e+07
ncdw12r_op_sh1p cdw12r_op_an cdw12r_op_at vdd vsrc pch W=2.4e-06 L=5e-07
ncdw12r_op_sh1n cdw12r_op_an cdw12r_op_at 0 0 nch W=1.2e-06 L=5e-07
ncdw12r_op_sh2p cdw12r_op_aq cdw12r_op_an vdd vsrc pch W=2.4e-06 L=5e-07
ncdw12r_op_sh2n cdw12r_op_aq cdw12r_op_an 0 0 nch W=1.2e-06 L=5e-07
ncdw12r_op_abp cdw12r_op_aqb cdw12r_op_aq vdd vsrc pch W=2.4e-06 L=5e-07
ncdw12r_op_abn cdw12r_op_aqb cdw12r_op_aq 0 0 nch W=1.2e-06 L=5e-07
rcdw12r_op_dr cdw12r_op_aq cdw12r_op_ad 1e+06
ccdw12r_op_dc cdw12r_op_ad 0 3.3e-07
ncdw12r_op_d2p cdw12r_op_adn cdw12r_op_ad vdd vsrc pch W=2.4e-06 L=5e-07
ncdw12r_op_d2n cdw12r_op_adn cdw12r_op_ad 0 0 nch W=1.2e-06 L=5e-07
ncdw12r_op_gpa cdw12r_op_pb cdw12r_op_aq vdd vsrc pch W=2.4e-06 L=5e-07
ncdw12r_op_gpb cdw12r_op_pb cdw12r_op_adn vdd vsrc pch W=2.4e-06 L=5e-07
ncdw12r_op_gna cdw12r_op_pb cdw12r_op_aq cdw12r_op_gx 0 nch W=2.4e-06 L=5e-07
ncdw12r_op_gnb cdw12r_op_gx cdw12r_op_adn 0 0 nch W=2.4e-06 L=5e-07
ncdw12r_op_op cdw12r_op_p cdw12r_op_pb vdd vsrc pch W=2.4e-06 L=5e-07
ncdw12r_op_on cdw12r_op_p cdw12r_op_pb 0 0 nch W=1.2e-06 L=5e-07
ncdw12r_st_mh cdw12r_mi cdw12r_hs cdw12r_st_x 0 nch W=2e-06 L=4e-06
ncdw12r_st_mp cdw12r_st_x thw12r_op_aq 0 0 nch W=4e-06 L=1e-06
ncdw12r_rm_md cdw12r_mi cdw12r_mi vdd vsrc pch W=4e-06 L=2e-06
ncdw12r_rm_mo cdw12r_vm cdw12r_mi vdd vsrc pch W=1e-06 L=8e-06
ncdw12r_kh cdw12r_vm cdw12r_hc cdw12r_kx 0 nch W=2e-06 L=4e-06
va_ncdw12r_kp_s vrest ncdw12r_kp_s 0
ncdw12r_kp cdw12r_kx thw12r_op_aq ncdw12r_kp_s 0 nch W=4e-06 L=1e-06
ncdw23f_hsf_sw cdw23f_hsf_sd sgw23f_op_aqb vdd vsrc pch W=4e-06 L=5e-07
rcdw23f_hsf_rr cdw23f_hsf_sd cdw23f_hsf_h1 100000
ccdw23f_hsf_c1 cdw23f_hsf_h1 0 1e-06
rcdw23f_hsf_r2 cdw23f_hsf_h1 cdw23f_hs 1e+06
ccdw23f_hsf_c2 cdw23f_hs 0 4.7e-07
rcdw23f_hsf_rl cdw23f_hs 0 4.7e+06
ncdw23f_hcf_sw cdw23f_hcf_sd sgw23r_op_aqb vdd vsrc pch W=4e-06 L=5e-07
rcdw23f_hcf_rr cdw23f_hcf_sd cdw23f_hcf_h1 100000
ccdw23f_hcf_c1 cdw23f_hcf_h1 0 1e-06
rcdw23f_hcf_r2 cdw23f_hcf_h1 cdw23f_hc 1e+06
ccdw23f_hcf_c2 cdw23f_hc 0 4.7e-07
rcdw23f_hcf_rl cdw23f_hc 0 4.7e+06
ccdw23f_cm cdw23f_vm 0 1.5e-06
va_rcdw23f_rm_n vrest rcdw23f_rm_n 0
rcdw23f_rm cdw23f_vm rcdw23f_rm_n 1e+06
rcdw23f_kb vdd cdw23f_knb 1e+06
ncdw23f_kmb cdw23f_knb cdw23f_knb 0 0 nch W=4e-06 L=4e-06
ncdw23f_kmt cdw23f_ktail cdw23f_knb 0 0 nch W=4e-06 L=4e-06
ncdw23f_km1 cdw23f_kd1 cdw23f_vm cdw23f_ktail 0 nch W=4e-06 L=4e-06
ncdw23f_km2 cdw23f_ko1 cdw23f_h cdw23f_ktail 0 nch W=4e-06 L=4e-06
ncdw23f_km3 cdw23f_kd1 cdw23f_kd1 vdd vsrc pch W=4e-06 L=4e-06
ncdw23f_km4 cdw23f_ko1 cdw23f_kd1 vdd vsrc pch W=4e-06 L=4e-06
ncdw23f_kporclamp cdw23f_ko1 por_hold 0 0 nch W=4e-06 L=1e-06
ncdw23f_ki1p cdw23f_qb cdw23f_ko1 vdd vsrc pch W=2.4e-06 L=5e-07
ncdw23f_ki1n cdw23f_qb cdw23f_ko1 0 0 nch W=1.2e-06 L=5e-07
ncdw23f_ki2p cdw23f_q cdw23f_qb vdd vsrc pch W=2.4e-06 L=5e-07
ncdw23f_ki2n cdw23f_q cdw23f_qb 0 0 nch W=1.2e-06 L=5e-07
rcdw23f_hra cdw23f_h vthr 1e+06
rcdw23f_hrf cdw23f_h cdw23f_qb 1.9e+07
ccdw23f_hc cdw23f_h 0 2.1e-09
ncdw23f_dis cdw23f_vm cdw23f_q cdw23f_vmd 0 nch W=4e-06 L=1e-06
va_rcdw23f_rdis_n vrest rcdw23f_rdis_n 0
rcdw23f_rdis cdw23f_vmd rcdw23f_rdis_n 12000
ncdw23f_rp cdw23f_rt cdw23f_qb vdd vsrc pch W=2e-06 L=1e-06
rcdw23f_rrc cdw23f_rt cdw23f_rec 10000
ccdw23f_rc cdw23f_rec 0 1e-07
rcdw23f_rr cdw23f_rec 0 8.2e+06
ncdw23f_sh1 cdw23f_vm cdw23f_rec cdw23f_vms 0 nch W=2e-06 L=1e-06
va_ncdw23f_sh2_s vrest ncdw23f_sh2_s 0
ncdw23f_sh2 cdw23f_vms cdw23f_qb ncdw23f_sh2_s 0 nch W=2e-06 L=1e-06
ncdw23f_porh cdw23f_h por_hold vthr 0 nch W=2e-06 L=1e-06
va_ncdw23f_porm_s vrest ncdw23f_porm_s 0
ncdw23f_porm cdw23f_vm por_hold ncdw23f_porm_s 0 nch W=2e-06 L=1e-06
ncdw23f_op_tsw cdw23f_op_tt cdw23f_qb vdd vsrc pch W=2e-06 L=1e-06
rcdw23f_op_trc cdw23f_op_tt cdw23f_op_at 10000
ccdw23f_op_tc cdw23f_op_at 0 1e-07
rcdw23f_op_trl cdw23f_op_at 0 2.2e+07
ncdw23f_op_sh1p cdw23f_op_an cdw23f_op_at vdd vsrc pch W=2.4e-06 L=5e-07
ncdw23f_op_sh1n cdw23f_op_an cdw23f_op_at 0 0 nch W=1.2e-06 L=5e-07
ncdw23f_op_sh2p cdw23f_op_aq cdw23f_op_an vdd vsrc pch W=2.4e-06 L=5e-07
ncdw23f_op_sh2n cdw23f_op_aq cdw23f_op_an 0 0 nch W=1.2e-06 L=5e-07
ncdw23f_op_abp cdw23f_op_aqb cdw23f_op_aq vdd vsrc pch W=2.4e-06 L=5e-07
ncdw23f_op_abn cdw23f_op_aqb cdw23f_op_aq 0 0 nch W=1.2e-06 L=5e-07
rcdw23f_op_dr cdw23f_op_aq cdw23f_op_ad 1e+06
ccdw23f_op_dc cdw23f_op_ad 0 3.3e-07
ncdw23f_op_d2p cdw23f_op_adn cdw23f_op_ad vdd vsrc pch W=2.4e-06 L=5e-07
ncdw23f_op_d2n cdw23f_op_adn cdw23f_op_ad 0 0 nch W=1.2e-06 L=5e-07
ncdw23f_op_gpa cdw23f_op_pb cdw23f_op_aq vdd vsrc pch W=2.4e-06 L=5e-07
ncdw23f_op_gpb cdw23f_op_pb cdw23f_op_adn vdd vsrc pch W=2.4e-06 L=5e-07
ncdw23f_op_gna cdw23f_op_pb cdw23f_op_aq cdw23f_op_gx 0 nch W=2.4e-06 L=5e-07
ncdw23f_op_gnb cdw23f_op_gx cdw23f_op_adn 0 0 nch W=2.4e-06 L=5e-07
ncdw23f_op_op cdw23f_op_p cdw23f_op_pb vdd vsrc pch W=2.4e-06 L=5e-07
ncdw23f_op_on cdw23f_op_p cdw23f_op_pb 0 0 nch W=1.2e-06 L=5e-07
ncdw23f_st_mh cdw23f_mi cdw23f_hs cdw23f_st_x 0 nch W=2e-06 L=4e-06
ncdw23f_st_mp cdw23f_st_x thw23f_op_aq 0 0 nch W=4e-06 L=1e-06
ncdw23f_rm_md cdw23f_mi cdw23f_mi vdd vsrc pch W=4e-06 L=2e-06
ncdw23f_rm_mo cdw23f_vm cdw23f_mi vdd vsrc pch W=1e-06 L=8e-06
ncdw23f_kh cdw23f_vm cdw23f_hc cdw23f_kx 0 nch W=2e-06 L=4e-06
va_ncdw23f_kp_s vrest ncdw23f_kp_s 0
ncdw23f_kp cdw23f_kx thw23f_op_aq ncdw23f_kp_s 0 nch W=4e-06 L=1e-06
ncdw23r_hsf_sw cdw23r_hsf_sd sgw23r_op_aqb vdd vsrc pch W=4e-06 L=5e-07
rcdw23r_hsf_rr cdw23r_hsf_sd cdw23r_hsf_h1 100000
ccdw23r_hsf_c1 cdw23r_hsf_h1 0 1e-06
rcdw23r_hsf_r2 cdw23r_hsf_h1 cdw23r_hs 1e+06
ccdw23r_hsf_c2 cdw23r_hs 0 4.7e-07
rcdw23r_hsf_rl cdw23r_hs 0 4.7e+06
ncdw23r_hcf_sw cdw23r_hcf_sd sgw23f_op_aqb vdd vsrc pch W=4e-06 L=5e-07
rcdw23r_hcf_rr cdw23r_hcf_sd cdw23r_hcf_h1 100000
ccdw23r_hcf_c1 cdw23r_hcf_h1 0 1e-06
rcdw23r_hcf_r2 cdw23r_hcf_h1 cdw23r_hc 1e+06
ccdw23r_hcf_c2 cdw23r_hc 0 4.7e-07
rcdw23r_hcf_rl cdw23r_hc 0 4.7e+06
ccdw23r_cm cdw23r_vm 0 1.5e-06
va_rcdw23r_rm_n vrest rcdw23r_rm_n 0
rcdw23r_rm cdw23r_vm rcdw23r_rm_n 1e+06
rcdw23r_kb vdd cdw23r_knb 1e+06
ncdw23r_kmb cdw23r_knb cdw23r_knb 0 0 nch W=4e-06 L=4e-06
ncdw23r_kmt cdw23r_ktail cdw23r_knb 0 0 nch W=4e-06 L=4e-06
ncdw23r_km1 cdw23r_kd1 cdw23r_vm cdw23r_ktail 0 nch W=4e-06 L=4e-06
ncdw23r_km2 cdw23r_ko1 cdw23r_h cdw23r_ktail 0 nch W=4e-06 L=4e-06
ncdw23r_km3 cdw23r_kd1 cdw23r_kd1 vdd vsrc pch W=4e-06 L=4e-06
ncdw23r_km4 cdw23r_ko1 cdw23r_kd1 vdd vsrc pch W=4e-06 L=4e-06
ncdw23r_kporclamp cdw23r_ko1 por_hold 0 0 nch W=4e-06 L=1e-06
ncdw23r_ki1p cdw23r_qb cdw23r_ko1 vdd vsrc pch W=2.4e-06 L=5e-07
ncdw23r_ki1n cdw23r_qb cdw23r_ko1 0 0 nch W=1.2e-06 L=5e-07
ncdw23r_ki2p cdw23r_q cdw23r_qb vdd vsrc pch W=2.4e-06 L=5e-07
ncdw23r_ki2n cdw23r_q cdw23r_qb 0 0 nch W=1.2e-06 L=5e-07
rcdw23r_hra cdw23r_h vthr 1e+06
rcdw23r_hrf cdw23r_h cdw23r_qb 1.9e+07
ccdw23r_hc cdw23r_h 0 2.1e-09
ncdw23r_dis cdw23r_vm cdw23r_q cdw23r_vmd 0 nch W=4e-06 L=1e-06
va_rcdw23r_rdis_n vrest rcdw23r_rdis_n 0
rcdw23r_rdis cdw23r_vmd rcdw23r_rdis_n 12000
ncdw23r_rp cdw23r_rt cdw23r_qb vdd vsrc pch W=2e-06 L=1e-06
rcdw23r_rrc cdw23r_rt cdw23r_rec 10000
ccdw23r_rc cdw23r_rec 0 1e-07
rcdw23r_rr cdw23r_rec 0 8.2e+06
ncdw23r_sh1 cdw23r_vm cdw23r_rec cdw23r_vms 0 nch W=2e-06 L=1e-06
va_ncdw23r_sh2_s vrest ncdw23r_sh2_s 0
ncdw23r_sh2 cdw23r_vms cdw23r_qb ncdw23r_sh2_s 0 nch W=2e-06 L=1e-06
ncdw23r_porh cdw23r_h por_hold vthr 0 nch W=2e-06 L=1e-06
va_ncdw23r_porm_s vrest ncdw23r_porm_s 0
ncdw23r_porm cdw23r_vm por_hold ncdw23r_porm_s 0 nch W=2e-06 L=1e-06
ncdw23r_op_tsw cdw23r_op_tt cdw23r_qb vdd vsrc pch W=2e-06 L=1e-06
rcdw23r_op_trc cdw23r_op_tt cdw23r_op_at 10000
ccdw23r_op_tc cdw23r_op_at 0 1e-07
rcdw23r_op_trl cdw23r_op_at 0 2.2e+07
ncdw23r_op_sh1p cdw23r_op_an cdw23r_op_at vdd vsrc pch W=2.4e-06 L=5e-07
ncdw23r_op_sh1n cdw23r_op_an cdw23r_op_at 0 0 nch W=1.2e-06 L=5e-07
ncdw23r_op_sh2p cdw23r_op_aq cdw23r_op_an vdd vsrc pch W=2.4e-06 L=5e-07
ncdw23r_op_sh2n cdw23r_op_aq cdw23r_op_an 0 0 nch W=1.2e-06 L=5e-07
ncdw23r_op_abp cdw23r_op_aqb cdw23r_op_aq vdd vsrc pch W=2.4e-06 L=5e-07
ncdw23r_op_abn cdw23r_op_aqb cdw23r_op_aq 0 0 nch W=1.2e-06 L=5e-07
rcdw23r_op_dr cdw23r_op_aq cdw23r_op_ad 1e+06
ccdw23r_op_dc cdw23r_op_ad 0 3.3e-07
ncdw23r_op_d2p cdw23r_op_adn cdw23r_op_ad vdd vsrc pch W=2.4e-06 L=5e-07
ncdw23r_op_d2n cdw23r_op_adn cdw23r_op_ad 0 0 nch W=1.2e-06 L=5e-07
ncdw23r_op_gpa cdw23r_op_pb cdw23r_op_aq vdd vsrc pch W=2.4e-06 L=5e-07
ncdw23r_op_gpb cdw23r_op_pb cdw23r_op_adn vdd vsrc pch W=2.4e-06 L=5e-07
ncdw23r_op_gna cdw23r_op_pb cdw23r_op_aq cdw23r_op_gx 0 nch W=2.4e-06 L=5e-07
ncdw23r_op_gnb cdw23r_op_gx cdw23r_op_adn 0 0 nch W=2.4e-06 L=5e-07
ncdw23r_op_op cdw23r_op_p cdw23r_op_pb vdd vsrc pch W=2.4e-06 L=5e-07
ncdw23r_op_on cdw23r_op_p cdw23r_op_pb 0 0 nch W=1.2e-06 L=5e-07
ncdw23r_st_mh cdw23r_mi cdw23r_hs cdw23r_st_x 0 nch W=2e-06 L=4e-06
ncdw23r_st_mp cdw23r_st_x thw23r_op_aq 0 0 nch W=4e-06 L=1e-06
ncdw23r_rm_md cdw23r_mi cdw23r_mi vdd vsrc pch W=4e-06 L=2e-06
ncdw23r_rm_mo cdw23r_vm cdw23r_mi vdd vsrc pch W=1e-06 L=8e-06
ncdw23r_kh cdw23r_vm cdw23r_hc cdw23r_kx 0 nch W=2e-06 L=4e-06
va_ncdw23r_kp_s vrest ncdw23r_kp_s 0
ncdw23r_kp cdw23r_kx thw23r_op_aq ncdw23r_kp_s 0 nch W=4e-06 L=1e-06
ncdw34f_hsf_sw cdw34f_hsf_sd sgw34f_op_aqb vdd vsrc pch W=4e-06 L=5e-07
rcdw34f_hsf_rr cdw34f_hsf_sd cdw34f_hsf_h1 100000
ccdw34f_hsf_c1 cdw34f_hsf_h1 0 1e-06
rcdw34f_hsf_r2 cdw34f_hsf_h1 cdw34f_hs 1e+06
ccdw34f_hsf_c2 cdw34f_hs 0 4.7e-07
rcdw34f_hsf_rl cdw34f_hs 0 4.7e+06
ncdw34f_hcf_sw cdw34f_hcf_sd sgw34r_op_aqb vdd vsrc pch W=4e-06 L=5e-07
rcdw34f_hcf_rr cdw34f_hcf_sd cdw34f_hcf_h1 100000
ccdw34f_hcf_c1 cdw34f_hcf_h1 0 1e-06
rcdw34f_hcf_r2 cdw34f_hcf_h1 cdw34f_hc 1e+06
ccdw34f_hcf_c2 cdw34f_hc 0 4.7e-07
rcdw34f_hcf_rl cdw34f_hc 0 4.7e+06
ccdw34f_cm cdw34f_vm 0 1.5e-06
va_rcdw34f_rm_n vrest rcdw34f_rm_n 0
rcdw34f_rm cdw34f_vm rcdw34f_rm_n 1e+06
rcdw34f_kb vdd cdw34f_knb 1e+06
ncdw34f_kmb cdw34f_knb cdw34f_knb 0 0 nch W=4e-06 L=4e-06
ncdw34f_kmt cdw34f_ktail cdw34f_knb 0 0 nch W=4e-06 L=4e-06
ncdw34f_km1 cdw34f_kd1 cdw34f_vm cdw34f_ktail 0 nch W=4e-06 L=4e-06
ncdw34f_km2 cdw34f_ko1 cdw34f_h cdw34f_ktail 0 nch W=4e-06 L=4e-06
ncdw34f_km3 cdw34f_kd1 cdw34f_kd1 vdd vsrc pch W=4e-06 L=4e-06
ncdw34f_km4 cdw34f_ko1 cdw34f_kd1 vdd vsrc pch W=4e-06 L=4e-06
ncdw34f_kporclamp cdw34f_ko1 por_hold 0 0 nch W=4e-06 L=1e-06
ncdw34f_ki1p cdw34f_qb cdw34f_ko1 vdd vsrc pch W=2.4e-06 L=5e-07
ncdw34f_ki1n cdw34f_qb cdw34f_ko1 0 0 nch W=1.2e-06 L=5e-07
ncdw34f_ki2p cdw34f_q cdw34f_qb vdd vsrc pch W=2.4e-06 L=5e-07
ncdw34f_ki2n cdw34f_q cdw34f_qb 0 0 nch W=1.2e-06 L=5e-07
rcdw34f_hra cdw34f_h vthr 1e+06
rcdw34f_hrf cdw34f_h cdw34f_qb 1.9e+07
ccdw34f_hc cdw34f_h 0 2.1e-09
ncdw34f_dis cdw34f_vm cdw34f_q cdw34f_vmd 0 nch W=4e-06 L=1e-06
va_rcdw34f_rdis_n vrest rcdw34f_rdis_n 0
rcdw34f_rdis cdw34f_vmd rcdw34f_rdis_n 12000
ncdw34f_rp cdw34f_rt cdw34f_qb vdd vsrc pch W=2e-06 L=1e-06
rcdw34f_rrc cdw34f_rt cdw34f_rec 10000
ccdw34f_rc cdw34f_rec 0 1e-07
rcdw34f_rr cdw34f_rec 0 8.2e+06
ncdw34f_sh1 cdw34f_vm cdw34f_rec cdw34f_vms 0 nch W=2e-06 L=1e-06
va_ncdw34f_sh2_s vrest ncdw34f_sh2_s 0
ncdw34f_sh2 cdw34f_vms cdw34f_qb ncdw34f_sh2_s 0 nch W=2e-06 L=1e-06
ncdw34f_porh cdw34f_h por_hold vthr 0 nch W=2e-06 L=1e-06
va_ncdw34f_porm_s vrest ncdw34f_porm_s 0
ncdw34f_porm cdw34f_vm por_hold ncdw34f_porm_s 0 nch W=2e-06 L=1e-06
ncdw34f_op_tsw cdw34f_op_tt cdw34f_qb vdd vsrc pch W=2e-06 L=1e-06
rcdw34f_op_trc cdw34f_op_tt cdw34f_op_at 10000
ccdw34f_op_tc cdw34f_op_at 0 1e-07
rcdw34f_op_trl cdw34f_op_at 0 2.2e+07
ncdw34f_op_sh1p cdw34f_op_an cdw34f_op_at vdd vsrc pch W=2.4e-06 L=5e-07
ncdw34f_op_sh1n cdw34f_op_an cdw34f_op_at 0 0 nch W=1.2e-06 L=5e-07
ncdw34f_op_sh2p cdw34f_op_aq cdw34f_op_an vdd vsrc pch W=2.4e-06 L=5e-07
ncdw34f_op_sh2n cdw34f_op_aq cdw34f_op_an 0 0 nch W=1.2e-06 L=5e-07
ncdw34f_op_abp cdw34f_op_aqb cdw34f_op_aq vdd vsrc pch W=2.4e-06 L=5e-07
ncdw34f_op_abn cdw34f_op_aqb cdw34f_op_aq 0 0 nch W=1.2e-06 L=5e-07
rcdw34f_op_dr cdw34f_op_aq cdw34f_op_ad 1e+06
ccdw34f_op_dc cdw34f_op_ad 0 3.3e-07
ncdw34f_op_d2p cdw34f_op_adn cdw34f_op_ad vdd vsrc pch W=2.4e-06 L=5e-07
ncdw34f_op_d2n cdw34f_op_adn cdw34f_op_ad 0 0 nch W=1.2e-06 L=5e-07
ncdw34f_op_gpa cdw34f_op_pb cdw34f_op_aq vdd vsrc pch W=2.4e-06 L=5e-07
ncdw34f_op_gpb cdw34f_op_pb cdw34f_op_adn vdd vsrc pch W=2.4e-06 L=5e-07
ncdw34f_op_gna cdw34f_op_pb cdw34f_op_aq cdw34f_op_gx 0 nch W=2.4e-06 L=5e-07
ncdw34f_op_gnb cdw34f_op_gx cdw34f_op_adn 0 0 nch W=2.4e-06 L=5e-07
ncdw34f_op_op cdw34f_op_p cdw34f_op_pb vdd vsrc pch W=2.4e-06 L=5e-07
ncdw34f_op_on cdw34f_op_p cdw34f_op_pb 0 0 nch W=1.2e-06 L=5e-07
ncdw34f_st_mh cdw34f_mi cdw34f_hs cdw34f_st_x 0 nch W=2e-06 L=4e-06
ncdw34f_st_mp cdw34f_st_x thw34f_op_aq 0 0 nch W=4e-06 L=1e-06
ncdw34f_rm_md cdw34f_mi cdw34f_mi vdd vsrc pch W=4e-06 L=2e-06
ncdw34f_rm_mo cdw34f_vm cdw34f_mi vdd vsrc pch W=1e-06 L=8e-06
ncdw34f_kh cdw34f_vm cdw34f_hc cdw34f_kx 0 nch W=2e-06 L=4e-06
va_ncdw34f_kp_s vrest ncdw34f_kp_s 0
ncdw34f_kp cdw34f_kx thw34f_op_aq ncdw34f_kp_s 0 nch W=4e-06 L=1e-06
ncdw34r_hsf_sw cdw34r_hsf_sd sgw34r_op_aqb vdd vsrc pch W=4e-06 L=5e-07
rcdw34r_hsf_rr cdw34r_hsf_sd cdw34r_hsf_h1 100000
ccdw34r_hsf_c1 cdw34r_hsf_h1 0 1e-06
rcdw34r_hsf_r2 cdw34r_hsf_h1 cdw34r_hs 1e+06
ccdw34r_hsf_c2 cdw34r_hs 0 4.7e-07
rcdw34r_hsf_rl cdw34r_hs 0 4.7e+06
ncdw34r_hcf_sw cdw34r_hcf_sd sgw34f_op_aqb vdd vsrc pch W=4e-06 L=5e-07
rcdw34r_hcf_rr cdw34r_hcf_sd cdw34r_hcf_h1 100000
ccdw34r_hcf_c1 cdw34r_hcf_h1 0 1e-06
rcdw34r_hcf_r2 cdw34r_hcf_h1 cdw34r_hc 1e+06
ccdw34r_hcf_c2 cdw34r_hc 0 4.7e-07
rcdw34r_hcf_rl cdw34r_hc 0 4.7e+06
ccdw34r_cm cdw34r_vm 0 1.5e-06
va_rcdw34r_rm_n vrest rcdw34r_rm_n 0
rcdw34r_rm cdw34r_vm rcdw34r_rm_n 1e+06
rcdw34r_kb vdd cdw34r_knb 1e+06
ncdw34r_kmb cdw34r_knb cdw34r_knb 0 0 nch W=4e-06 L=4e-06
ncdw34r_kmt cdw34r_ktail cdw34r_knb 0 0 nch W=4e-06 L=4e-06
ncdw34r_km1 cdw34r_kd1 cdw34r_vm cdw34r_ktail 0 nch W=4e-06 L=4e-06
ncdw34r_km2 cdw34r_ko1 cdw34r_h cdw34r_ktail 0 nch W=4e-06 L=4e-06
ncdw34r_km3 cdw34r_kd1 cdw34r_kd1 vdd vsrc pch W=4e-06 L=4e-06
ncdw34r_km4 cdw34r_ko1 cdw34r_kd1 vdd vsrc pch W=4e-06 L=4e-06
ncdw34r_kporclamp cdw34r_ko1 por_hold 0 0 nch W=4e-06 L=1e-06
ncdw34r_ki1p cdw34r_qb cdw34r_ko1 vdd vsrc pch W=2.4e-06 L=5e-07
ncdw34r_ki1n cdw34r_qb cdw34r_ko1 0 0 nch W=1.2e-06 L=5e-07
ncdw34r_ki2p cdw34r_q cdw34r_qb vdd vsrc pch W=2.4e-06 L=5e-07
ncdw34r_ki2n cdw34r_q cdw34r_qb 0 0 nch W=1.2e-06 L=5e-07
rcdw34r_hra cdw34r_h vthr 1e+06
rcdw34r_hrf cdw34r_h cdw34r_qb 1.9e+07
ccdw34r_hc cdw34r_h 0 2.1e-09
ncdw34r_dis cdw34r_vm cdw34r_q cdw34r_vmd 0 nch W=4e-06 L=1e-06
va_rcdw34r_rdis_n vrest rcdw34r_rdis_n 0
rcdw34r_rdis cdw34r_vmd rcdw34r_rdis_n 12000
ncdw34r_rp cdw34r_rt cdw34r_qb vdd vsrc pch W=2e-06 L=1e-06
rcdw34r_rrc cdw34r_rt cdw34r_rec 10000
ccdw34r_rc cdw34r_rec 0 1e-07
rcdw34r_rr cdw34r_rec 0 8.2e+06
ncdw34r_sh1 cdw34r_vm cdw34r_rec cdw34r_vms 0 nch W=2e-06 L=1e-06
va_ncdw34r_sh2_s vrest ncdw34r_sh2_s 0
ncdw34r_sh2 cdw34r_vms cdw34r_qb ncdw34r_sh2_s 0 nch W=2e-06 L=1e-06
ncdw34r_porh cdw34r_h por_hold vthr 0 nch W=2e-06 L=1e-06
va_ncdw34r_porm_s vrest ncdw34r_porm_s 0
ncdw34r_porm cdw34r_vm por_hold ncdw34r_porm_s 0 nch W=2e-06 L=1e-06
ncdw34r_op_tsw cdw34r_op_tt cdw34r_qb vdd vsrc pch W=2e-06 L=1e-06
rcdw34r_op_trc cdw34r_op_tt cdw34r_op_at 10000
ccdw34r_op_tc cdw34r_op_at 0 1e-07
rcdw34r_op_trl cdw34r_op_at 0 2.2e+07
ncdw34r_op_sh1p cdw34r_op_an cdw34r_op_at vdd vsrc pch W=2.4e-06 L=5e-07
ncdw34r_op_sh1n cdw34r_op_an cdw34r_op_at 0 0 nch W=1.2e-06 L=5e-07
ncdw34r_op_sh2p cdw34r_op_aq cdw34r_op_an vdd vsrc pch W=2.4e-06 L=5e-07
ncdw34r_op_sh2n cdw34r_op_aq cdw34r_op_an 0 0 nch W=1.2e-06 L=5e-07
ncdw34r_op_abp cdw34r_op_aqb cdw34r_op_aq vdd vsrc pch W=2.4e-06 L=5e-07
ncdw34r_op_abn cdw34r_op_aqb cdw34r_op_aq 0 0 nch W=1.2e-06 L=5e-07
rcdw34r_op_dr cdw34r_op_aq cdw34r_op_ad 1e+06
ccdw34r_op_dc cdw34r_op_ad 0 3.3e-07
ncdw34r_op_d2p cdw34r_op_adn cdw34r_op_ad vdd vsrc pch W=2.4e-06 L=5e-07
ncdw34r_op_d2n cdw34r_op_adn cdw34r_op_ad 0 0 nch W=1.2e-06 L=5e-07
ncdw34r_op_gpa cdw34r_op_pb cdw34r_op_aq vdd vsrc pch W=2.4e-06 L=5e-07
ncdw34r_op_gpb cdw34r_op_pb cdw34r_op_adn vdd vsrc pch W=2.4e-06 L=5e-07
ncdw34r_op_gna cdw34r_op_pb cdw34r_op_aq cdw34r_op_gx 0 nch W=2.4e-06 L=5e-07
ncdw34r_op_gnb cdw34r_op_gx cdw34r_op_adn 0 0 nch W=2.4e-06 L=5e-07
ncdw34r_op_op cdw34r_op_p cdw34r_op_pb vdd vsrc pch W=2.4e-06 L=5e-07
ncdw34r_op_on cdw34r_op_p cdw34r_op_pb 0 0 nch W=1.2e-06 L=5e-07
ncdw34r_st_mh cdw34r_mi cdw34r_hs cdw34r_st_x 0 nch W=2e-06 L=4e-06
ncdw34r_st_mp cdw34r_st_x thw34r_op_aq 0 0 nch W=4e-06 L=1e-06
ncdw34r_rm_md cdw34r_mi cdw34r_mi vdd vsrc pch W=4e-06 L=2e-06
ncdw34r_rm_mo cdw34r_vm cdw34r_mi vdd vsrc pch W=1e-06 L=8e-06
ncdw34r_kh cdw34r_vm cdw34r_hc cdw34r_kx 0 nch W=2e-06 L=4e-06
va_ncdw34r_kp_s vrest ncdw34r_kp_s 0
ncdw34r_kp cdw34r_kx thw34r_op_aq ncdw34r_kp_s 0 nch W=4e-06 L=1e-06
nhsc1_sw hsc1_sd gc1_col_qb vdd vsrc pch W=4e-06 L=5e-07
rhsc1_rr hsc1_sd hsc1_h1 100000
chsc1_c1 hsc1_h1 0 1e-06
rhsc1_r2 hsc1_h1 hc1 1e+06
chsc1_c2 hc1 0 4.7e-07
rhsc1_rl hc1 0 4.7e+06
nhsc2_sw hsc2_sd gc2_col_qb vdd vsrc pch W=4e-06 L=5e-07
rhsc2_rr hsc2_sd hsc2_h1 100000
chsc2_c1 hsc2_h1 0 1e-06
rhsc2_r2 hsc2_h1 hc2 1e+06
chsc2_c2 hc2 0 4.7e-07
rhsc2_rl hc2 0 4.7e+06
nthc12f_st_mh thc12f_mi hc1 thc12f_st_x 0 nch W=2e-06 L=4e-06
nthc12f_st_mp thc12f_st_x gc2_op_aq 0 0 nch W=4e-06 L=1e-06
cthc12f_cm thc12f_vm 0 1.5e-06
va_rthc12f_rm_n vrest rthc12f_rm_n 0
rthc12f_rm thc12f_vm rthc12f_rm_n 1e+06
rthc12f_kb vdd thc12f_knb 1e+06
nthc12f_kmb thc12f_knb thc12f_knb 0 0 nch W=4e-06 L=4e-06
nthc12f_kmt thc12f_ktail thc12f_knb 0 0 nch W=4e-06 L=4e-06
nthc12f_km1 thc12f_kd1 thc12f_vm thc12f_ktail 0 nch W=4e-06 L=4e-06
nthc12f_km2 thc12f_ko1 thc12f_h thc12f_ktail 0 nch W=4e-06 L=4e-06
nthc12f_km3 thc12f_kd1 thc12f_kd1 vdd vsrc pch W=4e-06 L=4e-06
nthc12f_km4 thc12f_ko1 thc12f_kd1 vdd vsrc pch W=4e-06 L=4e-06
nthc12f_kporclamp thc12f_ko1 por_hold 0 0 nch W=4e-06 L=1e-06
nthc12f_ki1p thc12f_qb thc12f_ko1 vdd vsrc pch W=2.4e-06 L=5e-07
nthc12f_ki1n thc12f_qb thc12f_ko1 0 0 nch W=1.2e-06 L=5e-07
nthc12f_ki2p thc12f_q thc12f_qb vdd vsrc pch W=2.4e-06 L=5e-07
nthc12f_ki2n thc12f_q thc12f_qb 0 0 nch W=1.2e-06 L=5e-07
rthc12f_hra thc12f_h vthr 1e+06
rthc12f_hrf thc12f_h thc12f_qb 1.9e+07
cthc12f_hc thc12f_h 0 2.1e-09
nthc12f_dis thc12f_vm thc12f_q thc12f_vmd 0 nch W=4e-06 L=1e-06
va_rthc12f_rdis_n vrest rthc12f_rdis_n 0
rthc12f_rdis thc12f_vmd rthc12f_rdis_n 12000
nthc12f_rp thc12f_rt thc12f_qb vdd vsrc pch W=2e-06 L=1e-06
rthc12f_rrc thc12f_rt thc12f_rec 10000
cthc12f_rc thc12f_rec 0 1e-07
rthc12f_rr thc12f_rec 0 8.2e+06
nthc12f_sh1 thc12f_vm thc12f_rec thc12f_vms 0 nch W=2e-06 L=1e-06
va_nthc12f_sh2_s vrest nthc12f_sh2_s 0
nthc12f_sh2 thc12f_vms thc12f_qb nthc12f_sh2_s 0 nch W=2e-06 L=1e-06
nthc12f_porh thc12f_h por_hold vthr 0 nch W=2e-06 L=1e-06
va_nthc12f_porm_s vrest nthc12f_porm_s 0
nthc12f_porm thc12f_vm por_hold nthc12f_porm_s 0 nch W=2e-06 L=1e-06
nthc12f_op_tsw thc12f_op_tt thc12f_qb vdd vsrc pch W=2e-06 L=1e-06
rthc12f_op_trc thc12f_op_tt thc12f_op_at 10000
cthc12f_op_tc thc12f_op_at 0 1e-07
rthc12f_op_trl thc12f_op_at 0 2.2e+07
nthc12f_op_sh1p thc12f_op_an thc12f_op_at vdd vsrc pch W=2.4e-06 L=5e-07
nthc12f_op_sh1n thc12f_op_an thc12f_op_at 0 0 nch W=1.2e-06 L=5e-07
nthc12f_op_sh2p thc12f_op_aq thc12f_op_an vdd vsrc pch W=2.4e-06 L=5e-07
nthc12f_op_sh2n thc12f_op_aq thc12f_op_an 0 0 nch W=1.2e-06 L=5e-07
nthc12f_op_abp thc12f_op_aqb thc12f_op_aq vdd vsrc pch W=2.4e-06 L=5e-07
nthc12f_op_abn thc12f_op_aqb thc12f_op_aq 0 0 nch W=1.2e-06 L=5e-07
rthc12f_op_dr thc12f_op_aq thc12f_op_ad 1e+06
cthc12f_op_dc thc12f_op_ad 0 3.3e-07
nthc12f_op_d2p thc12f_op_adn thc12f_op_ad vdd vsrc pch W=2.4e-06 L=5e-07
nthc12f_op_d2n thc12f_op_adn thc12f_op_ad 0 0 nch W=1.2e-06 L=5e-07
nthc12f_op_gpa thc12f_op_pb thc12f_op_aq vdd vsrc pch W=2.4e-06 L=5e-07
nthc12f_op_gpb thc12f_op_pb thc12f_op_adn vdd vsrc pch W=2.4e-06 L=5e-07
nthc12f_op_gna thc12f_op_pb thc12f_op_aq thc12f_op_gx 0 nch W=2.4e-06 L=5e-07
nthc12f_op_gnb thc12f_op_gx thc12f_op_adn 0 0 nch W=2.4e-06 L=5e-07
nthc12f_op_op thc12f_op_p thc12f_op_pb vdd vsrc pch W=2.4e-06 L=5e-07
nthc12f_op_on thc12f_op_p thc12f_op_pb 0 0 nch W=1.2e-06 L=5e-07
nthc12f_rm_md thc12f_mi thc12f_mi vdd vsrc pch W=4e-06 L=2e-06
nthc12f_rm_mo thc12f_vm thc12f_mi vdd vsrc pch W=1e-06 L=8e-06
nthc12r_st_mh thc12r_mi hc2 thc12r_st_x 0 nch W=2e-06 L=4e-06
nthc12r_st_mp thc12r_st_x gc1_op_aq 0 0 nch W=4e-06 L=1e-06
cthc12r_cm thc12r_vm 0 1.5e-06
va_rthc12r_rm_n vrest rthc12r_rm_n 0
rthc12r_rm thc12r_vm rthc12r_rm_n 1e+06
rthc12r_kb vdd thc12r_knb 1e+06
nthc12r_kmb thc12r_knb thc12r_knb 0 0 nch W=4e-06 L=4e-06
nthc12r_kmt thc12r_ktail thc12r_knb 0 0 nch W=4e-06 L=4e-06
nthc12r_km1 thc12r_kd1 thc12r_vm thc12r_ktail 0 nch W=4e-06 L=4e-06
nthc12r_km2 thc12r_ko1 thc12r_h thc12r_ktail 0 nch W=4e-06 L=4e-06
nthc12r_km3 thc12r_kd1 thc12r_kd1 vdd vsrc pch W=4e-06 L=4e-06
nthc12r_km4 thc12r_ko1 thc12r_kd1 vdd vsrc pch W=4e-06 L=4e-06
nthc12r_kporclamp thc12r_ko1 por_hold 0 0 nch W=4e-06 L=1e-06
nthc12r_ki1p thc12r_qb thc12r_ko1 vdd vsrc pch W=2.4e-06 L=5e-07
nthc12r_ki1n thc12r_qb thc12r_ko1 0 0 nch W=1.2e-06 L=5e-07
nthc12r_ki2p thc12r_q thc12r_qb vdd vsrc pch W=2.4e-06 L=5e-07
nthc12r_ki2n thc12r_q thc12r_qb 0 0 nch W=1.2e-06 L=5e-07
rthc12r_hra thc12r_h vthr 1e+06
rthc12r_hrf thc12r_h thc12r_qb 1.9e+07
cthc12r_hc thc12r_h 0 2.1e-09
nthc12r_dis thc12r_vm thc12r_q thc12r_vmd 0 nch W=4e-06 L=1e-06
va_rthc12r_rdis_n vrest rthc12r_rdis_n 0
rthc12r_rdis thc12r_vmd rthc12r_rdis_n 12000
nthc12r_rp thc12r_rt thc12r_qb vdd vsrc pch W=2e-06 L=1e-06
rthc12r_rrc thc12r_rt thc12r_rec 10000
cthc12r_rc thc12r_rec 0 1e-07
rthc12r_rr thc12r_rec 0 8.2e+06
nthc12r_sh1 thc12r_vm thc12r_rec thc12r_vms 0 nch W=2e-06 L=1e-06
va_nthc12r_sh2_s vrest nthc12r_sh2_s 0
nthc12r_sh2 thc12r_vms thc12r_qb nthc12r_sh2_s 0 nch W=2e-06 L=1e-06
nthc12r_porh thc12r_h por_hold vthr 0 nch W=2e-06 L=1e-06
va_nthc12r_porm_s vrest nthc12r_porm_s 0
nthc12r_porm thc12r_vm por_hold nthc12r_porm_s 0 nch W=2e-06 L=1e-06
nthc12r_op_tsw thc12r_op_tt thc12r_qb vdd vsrc pch W=2e-06 L=1e-06
rthc12r_op_trc thc12r_op_tt thc12r_op_at 10000
cthc12r_op_tc thc12r_op_at 0 1e-07
rthc12r_op_trl thc12r_op_at 0 2.2e+07
nthc12r_op_sh1p thc12r_op_an thc12r_op_at vdd vsrc pch W=2.4e-06 L=5e-07
nthc12r_op_sh1n thc12r_op_an thc12r_op_at 0 0 nch W=1.2e-06 L=5e-07
nthc12r_op_sh2p thc12r_op_aq thc12r_op_an vdd vsrc pch W=2.4e-06 L=5e-07
nthc12r_op_sh2n thc12r_op_aq thc12r_op_an 0 0 nch W=1.2e-06 L=5e-07
nthc12r_op_abp thc12r_op_aqb thc12r_op_aq vdd vsrc pch W=2.4e-06 L=5e-07
nthc12r_op_abn thc12r_op_aqb thc12r_op_aq 0 0 nch W=1.2e-06 L=5e-07
rthc12r_op_dr thc12r_op_aq thc12r_op_ad 1e+06
cthc12r_op_dc thc12r_op_ad 0 3.3e-07
nthc12r_op_d2p thc12r_op_adn thc12r_op_ad vdd vsrc pch W=2.4e-06 L=5e-07
nthc12r_op_d2n thc12r_op_adn thc12r_op_ad 0 0 nch W=1.2e-06 L=5e-07
nthc12r_op_gpa thc12r_op_pb thc12r_op_aq vdd vsrc pch W=2.4e-06 L=5e-07
nthc12r_op_gpb thc12r_op_pb thc12r_op_adn vdd vsrc pch W=2.4e-06 L=5e-07
nthc12r_op_gna thc12r_op_pb thc12r_op_aq thc12r_op_gx 0 nch W=2.4e-06 L=5e-07
nthc12r_op_gnb thc12r_op_gx thc12r_op_adn 0 0 nch W=2.4e-06 L=5e-07
nthc12r_op_op thc12r_op_p thc12r_op_pb vdd vsrc pch W=2.4e-06 L=5e-07
nthc12r_op_on thc12r_op_p thc12r_op_pb 0 0 nch W=1.2e-06 L=5e-07
nthc12r_rm_md thc12r_mi thc12r_mi vdd vsrc pch W=4e-06 L=2e-06
nthc12r_rm_mo thc12r_vm thc12r_mi vdd vsrc pch W=1e-06 L=8e-06
nhsc3_sw hsc3_sd gc3_col_qb vdd vsrc pch W=4e-06 L=5e-07
rhsc3_rr hsc3_sd hsc3_h1 100000
chsc3_c1 hsc3_h1 0 1e-06
rhsc3_r2 hsc3_h1 hc3 1e+06
chsc3_c2 hc3 0 4.7e-07
rhsc3_rl hc3 0 4.7e+06
nthc23f_st_mh thc23f_mi hc2 thc23f_st_x 0 nch W=2e-06 L=4e-06
nthc23f_st_mp thc23f_st_x gc3_op_aq 0 0 nch W=4e-06 L=1e-06
cthc23f_cm thc23f_vm 0 1.5e-06
va_rthc23f_rm_n vrest rthc23f_rm_n 0
rthc23f_rm thc23f_vm rthc23f_rm_n 1e+06
rthc23f_kb vdd thc23f_knb 1e+06
nthc23f_kmb thc23f_knb thc23f_knb 0 0 nch W=4e-06 L=4e-06
nthc23f_kmt thc23f_ktail thc23f_knb 0 0 nch W=4e-06 L=4e-06
nthc23f_km1 thc23f_kd1 thc23f_vm thc23f_ktail 0 nch W=4e-06 L=4e-06
nthc23f_km2 thc23f_ko1 thc23f_h thc23f_ktail 0 nch W=4e-06 L=4e-06
nthc23f_km3 thc23f_kd1 thc23f_kd1 vdd vsrc pch W=4e-06 L=4e-06
nthc23f_km4 thc23f_ko1 thc23f_kd1 vdd vsrc pch W=4e-06 L=4e-06
nthc23f_kporclamp thc23f_ko1 por_hold 0 0 nch W=4e-06 L=1e-06
nthc23f_ki1p thc23f_qb thc23f_ko1 vdd vsrc pch W=2.4e-06 L=5e-07
nthc23f_ki1n thc23f_qb thc23f_ko1 0 0 nch W=1.2e-06 L=5e-07
nthc23f_ki2p thc23f_q thc23f_qb vdd vsrc pch W=2.4e-06 L=5e-07
nthc23f_ki2n thc23f_q thc23f_qb 0 0 nch W=1.2e-06 L=5e-07
rthc23f_hra thc23f_h vthr 1e+06
rthc23f_hrf thc23f_h thc23f_qb 1.9e+07
cthc23f_hc thc23f_h 0 2.1e-09
nthc23f_dis thc23f_vm thc23f_q thc23f_vmd 0 nch W=4e-06 L=1e-06
va_rthc23f_rdis_n vrest rthc23f_rdis_n 0
rthc23f_rdis thc23f_vmd rthc23f_rdis_n 12000
nthc23f_rp thc23f_rt thc23f_qb vdd vsrc pch W=2e-06 L=1e-06
rthc23f_rrc thc23f_rt thc23f_rec 10000
cthc23f_rc thc23f_rec 0 1e-07
rthc23f_rr thc23f_rec 0 8.2e+06
nthc23f_sh1 thc23f_vm thc23f_rec thc23f_vms 0 nch W=2e-06 L=1e-06
va_nthc23f_sh2_s vrest nthc23f_sh2_s 0
nthc23f_sh2 thc23f_vms thc23f_qb nthc23f_sh2_s 0 nch W=2e-06 L=1e-06
nthc23f_porh thc23f_h por_hold vthr 0 nch W=2e-06 L=1e-06
va_nthc23f_porm_s vrest nthc23f_porm_s 0
nthc23f_porm thc23f_vm por_hold nthc23f_porm_s 0 nch W=2e-06 L=1e-06
nthc23f_op_tsw thc23f_op_tt thc23f_qb vdd vsrc pch W=2e-06 L=1e-06
rthc23f_op_trc thc23f_op_tt thc23f_op_at 10000
cthc23f_op_tc thc23f_op_at 0 1e-07
rthc23f_op_trl thc23f_op_at 0 2.2e+07
nthc23f_op_sh1p thc23f_op_an thc23f_op_at vdd vsrc pch W=2.4e-06 L=5e-07
nthc23f_op_sh1n thc23f_op_an thc23f_op_at 0 0 nch W=1.2e-06 L=5e-07
nthc23f_op_sh2p thc23f_op_aq thc23f_op_an vdd vsrc pch W=2.4e-06 L=5e-07
nthc23f_op_sh2n thc23f_op_aq thc23f_op_an 0 0 nch W=1.2e-06 L=5e-07
nthc23f_op_abp thc23f_op_aqb thc23f_op_aq vdd vsrc pch W=2.4e-06 L=5e-07
nthc23f_op_abn thc23f_op_aqb thc23f_op_aq 0 0 nch W=1.2e-06 L=5e-07
rthc23f_op_dr thc23f_op_aq thc23f_op_ad 1e+06
cthc23f_op_dc thc23f_op_ad 0 3.3e-07
nthc23f_op_d2p thc23f_op_adn thc23f_op_ad vdd vsrc pch W=2.4e-06 L=5e-07
nthc23f_op_d2n thc23f_op_adn thc23f_op_ad 0 0 nch W=1.2e-06 L=5e-07
nthc23f_op_gpa thc23f_op_pb thc23f_op_aq vdd vsrc pch W=2.4e-06 L=5e-07
nthc23f_op_gpb thc23f_op_pb thc23f_op_adn vdd vsrc pch W=2.4e-06 L=5e-07
nthc23f_op_gna thc23f_op_pb thc23f_op_aq thc23f_op_gx 0 nch W=2.4e-06 L=5e-07
nthc23f_op_gnb thc23f_op_gx thc23f_op_adn 0 0 nch W=2.4e-06 L=5e-07
nthc23f_op_op thc23f_op_p thc23f_op_pb vdd vsrc pch W=2.4e-06 L=5e-07
nthc23f_op_on thc23f_op_p thc23f_op_pb 0 0 nch W=1.2e-06 L=5e-07
nthc23f_rm_md thc23f_mi thc23f_mi vdd vsrc pch W=4e-06 L=2e-06
nthc23f_rm_mo thc23f_vm thc23f_mi vdd vsrc pch W=1e-06 L=8e-06
nthc23r_st_mh thc23r_mi hc3 thc23r_st_x 0 nch W=2e-06 L=4e-06
nthc23r_st_mp thc23r_st_x gc2_op_aq 0 0 nch W=4e-06 L=1e-06
cthc23r_cm thc23r_vm 0 1.5e-06
va_rthc23r_rm_n vrest rthc23r_rm_n 0
rthc23r_rm thc23r_vm rthc23r_rm_n 1e+06
rthc23r_kb vdd thc23r_knb 1e+06
nthc23r_kmb thc23r_knb thc23r_knb 0 0 nch W=4e-06 L=4e-06
nthc23r_kmt thc23r_ktail thc23r_knb 0 0 nch W=4e-06 L=4e-06
nthc23r_km1 thc23r_kd1 thc23r_vm thc23r_ktail 0 nch W=4e-06 L=4e-06
nthc23r_km2 thc23r_ko1 thc23r_h thc23r_ktail 0 nch W=4e-06 L=4e-06
nthc23r_km3 thc23r_kd1 thc23r_kd1 vdd vsrc pch W=4e-06 L=4e-06
nthc23r_km4 thc23r_ko1 thc23r_kd1 vdd vsrc pch W=4e-06 L=4e-06
nthc23r_kporclamp thc23r_ko1 por_hold 0 0 nch W=4e-06 L=1e-06
nthc23r_ki1p thc23r_qb thc23r_ko1 vdd vsrc pch W=2.4e-06 L=5e-07
nthc23r_ki1n thc23r_qb thc23r_ko1 0 0 nch W=1.2e-06 L=5e-07
nthc23r_ki2p thc23r_q thc23r_qb vdd vsrc pch W=2.4e-06 L=5e-07
nthc23r_ki2n thc23r_q thc23r_qb 0 0 nch W=1.2e-06 L=5e-07
rthc23r_hra thc23r_h vthr 1e+06
rthc23r_hrf thc23r_h thc23r_qb 1.9e+07
cthc23r_hc thc23r_h 0 2.1e-09
nthc23r_dis thc23r_vm thc23r_q thc23r_vmd 0 nch W=4e-06 L=1e-06
va_rthc23r_rdis_n vrest rthc23r_rdis_n 0
rthc23r_rdis thc23r_vmd rthc23r_rdis_n 12000
nthc23r_rp thc23r_rt thc23r_qb vdd vsrc pch W=2e-06 L=1e-06
rthc23r_rrc thc23r_rt thc23r_rec 10000
cthc23r_rc thc23r_rec 0 1e-07
rthc23r_rr thc23r_rec 0 8.2e+06
nthc23r_sh1 thc23r_vm thc23r_rec thc23r_vms 0 nch W=2e-06 L=1e-06
va_nthc23r_sh2_s vrest nthc23r_sh2_s 0
nthc23r_sh2 thc23r_vms thc23r_qb nthc23r_sh2_s 0 nch W=2e-06 L=1e-06
nthc23r_porh thc23r_h por_hold vthr 0 nch W=2e-06 L=1e-06
va_nthc23r_porm_s vrest nthc23r_porm_s 0
nthc23r_porm thc23r_vm por_hold nthc23r_porm_s 0 nch W=2e-06 L=1e-06
nthc23r_op_tsw thc23r_op_tt thc23r_qb vdd vsrc pch W=2e-06 L=1e-06
rthc23r_op_trc thc23r_op_tt thc23r_op_at 10000
cthc23r_op_tc thc23r_op_at 0 1e-07
rthc23r_op_trl thc23r_op_at 0 2.2e+07
nthc23r_op_sh1p thc23r_op_an thc23r_op_at vdd vsrc pch W=2.4e-06 L=5e-07
nthc23r_op_sh1n thc23r_op_an thc23r_op_at 0 0 nch W=1.2e-06 L=5e-07
nthc23r_op_sh2p thc23r_op_aq thc23r_op_an vdd vsrc pch W=2.4e-06 L=5e-07
nthc23r_op_sh2n thc23r_op_aq thc23r_op_an 0 0 nch W=1.2e-06 L=5e-07
nthc23r_op_abp thc23r_op_aqb thc23r_op_aq vdd vsrc pch W=2.4e-06 L=5e-07
nthc23r_op_abn thc23r_op_aqb thc23r_op_aq 0 0 nch W=1.2e-06 L=5e-07
rthc23r_op_dr thc23r_op_aq thc23r_op_ad 1e+06
cthc23r_op_dc thc23r_op_ad 0 3.3e-07
nthc23r_op_d2p thc23r_op_adn thc23r_op_ad vdd vsrc pch W=2.4e-06 L=5e-07
nthc23r_op_d2n thc23r_op_adn thc23r_op_ad 0 0 nch W=1.2e-06 L=5e-07
nthc23r_op_gpa thc23r_op_pb thc23r_op_aq vdd vsrc pch W=2.4e-06 L=5e-07
nthc23r_op_gpb thc23r_op_pb thc23r_op_adn vdd vsrc pch W=2.4e-06 L=5e-07
nthc23r_op_gna thc23r_op_pb thc23r_op_aq thc23r_op_gx 0 nch W=2.4e-06 L=5e-07
nthc23r_op_gnb thc23r_op_gx thc23r_op_adn 0 0 nch W=2.4e-06 L=5e-07
nthc23r_op_op thc23r_op_p thc23r_op_pb vdd vsrc pch W=2.4e-06 L=5e-07
nthc23r_op_on thc23r_op_p thc23r_op_pb 0 0 nch W=1.2e-06 L=5e-07
nthc23r_rm_md thc23r_mi thc23r_mi vdd vsrc pch W=4e-06 L=2e-06
nthc23r_rm_mo thc23r_vm thc23r_mi vdd vsrc pch W=1e-06 L=8e-06
nhsc4_sw hsc4_sd gc4_col_qb vdd vsrc pch W=4e-06 L=5e-07
rhsc4_rr hsc4_sd hsc4_h1 100000
chsc4_c1 hsc4_h1 0 1e-06
rhsc4_r2 hsc4_h1 hc4 1e+06
chsc4_c2 hc4 0 4.7e-07
rhsc4_rl hc4 0 4.7e+06
nthc34f_st_mh thc34f_mi hc3 thc34f_st_x 0 nch W=2e-06 L=4e-06
nthc34f_st_mp thc34f_st_x gc4_op_aq 0 0 nch W=4e-06 L=1e-06
cthc34f_cm thc34f_vm 0 1.5e-06
va_rthc34f_rm_n vrest rthc34f_rm_n 0
rthc34f_rm thc34f_vm rthc34f_rm_n 1e+06
rthc34f_kb vdd thc34f_knb 1e+06
nthc34f_kmb thc34f_knb thc34f_knb 0 0 nch W=4e-06 L=4e-06
nthc34f_kmt thc34f_ktail thc34f_knb 0 0 nch W=4e-06 L=4e-06
nthc34f_km1 thc34f_kd1 thc34f_vm thc34f_ktail 0 nch W=4e-06 L=4e-06
nthc34f_km2 thc34f_ko1 thc34f_h thc34f_ktail 0 nch W=4e-06 L=4e-06
nthc34f_km3 thc34f_kd1 thc34f_kd1 vdd vsrc pch W=4e-06 L=4e-06
nthc34f_km4 thc34f_ko1 thc34f_kd1 vdd vsrc pch W=4e-06 L=4e-06
nthc34f_kporclamp thc34f_ko1 por_hold 0 0 nch W=4e-06 L=1e-06
nthc34f_ki1p thc34f_qb thc34f_ko1 vdd vsrc pch W=2.4e-06 L=5e-07
nthc34f_ki1n thc34f_qb thc34f_ko1 0 0 nch W=1.2e-06 L=5e-07
nthc34f_ki2p thc34f_q thc34f_qb vdd vsrc pch W=2.4e-06 L=5e-07
nthc34f_ki2n thc34f_q thc34f_qb 0 0 nch W=1.2e-06 L=5e-07
rthc34f_hra thc34f_h vthr 1e+06
rthc34f_hrf thc34f_h thc34f_qb 1.9e+07
cthc34f_hc thc34f_h 0 2.1e-09
nthc34f_dis thc34f_vm thc34f_q thc34f_vmd 0 nch W=4e-06 L=1e-06
va_rthc34f_rdis_n vrest rthc34f_rdis_n 0
rthc34f_rdis thc34f_vmd rthc34f_rdis_n 12000
nthc34f_rp thc34f_rt thc34f_qb vdd vsrc pch W=2e-06 L=1e-06
rthc34f_rrc thc34f_rt thc34f_rec 10000
cthc34f_rc thc34f_rec 0 1e-07
rthc34f_rr thc34f_rec 0 8.2e+06
nthc34f_sh1 thc34f_vm thc34f_rec thc34f_vms 0 nch W=2e-06 L=1e-06
va_nthc34f_sh2_s vrest nthc34f_sh2_s 0
nthc34f_sh2 thc34f_vms thc34f_qb nthc34f_sh2_s 0 nch W=2e-06 L=1e-06
nthc34f_porh thc34f_h por_hold vthr 0 nch W=2e-06 L=1e-06
va_nthc34f_porm_s vrest nthc34f_porm_s 0
nthc34f_porm thc34f_vm por_hold nthc34f_porm_s 0 nch W=2e-06 L=1e-06
nthc34f_op_tsw thc34f_op_tt thc34f_qb vdd vsrc pch W=2e-06 L=1e-06
rthc34f_op_trc thc34f_op_tt thc34f_op_at 10000
cthc34f_op_tc thc34f_op_at 0 1e-07
rthc34f_op_trl thc34f_op_at 0 2.2e+07
nthc34f_op_sh1p thc34f_op_an thc34f_op_at vdd vsrc pch W=2.4e-06 L=5e-07
nthc34f_op_sh1n thc34f_op_an thc34f_op_at 0 0 nch W=1.2e-06 L=5e-07
nthc34f_op_sh2p thc34f_op_aq thc34f_op_an vdd vsrc pch W=2.4e-06 L=5e-07
nthc34f_op_sh2n thc34f_op_aq thc34f_op_an 0 0 nch W=1.2e-06 L=5e-07
nthc34f_op_abp thc34f_op_aqb thc34f_op_aq vdd vsrc pch W=2.4e-06 L=5e-07
nthc34f_op_abn thc34f_op_aqb thc34f_op_aq 0 0 nch W=1.2e-06 L=5e-07
rthc34f_op_dr thc34f_op_aq thc34f_op_ad 1e+06
cthc34f_op_dc thc34f_op_ad 0 3.3e-07
nthc34f_op_d2p thc34f_op_adn thc34f_op_ad vdd vsrc pch W=2.4e-06 L=5e-07
nthc34f_op_d2n thc34f_op_adn thc34f_op_ad 0 0 nch W=1.2e-06 L=5e-07
nthc34f_op_gpa thc34f_op_pb thc34f_op_aq vdd vsrc pch W=2.4e-06 L=5e-07
nthc34f_op_gpb thc34f_op_pb thc34f_op_adn vdd vsrc pch W=2.4e-06 L=5e-07
nthc34f_op_gna thc34f_op_pb thc34f_op_aq thc34f_op_gx 0 nch W=2.4e-06 L=5e-07
nthc34f_op_gnb thc34f_op_gx thc34f_op_adn 0 0 nch W=2.4e-06 L=5e-07
nthc34f_op_op thc34f_op_p thc34f_op_pb vdd vsrc pch W=2.4e-06 L=5e-07
nthc34f_op_on thc34f_op_p thc34f_op_pb 0 0 nch W=1.2e-06 L=5e-07
nthc34f_rm_md thc34f_mi thc34f_mi vdd vsrc pch W=4e-06 L=2e-06
nthc34f_rm_mo thc34f_vm thc34f_mi vdd vsrc pch W=1e-06 L=8e-06
nthc34r_st_mh thc34r_mi hc4 thc34r_st_x 0 nch W=2e-06 L=4e-06
nthc34r_st_mp thc34r_st_x gc3_op_aq 0 0 nch W=4e-06 L=1e-06
cthc34r_cm thc34r_vm 0 1.5e-06
va_rthc34r_rm_n vrest rthc34r_rm_n 0
rthc34r_rm thc34r_vm rthc34r_rm_n 1e+06
rthc34r_kb vdd thc34r_knb 1e+06
nthc34r_kmb thc34r_knb thc34r_knb 0 0 nch W=4e-06 L=4e-06
nthc34r_kmt thc34r_ktail thc34r_knb 0 0 nch W=4e-06 L=4e-06
nthc34r_km1 thc34r_kd1 thc34r_vm thc34r_ktail 0 nch W=4e-06 L=4e-06
nthc34r_km2 thc34r_ko1 thc34r_h thc34r_ktail 0 nch W=4e-06 L=4e-06
nthc34r_km3 thc34r_kd1 thc34r_kd1 vdd vsrc pch W=4e-06 L=4e-06
nthc34r_km4 thc34r_ko1 thc34r_kd1 vdd vsrc pch W=4e-06 L=4e-06
nthc34r_kporclamp thc34r_ko1 por_hold 0 0 nch W=4e-06 L=1e-06
nthc34r_ki1p thc34r_qb thc34r_ko1 vdd vsrc pch W=2.4e-06 L=5e-07
nthc34r_ki1n thc34r_qb thc34r_ko1 0 0 nch W=1.2e-06 L=5e-07
nthc34r_ki2p thc34r_q thc34r_qb vdd vsrc pch W=2.4e-06 L=5e-07
nthc34r_ki2n thc34r_q thc34r_qb 0 0 nch W=1.2e-06 L=5e-07
rthc34r_hra thc34r_h vthr 1e+06
rthc34r_hrf thc34r_h thc34r_qb 1.9e+07
cthc34r_hc thc34r_h 0 2.1e-09
nthc34r_dis thc34r_vm thc34r_q thc34r_vmd 0 nch W=4e-06 L=1e-06
va_rthc34r_rdis_n vrest rthc34r_rdis_n 0
rthc34r_rdis thc34r_vmd rthc34r_rdis_n 12000
nthc34r_rp thc34r_rt thc34r_qb vdd vsrc pch W=2e-06 L=1e-06
rthc34r_rrc thc34r_rt thc34r_rec 10000
cthc34r_rc thc34r_rec 0 1e-07
rthc34r_rr thc34r_rec 0 8.2e+06
nthc34r_sh1 thc34r_vm thc34r_rec thc34r_vms 0 nch W=2e-06 L=1e-06
va_nthc34r_sh2_s vrest nthc34r_sh2_s 0
nthc34r_sh2 thc34r_vms thc34r_qb nthc34r_sh2_s 0 nch W=2e-06 L=1e-06
nthc34r_porh thc34r_h por_hold vthr 0 nch W=2e-06 L=1e-06
va_nthc34r_porm_s vrest nthc34r_porm_s 0
nthc34r_porm thc34r_vm por_hold nthc34r_porm_s 0 nch W=2e-06 L=1e-06
nthc34r_op_tsw thc34r_op_tt thc34r_qb vdd vsrc pch W=2e-06 L=1e-06
rthc34r_op_trc thc34r_op_tt thc34r_op_at 10000
cthc34r_op_tc thc34r_op_at 0 1e-07
rthc34r_op_trl thc34r_op_at 0 2.2e+07
nthc34r_op_sh1p thc34r_op_an thc34r_op_at vdd vsrc pch W=2.4e-06 L=5e-07
nthc34r_op_sh1n thc34r_op_an thc34r_op_at 0 0 nch W=1.2e-06 L=5e-07
nthc34r_op_sh2p thc34r_op_aq thc34r_op_an vdd vsrc pch W=2.4e-06 L=5e-07
nthc34r_op_sh2n thc34r_op_aq thc34r_op_an 0 0 nch W=1.2e-06 L=5e-07
nthc34r_op_abp thc34r_op_aqb thc34r_op_aq vdd vsrc pch W=2.4e-06 L=5e-07
nthc34r_op_abn thc34r_op_aqb thc34r_op_aq 0 0 nch W=1.2e-06 L=5e-07
rthc34r_op_dr thc34r_op_aq thc34r_op_ad 1e+06
cthc34r_op_dc thc34r_op_ad 0 3.3e-07
nthc34r_op_d2p thc34r_op_adn thc34r_op_ad vdd vsrc pch W=2.4e-06 L=5e-07
nthc34r_op_d2n thc34r_op_adn thc34r_op_ad 0 0 nch W=1.2e-06 L=5e-07
nthc34r_op_gpa thc34r_op_pb thc34r_op_aq vdd vsrc pch W=2.4e-06 L=5e-07
nthc34r_op_gpb thc34r_op_pb thc34r_op_adn vdd vsrc pch W=2.4e-06 L=5e-07
nthc34r_op_gna thc34r_op_pb thc34r_op_aq thc34r_op_gx 0 nch W=2.4e-06 L=5e-07
nthc34r_op_gnb thc34r_op_gx thc34r_op_adn 0 0 nch W=2.4e-06 L=5e-07
nthc34r_op_op thc34r_op_p thc34r_op_pb vdd vsrc pch W=2.4e-06 L=5e-07
nthc34r_op_on thc34r_op_p thc34r_op_pb 0 0 nch W=1.2e-06 L=5e-07
nthc34r_rm_md thc34r_mi thc34r_mi vdd vsrc pch W=4e-06 L=2e-06
nthc34r_rm_mo thc34r_vm thc34r_mi vdd vsrc pch W=1e-06 L=8e-06
cspcc1 spc1 0 1e-07
rspcl1 spc1 vmid 1e+06
nspci1_eni_p spci1_ena gc1_op_aqb vdd vsrc pch W=2.4e-06 L=5e-07
nspci1_eni_n spci1_ena gc1_op_aqb 0 0 nch W=1.2e-06 L=5e-07
nspci1_cp spc1 spci1_cg vdd vsrc pch W=2e-06 L=4e-06
nspci1_bias irefp_n gc1_op_aqb spci1_cg vsrc pch W=1.2e-06 L=1e-06
nspci1_off spci1_cg spci1_ena vdd vsrc pch W=2.4e-06 L=1e-06
cspcc2 spc2 0 1e-07
rspcl2 spc2 vmid 1e+06
nspci2_eni_p spci2_ena gc2_op_aqb vdd vsrc pch W=2.4e-06 L=5e-07
nspci2_eni_n spci2_ena gc2_op_aqb 0 0 nch W=1.2e-06 L=5e-07
nspci2_cp spc2 spci2_cg vdd vsrc pch W=2e-06 L=4e-06
nspci2_bias irefp_n gc2_op_aqb spci2_cg vsrc pch W=1.2e-06 L=1e-06
nspci2_off spci2_cg spci2_ena vdd vsrc pch W=2.4e-06 L=1e-06
cspcc3 spc3 0 1e-07
rspcl3 spc3 vmid 1e+06
nspci3_eni_p spci3_ena gc3_op_aqb vdd vsrc pch W=2.4e-06 L=5e-07
nspci3_eni_n spci3_ena gc3_op_aqb 0 0 nch W=1.2e-06 L=5e-07
nspci3_cp spc3 spci3_cg vdd vsrc pch W=2e-06 L=4e-06
nspci3_bias irefp_n gc3_op_aqb spci3_cg vsrc pch W=1.2e-06 L=1e-06
nspci3_off spci3_cg spci3_ena vdd vsrc pch W=2.4e-06 L=1e-06
cspcc4 spc4 0 1e-07
rspcl4 spc4 vmid 1e+06
nspci4_eni_p spci4_ena gc4_op_aqb vdd vsrc pch W=2.4e-06 L=5e-07
nspci4_eni_n spci4_ena gc4_op_aqb 0 0 nch W=1.2e-06 L=5e-07
nspci4_cp spc4 spci4_cg vdd vsrc pch W=2e-06 L=4e-06
nspci4_bias irefp_n gc4_op_aqb spci4_cg vsrc pch W=1.2e-06 L=1e-06
nspci4_off spci4_cg spci4_ena vdd vsrc pch W=2.4e-06 L=1e-06
rspcrs12 spc1 spcs12 200000
cspccs12 spcs12 0 1e-12
rspcrt12 spcs12 spc2 800000
rspcrs23 spc2 spcs23 200000
cspccs23 spcs23 0 1e-12
rspcrt23 spcs23 spc3 800000
rspcrs34 spc3 spcs34 200000
cspccs34 spcs34 0 1e-12
rspcrt34 spcs34 spc4 800000
csgc12f_cm sgc12f_vm 0 1e-07
va_rsgc12f_rm_n vrest rsgc12f_rm_n 0
rsgc12f_rm sgc12f_vm rsgc12f_rm_n 1e+06
rsgc12f_kb vdd sgc12f_knb 1e+06
nsgc12f_kmb sgc12f_knb sgc12f_knb 0 0 nch W=4e-06 L=4e-06
nsgc12f_kmt sgc12f_ktail sgc12f_knb 0 0 nch W=4e-06 L=4e-06
nsgc12f_km1 sgc12f_kd1 sgc12f_vm sgc12f_ktail 0 nch W=4e-06 L=4e-06
nsgc12f_km2 sgc12f_ko1 sgc12f_h sgc12f_ktail 0 nch W=4e-06 L=4e-06
nsgc12f_km3 sgc12f_kd1 sgc12f_kd1 vdd vsrc pch W=4e-06 L=4e-06
nsgc12f_km4 sgc12f_ko1 sgc12f_kd1 vdd vsrc pch W=4e-06 L=4e-06
nsgc12f_kporclamp sgc12f_ko1 por_hold 0 0 nch W=4e-06 L=1e-06
nsgc12f_ki1p sgc12f_qb sgc12f_ko1 vdd vsrc pch W=2.4e-06 L=5e-07
nsgc12f_ki1n sgc12f_qb sgc12f_ko1 0 0 nch W=1.2e-06 L=5e-07
nsgc12f_ki2p sgc12f_q sgc12f_qb vdd vsrc pch W=2.4e-06 L=5e-07
nsgc12f_ki2n sgc12f_q sgc12f_qb 0 0 nch W=1.2e-06 L=5e-07
rsgc12f_hra sgc12f_h vthr 1e+06
rsgc12f_hrf sgc12f_h sgc12f_qb 1.9e+07
csgc12f_hc sgc12f_h 0 2.1e-09
nsgc12f_dis sgc12f_vm sgc12f_q sgc12f_vmd 0 nch W=4e-06 L=1e-06
va_rsgc12f_rdis_n vrest rsgc12f_rdis_n 0
rsgc12f_rdis sgc12f_vmd rsgc12f_rdis_n 75000
nsgc12f_rp sgc12f_rt sgc12f_qb vdd vsrc pch W=2e-06 L=1e-06
rsgc12f_rrc sgc12f_rt sgc12f_rec 10000
csgc12f_rc sgc12f_rec 0 1e-07
rsgc12f_rr sgc12f_rec 0 8.2e+06
nsgc12f_sh1 sgc12f_vm sgc12f_rec sgc12f_vms 0 nch W=2e-06 L=1e-06
va_nsgc12f_sh2_s vrest nsgc12f_sh2_s 0
nsgc12f_sh2 sgc12f_vms sgc12f_qb nsgc12f_sh2_s 0 nch W=2e-06 L=1e-06
nsgc12f_porh sgc12f_h por_hold vthr 0 nch W=2e-06 L=1e-06
va_nsgc12f_porm_s vrest nsgc12f_porm_s 0
nsgc12f_porm sgc12f_vm por_hold nsgc12f_porm_s 0 nch W=2e-06 L=1e-06
nsgc12f_op_tsw sgc12f_op_tt sgc12f_qb vdd vsrc pch W=2e-06 L=1e-06
rsgc12f_op_trc sgc12f_op_tt sgc12f_op_at 10000
csgc12f_op_tc sgc12f_op_at 0 1e-07
rsgc12f_op_trl sgc12f_op_at 0 2.2e+07
nsgc12f_op_sh1p sgc12f_op_an sgc12f_op_at vdd vsrc pch W=2.4e-06 L=5e-07
nsgc12f_op_sh1n sgc12f_op_an sgc12f_op_at 0 0 nch W=1.2e-06 L=5e-07
nsgc12f_op_sh2p sgc12f_op_aq sgc12f_op_an vdd vsrc pch W=2.4e-06 L=5e-07
nsgc12f_op_sh2n sgc12f_op_aq sgc12f_op_an 0 0 nch W=1.2e-06 L=5e-07
nsgc12f_op_abp sgc12f_op_aqb sgc12f_op_aq vdd vsrc pch W=2.4e-06 L=5e-07
nsgc12f_op_abn sgc12f_op_aqb sgc12f_op_aq 0 0 nch W=1.2e-06 L=5e-07
rsgc12f_op_dr sgc12f_op_aq sgc12f_op_ad 1e+06
csgc12f_op_dc sgc12f_op_ad 0 3.3e-07
nsgc12f_op_d2p sgc12f_op_adn sgc12f_op_ad vdd vsrc pch W=2.4e-06 L=5e-07
nsgc12f_op_d2n sgc12f_op_adn sgc12f_op_ad 0 0 nch W=1.2e-06 L=5e-07
nsgc12f_op_gpa sgc12f_op_pb sgc12f_op_aq vdd vsrc pch W=2.4e-06 L=5e-07
nsgc12f_op_gpb sgc12f_op_pb sgc12f_op_adn vdd vsrc pch W=2.4e-06 L=5e-07
nsgc12f_op_gna sgc12f_op_pb sgc12f_op_aq sgc12f_op_gx 0 nch W=2.4e-06 L=5e-07
nsgc12f_op_gnb sgc12f_op_gx sgc12f_op_adn 0 0 nch W=2.4e-06 L=5e-07
nsgc12f_op_op sgc12f_op_p sgc12f_op_pb vdd vsrc pch W=2.4e-06 L=5e-07
nsgc12f_op_on sgc12f_op_p sgc12f_op_pb 0 0 nch W=1.2e-06 L=5e-07
rsgc12f_ota_b vdd sgc12f_ota_nb 3.3e+06
nsgc12f_ota_mb sgc12f_ota_nb sgc12f_ota_nb 0 0 nch W=4e-06 L=4e-06
nsgc12f_ota_mt sgc12f_ota_tail sgc12f_ota_nb 0 0 nch W=4e-06 L=4e-06
nsgc12f_ota_m1 sgc12f_ota_d1 spc1 sgc12f_ota_tail 0 nch W=1e-05 L=2e-06
nsgc12f_ota_m2 sgc12f_vm spcs12 sgc12f_ota_tail 0 nch W=1e-05 L=2e-06
nsgc12f_ota_m3 sgc12f_ota_d1 sgc12f_ota_d1 vdd vsrc pch W=1e-05 L=2e-06
nsgc12f_ota_m4 sgc12f_vm sgc12f_ota_d1 vdd vsrc pch W=1e-05 L=2e-06
csgc12r_cm sgc12r_vm 0 1e-07
va_rsgc12r_rm_n vrest rsgc12r_rm_n 0
rsgc12r_rm sgc12r_vm rsgc12r_rm_n 1e+06
rsgc12r_kb vdd sgc12r_knb 1e+06
nsgc12r_kmb sgc12r_knb sgc12r_knb 0 0 nch W=4e-06 L=4e-06
nsgc12r_kmt sgc12r_ktail sgc12r_knb 0 0 nch W=4e-06 L=4e-06
nsgc12r_km1 sgc12r_kd1 sgc12r_vm sgc12r_ktail 0 nch W=4e-06 L=4e-06
nsgc12r_km2 sgc12r_ko1 sgc12r_h sgc12r_ktail 0 nch W=4e-06 L=4e-06
nsgc12r_km3 sgc12r_kd1 sgc12r_kd1 vdd vsrc pch W=4e-06 L=4e-06
nsgc12r_km4 sgc12r_ko1 sgc12r_kd1 vdd vsrc pch W=4e-06 L=4e-06
nsgc12r_kporclamp sgc12r_ko1 por_hold 0 0 nch W=4e-06 L=1e-06
nsgc12r_ki1p sgc12r_qb sgc12r_ko1 vdd vsrc pch W=2.4e-06 L=5e-07
nsgc12r_ki1n sgc12r_qb sgc12r_ko1 0 0 nch W=1.2e-06 L=5e-07
nsgc12r_ki2p sgc12r_q sgc12r_qb vdd vsrc pch W=2.4e-06 L=5e-07
nsgc12r_ki2n sgc12r_q sgc12r_qb 0 0 nch W=1.2e-06 L=5e-07
rsgc12r_hra sgc12r_h vthr 1e+06
rsgc12r_hrf sgc12r_h sgc12r_qb 1.9e+07
csgc12r_hc sgc12r_h 0 2.1e-09
nsgc12r_dis sgc12r_vm sgc12r_q sgc12r_vmd 0 nch W=4e-06 L=1e-06
va_rsgc12r_rdis_n vrest rsgc12r_rdis_n 0
rsgc12r_rdis sgc12r_vmd rsgc12r_rdis_n 75000
nsgc12r_rp sgc12r_rt sgc12r_qb vdd vsrc pch W=2e-06 L=1e-06
rsgc12r_rrc sgc12r_rt sgc12r_rec 10000
csgc12r_rc sgc12r_rec 0 1e-07
rsgc12r_rr sgc12r_rec 0 8.2e+06
nsgc12r_sh1 sgc12r_vm sgc12r_rec sgc12r_vms 0 nch W=2e-06 L=1e-06
va_nsgc12r_sh2_s vrest nsgc12r_sh2_s 0
nsgc12r_sh2 sgc12r_vms sgc12r_qb nsgc12r_sh2_s 0 nch W=2e-06 L=1e-06
nsgc12r_porh sgc12r_h por_hold vthr 0 nch W=2e-06 L=1e-06
va_nsgc12r_porm_s vrest nsgc12r_porm_s 0
nsgc12r_porm sgc12r_vm por_hold nsgc12r_porm_s 0 nch W=2e-06 L=1e-06
nsgc12r_op_tsw sgc12r_op_tt sgc12r_qb vdd vsrc pch W=2e-06 L=1e-06
rsgc12r_op_trc sgc12r_op_tt sgc12r_op_at 10000
csgc12r_op_tc sgc12r_op_at 0 1e-07
rsgc12r_op_trl sgc12r_op_at 0 2.2e+07
nsgc12r_op_sh1p sgc12r_op_an sgc12r_op_at vdd vsrc pch W=2.4e-06 L=5e-07
nsgc12r_op_sh1n sgc12r_op_an sgc12r_op_at 0 0 nch W=1.2e-06 L=5e-07
nsgc12r_op_sh2p sgc12r_op_aq sgc12r_op_an vdd vsrc pch W=2.4e-06 L=5e-07
nsgc12r_op_sh2n sgc12r_op_aq sgc12r_op_an 0 0 nch W=1.2e-06 L=5e-07
nsgc12r_op_abp sgc12r_op_aqb sgc12r_op_aq vdd vsrc pch W=2.4e-06 L=5e-07
nsgc12r_op_abn sgc12r_op_aqb sgc12r_op_aq 0 0 nch W=1.2e-06 L=5e-07
rsgc12r_op_dr sgc12r_op_aq sgc12r_op_ad 1e+06
csgc12r_op_dc sgc12r_op_ad 0 3.3e-07
nsgc12r_op_d2p sgc12r_op_adn sgc12r_op_ad vdd vsrc pch W=2.4e-06 L=5e-07
nsgc12r_op_d2n sgc12r_op_adn sgc12r_op_ad 0 0 nch W=1.2e-06 L=5e-07
nsgc12r_op_gpa sgc12r_op_pb sgc12r_op_aq vdd vsrc pch W=2.4e-06 L=5e-07
nsgc12r_op_gpb sgc12r_op_pb sgc12r_op_adn vdd vsrc pch W=2.4e-06 L=5e-07
nsgc12r_op_gna sgc12r_op_pb sgc12r_op_aq sgc12r_op_gx 0 nch W=2.4e-06 L=5e-07
nsgc12r_op_gnb sgc12r_op_gx sgc12r_op_adn 0 0 nch W=2.4e-06 L=5e-07
nsgc12r_op_op sgc12r_op_p sgc12r_op_pb vdd vsrc pch W=2.4e-06 L=5e-07
nsgc12r_op_on sgc12r_op_p sgc12r_op_pb 0 0 nch W=1.2e-06 L=5e-07
rsgc12r_ota_b vdd sgc12r_ota_nb 3.3e+06
nsgc12r_ota_mb sgc12r_ota_nb sgc12r_ota_nb 0 0 nch W=4e-06 L=4e-06
nsgc12r_ota_mt sgc12r_ota_tail sgc12r_ota_nb 0 0 nch W=4e-06 L=4e-06
nsgc12r_ota_m1 sgc12r_ota_d1 spcs12 sgc12r_ota_tail 0 nch W=1e-05 L=2e-06
nsgc12r_ota_m2 sgc12r_vm spc1 sgc12r_ota_tail 0 nch W=1e-05 L=2e-06
nsgc12r_ota_m3 sgc12r_ota_d1 sgc12r_ota_d1 vdd vsrc pch W=1e-05 L=2e-06
nsgc12r_ota_m4 sgc12r_vm sgc12r_ota_d1 vdd vsrc pch W=1e-05 L=2e-06
csgc23f_cm sgc23f_vm 0 1e-07
va_rsgc23f_rm_n vrest rsgc23f_rm_n 0
rsgc23f_rm sgc23f_vm rsgc23f_rm_n 1e+06
rsgc23f_kb vdd sgc23f_knb 1e+06
nsgc23f_kmb sgc23f_knb sgc23f_knb 0 0 nch W=4e-06 L=4e-06
nsgc23f_kmt sgc23f_ktail sgc23f_knb 0 0 nch W=4e-06 L=4e-06
nsgc23f_km1 sgc23f_kd1 sgc23f_vm sgc23f_ktail 0 nch W=4e-06 L=4e-06
nsgc23f_km2 sgc23f_ko1 sgc23f_h sgc23f_ktail 0 nch W=4e-06 L=4e-06
nsgc23f_km3 sgc23f_kd1 sgc23f_kd1 vdd vsrc pch W=4e-06 L=4e-06
nsgc23f_km4 sgc23f_ko1 sgc23f_kd1 vdd vsrc pch W=4e-06 L=4e-06
nsgc23f_kporclamp sgc23f_ko1 por_hold 0 0 nch W=4e-06 L=1e-06
nsgc23f_ki1p sgc23f_qb sgc23f_ko1 vdd vsrc pch W=2.4e-06 L=5e-07
nsgc23f_ki1n sgc23f_qb sgc23f_ko1 0 0 nch W=1.2e-06 L=5e-07
nsgc23f_ki2p sgc23f_q sgc23f_qb vdd vsrc pch W=2.4e-06 L=5e-07
nsgc23f_ki2n sgc23f_q sgc23f_qb 0 0 nch W=1.2e-06 L=5e-07
rsgc23f_hra sgc23f_h vthr 1e+06
rsgc23f_hrf sgc23f_h sgc23f_qb 1.9e+07
csgc23f_hc sgc23f_h 0 2.1e-09
nsgc23f_dis sgc23f_vm sgc23f_q sgc23f_vmd 0 nch W=4e-06 L=1e-06
va_rsgc23f_rdis_n vrest rsgc23f_rdis_n 0
rsgc23f_rdis sgc23f_vmd rsgc23f_rdis_n 75000
nsgc23f_rp sgc23f_rt sgc23f_qb vdd vsrc pch W=2e-06 L=1e-06
rsgc23f_rrc sgc23f_rt sgc23f_rec 10000
csgc23f_rc sgc23f_rec 0 1e-07
rsgc23f_rr sgc23f_rec 0 8.2e+06
nsgc23f_sh1 sgc23f_vm sgc23f_rec sgc23f_vms 0 nch W=2e-06 L=1e-06
va_nsgc23f_sh2_s vrest nsgc23f_sh2_s 0
nsgc23f_sh2 sgc23f_vms sgc23f_qb nsgc23f_sh2_s 0 nch W=2e-06 L=1e-06
nsgc23f_porh sgc23f_h por_hold vthr 0 nch W=2e-06 L=1e-06
va_nsgc23f_porm_s vrest nsgc23f_porm_s 0
nsgc23f_porm sgc23f_vm por_hold nsgc23f_porm_s 0 nch W=2e-06 L=1e-06
nsgc23f_op_tsw sgc23f_op_tt sgc23f_qb vdd vsrc pch W=2e-06 L=1e-06
rsgc23f_op_trc sgc23f_op_tt sgc23f_op_at 10000
csgc23f_op_tc sgc23f_op_at 0 1e-07
rsgc23f_op_trl sgc23f_op_at 0 2.2e+07
nsgc23f_op_sh1p sgc23f_op_an sgc23f_op_at vdd vsrc pch W=2.4e-06 L=5e-07
nsgc23f_op_sh1n sgc23f_op_an sgc23f_op_at 0 0 nch W=1.2e-06 L=5e-07
nsgc23f_op_sh2p sgc23f_op_aq sgc23f_op_an vdd vsrc pch W=2.4e-06 L=5e-07
nsgc23f_op_sh2n sgc23f_op_aq sgc23f_op_an 0 0 nch W=1.2e-06 L=5e-07
nsgc23f_op_abp sgc23f_op_aqb sgc23f_op_aq vdd vsrc pch W=2.4e-06 L=5e-07
nsgc23f_op_abn sgc23f_op_aqb sgc23f_op_aq 0 0 nch W=1.2e-06 L=5e-07
rsgc23f_op_dr sgc23f_op_aq sgc23f_op_ad 1e+06
csgc23f_op_dc sgc23f_op_ad 0 3.3e-07
nsgc23f_op_d2p sgc23f_op_adn sgc23f_op_ad vdd vsrc pch W=2.4e-06 L=5e-07
nsgc23f_op_d2n sgc23f_op_adn sgc23f_op_ad 0 0 nch W=1.2e-06 L=5e-07
nsgc23f_op_gpa sgc23f_op_pb sgc23f_op_aq vdd vsrc pch W=2.4e-06 L=5e-07
nsgc23f_op_gpb sgc23f_op_pb sgc23f_op_adn vdd vsrc pch W=2.4e-06 L=5e-07
nsgc23f_op_gna sgc23f_op_pb sgc23f_op_aq sgc23f_op_gx 0 nch W=2.4e-06 L=5e-07
nsgc23f_op_gnb sgc23f_op_gx sgc23f_op_adn 0 0 nch W=2.4e-06 L=5e-07
nsgc23f_op_op sgc23f_op_p sgc23f_op_pb vdd vsrc pch W=2.4e-06 L=5e-07
nsgc23f_op_on sgc23f_op_p sgc23f_op_pb 0 0 nch W=1.2e-06 L=5e-07
rsgc23f_ota_b vdd sgc23f_ota_nb 3.3e+06
nsgc23f_ota_mb sgc23f_ota_nb sgc23f_ota_nb 0 0 nch W=4e-06 L=4e-06
nsgc23f_ota_mt sgc23f_ota_tail sgc23f_ota_nb 0 0 nch W=4e-06 L=4e-06
nsgc23f_ota_m1 sgc23f_ota_d1 spc2 sgc23f_ota_tail 0 nch W=1e-05 L=2e-06
nsgc23f_ota_m2 sgc23f_vm spcs23 sgc23f_ota_tail 0 nch W=1e-05 L=2e-06
nsgc23f_ota_m3 sgc23f_ota_d1 sgc23f_ota_d1 vdd vsrc pch W=1e-05 L=2e-06
nsgc23f_ota_m4 sgc23f_vm sgc23f_ota_d1 vdd vsrc pch W=1e-05 L=2e-06
csgc23r_cm sgc23r_vm 0 1e-07
va_rsgc23r_rm_n vrest rsgc23r_rm_n 0
rsgc23r_rm sgc23r_vm rsgc23r_rm_n 1e+06
rsgc23r_kb vdd sgc23r_knb 1e+06
nsgc23r_kmb sgc23r_knb sgc23r_knb 0 0 nch W=4e-06 L=4e-06
nsgc23r_kmt sgc23r_ktail sgc23r_knb 0 0 nch W=4e-06 L=4e-06
nsgc23r_km1 sgc23r_kd1 sgc23r_vm sgc23r_ktail 0 nch W=4e-06 L=4e-06
nsgc23r_km2 sgc23r_ko1 sgc23r_h sgc23r_ktail 0 nch W=4e-06 L=4e-06
nsgc23r_km3 sgc23r_kd1 sgc23r_kd1 vdd vsrc pch W=4e-06 L=4e-06
nsgc23r_km4 sgc23r_ko1 sgc23r_kd1 vdd vsrc pch W=4e-06 L=4e-06
nsgc23r_kporclamp sgc23r_ko1 por_hold 0 0 nch W=4e-06 L=1e-06
nsgc23r_ki1p sgc23r_qb sgc23r_ko1 vdd vsrc pch W=2.4e-06 L=5e-07
nsgc23r_ki1n sgc23r_qb sgc23r_ko1 0 0 nch W=1.2e-06 L=5e-07
nsgc23r_ki2p sgc23r_q sgc23r_qb vdd vsrc pch W=2.4e-06 L=5e-07
nsgc23r_ki2n sgc23r_q sgc23r_qb 0 0 nch W=1.2e-06 L=5e-07
rsgc23r_hra sgc23r_h vthr 1e+06
rsgc23r_hrf sgc23r_h sgc23r_qb 1.9e+07
csgc23r_hc sgc23r_h 0 2.1e-09
nsgc23r_dis sgc23r_vm sgc23r_q sgc23r_vmd 0 nch W=4e-06 L=1e-06
va_rsgc23r_rdis_n vrest rsgc23r_rdis_n 0
rsgc23r_rdis sgc23r_vmd rsgc23r_rdis_n 75000
nsgc23r_rp sgc23r_rt sgc23r_qb vdd vsrc pch W=2e-06 L=1e-06
rsgc23r_rrc sgc23r_rt sgc23r_rec 10000
csgc23r_rc sgc23r_rec 0 1e-07
rsgc23r_rr sgc23r_rec 0 8.2e+06
nsgc23r_sh1 sgc23r_vm sgc23r_rec sgc23r_vms 0 nch W=2e-06 L=1e-06
va_nsgc23r_sh2_s vrest nsgc23r_sh2_s 0
nsgc23r_sh2 sgc23r_vms sgc23r_qb nsgc23r_sh2_s 0 nch W=2e-06 L=1e-06
nsgc23r_porh sgc23r_h por_hold vthr 0 nch W=2e-06 L=1e-06
va_nsgc23r_porm_s vrest nsgc23r_porm_s 0
nsgc23r_porm sgc23r_vm por_hold nsgc23r_porm_s 0 nch W=2e-06 L=1e-06
nsgc23r_op_tsw sgc23r_op_tt sgc23r_qb vdd vsrc pch W=2e-06 L=1e-06
rsgc23r_op_trc sgc23r_op_tt sgc23r_op_at 10000
csgc23r_op_tc sgc23r_op_at 0 1e-07
rsgc23r_op_trl sgc23r_op_at 0 2.2e+07
nsgc23r_op_sh1p sgc23r_op_an sgc23r_op_at vdd vsrc pch W=2.4e-06 L=5e-07
nsgc23r_op_sh1n sgc23r_op_an sgc23r_op_at 0 0 nch W=1.2e-06 L=5e-07
nsgc23r_op_sh2p sgc23r_op_aq sgc23r_op_an vdd vsrc pch W=2.4e-06 L=5e-07
nsgc23r_op_sh2n sgc23r_op_aq sgc23r_op_an 0 0 nch W=1.2e-06 L=5e-07
nsgc23r_op_abp sgc23r_op_aqb sgc23r_op_aq vdd vsrc pch W=2.4e-06 L=5e-07
nsgc23r_op_abn sgc23r_op_aqb sgc23r_op_aq 0 0 nch W=1.2e-06 L=5e-07
rsgc23r_op_dr sgc23r_op_aq sgc23r_op_ad 1e+06
csgc23r_op_dc sgc23r_op_ad 0 3.3e-07
nsgc23r_op_d2p sgc23r_op_adn sgc23r_op_ad vdd vsrc pch W=2.4e-06 L=5e-07
nsgc23r_op_d2n sgc23r_op_adn sgc23r_op_ad 0 0 nch W=1.2e-06 L=5e-07
nsgc23r_op_gpa sgc23r_op_pb sgc23r_op_aq vdd vsrc pch W=2.4e-06 L=5e-07
nsgc23r_op_gpb sgc23r_op_pb sgc23r_op_adn vdd vsrc pch W=2.4e-06 L=5e-07
nsgc23r_op_gna sgc23r_op_pb sgc23r_op_aq sgc23r_op_gx 0 nch W=2.4e-06 L=5e-07
nsgc23r_op_gnb sgc23r_op_gx sgc23r_op_adn 0 0 nch W=2.4e-06 L=5e-07
nsgc23r_op_op sgc23r_op_p sgc23r_op_pb vdd vsrc pch W=2.4e-06 L=5e-07
nsgc23r_op_on sgc23r_op_p sgc23r_op_pb 0 0 nch W=1.2e-06 L=5e-07
rsgc23r_ota_b vdd sgc23r_ota_nb 3.3e+06
nsgc23r_ota_mb sgc23r_ota_nb sgc23r_ota_nb 0 0 nch W=4e-06 L=4e-06
nsgc23r_ota_mt sgc23r_ota_tail sgc23r_ota_nb 0 0 nch W=4e-06 L=4e-06
nsgc23r_ota_m1 sgc23r_ota_d1 spcs23 sgc23r_ota_tail 0 nch W=1e-05 L=2e-06
nsgc23r_ota_m2 sgc23r_vm spc2 sgc23r_ota_tail 0 nch W=1e-05 L=2e-06
nsgc23r_ota_m3 sgc23r_ota_d1 sgc23r_ota_d1 vdd vsrc pch W=1e-05 L=2e-06
nsgc23r_ota_m4 sgc23r_vm sgc23r_ota_d1 vdd vsrc pch W=1e-05 L=2e-06
csgc34f_cm sgc34f_vm 0 1e-07
va_rsgc34f_rm_n vrest rsgc34f_rm_n 0
rsgc34f_rm sgc34f_vm rsgc34f_rm_n 1e+06
rsgc34f_kb vdd sgc34f_knb 1e+06
nsgc34f_kmb sgc34f_knb sgc34f_knb 0 0 nch W=4e-06 L=4e-06
nsgc34f_kmt sgc34f_ktail sgc34f_knb 0 0 nch W=4e-06 L=4e-06
nsgc34f_km1 sgc34f_kd1 sgc34f_vm sgc34f_ktail 0 nch W=4e-06 L=4e-06
nsgc34f_km2 sgc34f_ko1 sgc34f_h sgc34f_ktail 0 nch W=4e-06 L=4e-06
nsgc34f_km3 sgc34f_kd1 sgc34f_kd1 vdd vsrc pch W=4e-06 L=4e-06
nsgc34f_km4 sgc34f_ko1 sgc34f_kd1 vdd vsrc pch W=4e-06 L=4e-06
nsgc34f_kporclamp sgc34f_ko1 por_hold 0 0 nch W=4e-06 L=1e-06
nsgc34f_ki1p sgc34f_qb sgc34f_ko1 vdd vsrc pch W=2.4e-06 L=5e-07
nsgc34f_ki1n sgc34f_qb sgc34f_ko1 0 0 nch W=1.2e-06 L=5e-07
nsgc34f_ki2p sgc34f_q sgc34f_qb vdd vsrc pch W=2.4e-06 L=5e-07
nsgc34f_ki2n sgc34f_q sgc34f_qb 0 0 nch W=1.2e-06 L=5e-07
rsgc34f_hra sgc34f_h vthr 1e+06
rsgc34f_hrf sgc34f_h sgc34f_qb 1.9e+07
csgc34f_hc sgc34f_h 0 2.1e-09
nsgc34f_dis sgc34f_vm sgc34f_q sgc34f_vmd 0 nch W=4e-06 L=1e-06
va_rsgc34f_rdis_n vrest rsgc34f_rdis_n 0
rsgc34f_rdis sgc34f_vmd rsgc34f_rdis_n 75000
nsgc34f_rp sgc34f_rt sgc34f_qb vdd vsrc pch W=2e-06 L=1e-06
rsgc34f_rrc sgc34f_rt sgc34f_rec 10000
csgc34f_rc sgc34f_rec 0 1e-07
rsgc34f_rr sgc34f_rec 0 8.2e+06
nsgc34f_sh1 sgc34f_vm sgc34f_rec sgc34f_vms 0 nch W=2e-06 L=1e-06
va_nsgc34f_sh2_s vrest nsgc34f_sh2_s 0
nsgc34f_sh2 sgc34f_vms sgc34f_qb nsgc34f_sh2_s 0 nch W=2e-06 L=1e-06
nsgc34f_porh sgc34f_h por_hold vthr 0 nch W=2e-06 L=1e-06
va_nsgc34f_porm_s vrest nsgc34f_porm_s 0
nsgc34f_porm sgc34f_vm por_hold nsgc34f_porm_s 0 nch W=2e-06 L=1e-06
nsgc34f_op_tsw sgc34f_op_tt sgc34f_qb vdd vsrc pch W=2e-06 L=1e-06
rsgc34f_op_trc sgc34f_op_tt sgc34f_op_at 10000
csgc34f_op_tc sgc34f_op_at 0 1e-07
rsgc34f_op_trl sgc34f_op_at 0 2.2e+07
nsgc34f_op_sh1p sgc34f_op_an sgc34f_op_at vdd vsrc pch W=2.4e-06 L=5e-07
nsgc34f_op_sh1n sgc34f_op_an sgc34f_op_at 0 0 nch W=1.2e-06 L=5e-07
nsgc34f_op_sh2p sgc34f_op_aq sgc34f_op_an vdd vsrc pch W=2.4e-06 L=5e-07
nsgc34f_op_sh2n sgc34f_op_aq sgc34f_op_an 0 0 nch W=1.2e-06 L=5e-07
nsgc34f_op_abp sgc34f_op_aqb sgc34f_op_aq vdd vsrc pch W=2.4e-06 L=5e-07
nsgc34f_op_abn sgc34f_op_aqb sgc34f_op_aq 0 0 nch W=1.2e-06 L=5e-07
rsgc34f_op_dr sgc34f_op_aq sgc34f_op_ad 1e+06
csgc34f_op_dc sgc34f_op_ad 0 3.3e-07
nsgc34f_op_d2p sgc34f_op_adn sgc34f_op_ad vdd vsrc pch W=2.4e-06 L=5e-07
nsgc34f_op_d2n sgc34f_op_adn sgc34f_op_ad 0 0 nch W=1.2e-06 L=5e-07
nsgc34f_op_gpa sgc34f_op_pb sgc34f_op_aq vdd vsrc pch W=2.4e-06 L=5e-07
nsgc34f_op_gpb sgc34f_op_pb sgc34f_op_adn vdd vsrc pch W=2.4e-06 L=5e-07
nsgc34f_op_gna sgc34f_op_pb sgc34f_op_aq sgc34f_op_gx 0 nch W=2.4e-06 L=5e-07
nsgc34f_op_gnb sgc34f_op_gx sgc34f_op_adn 0 0 nch W=2.4e-06 L=5e-07
nsgc34f_op_op sgc34f_op_p sgc34f_op_pb vdd vsrc pch W=2.4e-06 L=5e-07
nsgc34f_op_on sgc34f_op_p sgc34f_op_pb 0 0 nch W=1.2e-06 L=5e-07
rsgc34f_ota_b vdd sgc34f_ota_nb 3.3e+06
nsgc34f_ota_mb sgc34f_ota_nb sgc34f_ota_nb 0 0 nch W=4e-06 L=4e-06
nsgc34f_ota_mt sgc34f_ota_tail sgc34f_ota_nb 0 0 nch W=4e-06 L=4e-06
nsgc34f_ota_m1 sgc34f_ota_d1 spc3 sgc34f_ota_tail 0 nch W=1e-05 L=2e-06
nsgc34f_ota_m2 sgc34f_vm spcs34 sgc34f_ota_tail 0 nch W=1e-05 L=2e-06
nsgc34f_ota_m3 sgc34f_ota_d1 sgc34f_ota_d1 vdd vsrc pch W=1e-05 L=2e-06
nsgc34f_ota_m4 sgc34f_vm sgc34f_ota_d1 vdd vsrc pch W=1e-05 L=2e-06
csgc34r_cm sgc34r_vm 0 1e-07
va_rsgc34r_rm_n vrest rsgc34r_rm_n 0
rsgc34r_rm sgc34r_vm rsgc34r_rm_n 1e+06
rsgc34r_kb vdd sgc34r_knb 1e+06
nsgc34r_kmb sgc34r_knb sgc34r_knb 0 0 nch W=4e-06 L=4e-06
nsgc34r_kmt sgc34r_ktail sgc34r_knb 0 0 nch W=4e-06 L=4e-06
nsgc34r_km1 sgc34r_kd1 sgc34r_vm sgc34r_ktail 0 nch W=4e-06 L=4e-06
nsgc34r_km2 sgc34r_ko1 sgc34r_h sgc34r_ktail 0 nch W=4e-06 L=4e-06
nsgc34r_km3 sgc34r_kd1 sgc34r_kd1 vdd vsrc pch W=4e-06 L=4e-06
nsgc34r_km4 sgc34r_ko1 sgc34r_kd1 vdd vsrc pch W=4e-06 L=4e-06
nsgc34r_kporclamp sgc34r_ko1 por_hold 0 0 nch W=4e-06 L=1e-06
nsgc34r_ki1p sgc34r_qb sgc34r_ko1 vdd vsrc pch W=2.4e-06 L=5e-07
nsgc34r_ki1n sgc34r_qb sgc34r_ko1 0 0 nch W=1.2e-06 L=5e-07
nsgc34r_ki2p sgc34r_q sgc34r_qb vdd vsrc pch W=2.4e-06 L=5e-07
nsgc34r_ki2n sgc34r_q sgc34r_qb 0 0 nch W=1.2e-06 L=5e-07
rsgc34r_hra sgc34r_h vthr 1e+06
rsgc34r_hrf sgc34r_h sgc34r_qb 1.9e+07
csgc34r_hc sgc34r_h 0 2.1e-09
nsgc34r_dis sgc34r_vm sgc34r_q sgc34r_vmd 0 nch W=4e-06 L=1e-06
va_rsgc34r_rdis_n vrest rsgc34r_rdis_n 0
rsgc34r_rdis sgc34r_vmd rsgc34r_rdis_n 75000
nsgc34r_rp sgc34r_rt sgc34r_qb vdd vsrc pch W=2e-06 L=1e-06
rsgc34r_rrc sgc34r_rt sgc34r_rec 10000
csgc34r_rc sgc34r_rec 0 1e-07
rsgc34r_rr sgc34r_rec 0 8.2e+06
nsgc34r_sh1 sgc34r_vm sgc34r_rec sgc34r_vms 0 nch W=2e-06 L=1e-06
va_nsgc34r_sh2_s vrest nsgc34r_sh2_s 0
nsgc34r_sh2 sgc34r_vms sgc34r_qb nsgc34r_sh2_s 0 nch W=2e-06 L=1e-06
nsgc34r_porh sgc34r_h por_hold vthr 0 nch W=2e-06 L=1e-06
va_nsgc34r_porm_s vrest nsgc34r_porm_s 0
nsgc34r_porm sgc34r_vm por_hold nsgc34r_porm_s 0 nch W=2e-06 L=1e-06
nsgc34r_op_tsw sgc34r_op_tt sgc34r_qb vdd vsrc pch W=2e-06 L=1e-06
rsgc34r_op_trc sgc34r_op_tt sgc34r_op_at 10000
csgc34r_op_tc sgc34r_op_at 0 1e-07
rsgc34r_op_trl sgc34r_op_at 0 2.2e+07
nsgc34r_op_sh1p sgc34r_op_an sgc34r_op_at vdd vsrc pch W=2.4e-06 L=5e-07
nsgc34r_op_sh1n sgc34r_op_an sgc34r_op_at 0 0 nch W=1.2e-06 L=5e-07
nsgc34r_op_sh2p sgc34r_op_aq sgc34r_op_an vdd vsrc pch W=2.4e-06 L=5e-07
nsgc34r_op_sh2n sgc34r_op_aq sgc34r_op_an 0 0 nch W=1.2e-06 L=5e-07
nsgc34r_op_abp sgc34r_op_aqb sgc34r_op_aq vdd vsrc pch W=2.4e-06 L=5e-07
nsgc34r_op_abn sgc34r_op_aqb sgc34r_op_aq 0 0 nch W=1.2e-06 L=5e-07
rsgc34r_op_dr sgc34r_op_aq sgc34r_op_ad 1e+06
csgc34r_op_dc sgc34r_op_ad 0 3.3e-07
nsgc34r_op_d2p sgc34r_op_adn sgc34r_op_ad vdd vsrc pch W=2.4e-06 L=5e-07
nsgc34r_op_d2n sgc34r_op_adn sgc34r_op_ad 0 0 nch W=1.2e-06 L=5e-07
nsgc34r_op_gpa sgc34r_op_pb sgc34r_op_aq vdd vsrc pch W=2.4e-06 L=5e-07
nsgc34r_op_gpb sgc34r_op_pb sgc34r_op_adn vdd vsrc pch W=2.4e-06 L=5e-07
nsgc34r_op_gna sgc34r_op_pb sgc34r_op_aq sgc34r_op_gx 0 nch W=2.4e-06 L=5e-07
nsgc34r_op_gnb sgc34r_op_gx sgc34r_op_adn 0 0 nch W=2.4e-06 L=5e-07
nsgc34r_op_op sgc34r_op_p sgc34r_op_pb vdd vsrc pch W=2.4e-06 L=5e-07
nsgc34r_op_on sgc34r_op_p sgc34r_op_pb 0 0 nch W=1.2e-06 L=5e-07
rsgc34r_ota_b vdd sgc34r_ota_nb 3.3e+06
nsgc34r_ota_mb sgc34r_ota_nb sgc34r_ota_nb 0 0 nch W=4e-06 L=4e-06
nsgc34r_ota_mt sgc34r_ota_tail sgc34r_ota_nb 0 0 nch W=4e-06 L=4e-06
nsgc34r_ota_m1 sgc34r_ota_d1 spcs34 sgc34r_ota_tail 0 nch W=1e-05 L=2e-06
nsgc34r_ota_m2 sgc34r_vm spc3 sgc34r_ota_tail 0 nch W=1e-05 L=2e-06
nsgc34r_ota_m3 sgc34r_ota_d1 sgc34r_ota_d1 vdd vsrc pch W=1e-05 L=2e-06
nsgc34r_ota_m4 sgc34r_vm sgc34r_ota_d1 vdd vsrc pch W=1e-05 L=2e-06
ncdc12f_hsf_sw cdc12f_hsf_sd sgc12f_op_aqb vdd vsrc pch W=4e-06 L=5e-07
rcdc12f_hsf_rr cdc12f_hsf_sd cdc12f_hsf_h1 100000
ccdc12f_hsf_c1 cdc12f_hsf_h1 0 1e-06
rcdc12f_hsf_r2 cdc12f_hsf_h1 cdc12f_hs 1e+06
ccdc12f_hsf_c2 cdc12f_hs 0 4.7e-07
rcdc12f_hsf_rl cdc12f_hs 0 4.7e+06
ncdc12f_hcf_sw cdc12f_hcf_sd sgc12r_op_aqb vdd vsrc pch W=4e-06 L=5e-07
rcdc12f_hcf_rr cdc12f_hcf_sd cdc12f_hcf_h1 100000
ccdc12f_hcf_c1 cdc12f_hcf_h1 0 1e-06
rcdc12f_hcf_r2 cdc12f_hcf_h1 cdc12f_hc 1e+06
ccdc12f_hcf_c2 cdc12f_hc 0 4.7e-07
rcdc12f_hcf_rl cdc12f_hc 0 4.7e+06
ccdc12f_cm cdc12f_vm 0 1.5e-06
va_rcdc12f_rm_n vrest rcdc12f_rm_n 0
rcdc12f_rm cdc12f_vm rcdc12f_rm_n 1e+06
rcdc12f_kb vdd cdc12f_knb 1e+06
ncdc12f_kmb cdc12f_knb cdc12f_knb 0 0 nch W=4e-06 L=4e-06
ncdc12f_kmt cdc12f_ktail cdc12f_knb 0 0 nch W=4e-06 L=4e-06
ncdc12f_km1 cdc12f_kd1 cdc12f_vm cdc12f_ktail 0 nch W=4e-06 L=4e-06
ncdc12f_km2 cdc12f_ko1 cdc12f_h cdc12f_ktail 0 nch W=4e-06 L=4e-06
ncdc12f_km3 cdc12f_kd1 cdc12f_kd1 vdd vsrc pch W=4e-06 L=4e-06
ncdc12f_km4 cdc12f_ko1 cdc12f_kd1 vdd vsrc pch W=4e-06 L=4e-06
ncdc12f_kporclamp cdc12f_ko1 por_hold 0 0 nch W=4e-06 L=1e-06
ncdc12f_ki1p cdc12f_qb cdc12f_ko1 vdd vsrc pch W=2.4e-06 L=5e-07
ncdc12f_ki1n cdc12f_qb cdc12f_ko1 0 0 nch W=1.2e-06 L=5e-07
ncdc12f_ki2p cdc12f_q cdc12f_qb vdd vsrc pch W=2.4e-06 L=5e-07
ncdc12f_ki2n cdc12f_q cdc12f_qb 0 0 nch W=1.2e-06 L=5e-07
rcdc12f_hra cdc12f_h vthr 1e+06
rcdc12f_hrf cdc12f_h cdc12f_qb 1.9e+07
ccdc12f_hc cdc12f_h 0 2.1e-09
ncdc12f_dis cdc12f_vm cdc12f_q cdc12f_vmd 0 nch W=4e-06 L=1e-06
va_rcdc12f_rdis_n vrest rcdc12f_rdis_n 0
rcdc12f_rdis cdc12f_vmd rcdc12f_rdis_n 12000
ncdc12f_rp cdc12f_rt cdc12f_qb vdd vsrc pch W=2e-06 L=1e-06
rcdc12f_rrc cdc12f_rt cdc12f_rec 10000
ccdc12f_rc cdc12f_rec 0 1e-07
rcdc12f_rr cdc12f_rec 0 8.2e+06
ncdc12f_sh1 cdc12f_vm cdc12f_rec cdc12f_vms 0 nch W=2e-06 L=1e-06
va_ncdc12f_sh2_s vrest ncdc12f_sh2_s 0
ncdc12f_sh2 cdc12f_vms cdc12f_qb ncdc12f_sh2_s 0 nch W=2e-06 L=1e-06
ncdc12f_porh cdc12f_h por_hold vthr 0 nch W=2e-06 L=1e-06
va_ncdc12f_porm_s vrest ncdc12f_porm_s 0
ncdc12f_porm cdc12f_vm por_hold ncdc12f_porm_s 0 nch W=2e-06 L=1e-06
ncdc12f_op_tsw cdc12f_op_tt cdc12f_qb vdd vsrc pch W=2e-06 L=1e-06
rcdc12f_op_trc cdc12f_op_tt cdc12f_op_at 10000
ccdc12f_op_tc cdc12f_op_at 0 1e-07
rcdc12f_op_trl cdc12f_op_at 0 2.2e+07
ncdc12f_op_sh1p cdc12f_op_an cdc12f_op_at vdd vsrc pch W=2.4e-06 L=5e-07
ncdc12f_op_sh1n cdc12f_op_an cdc12f_op_at 0 0 nch W=1.2e-06 L=5e-07
ncdc12f_op_sh2p cdc12f_op_aq cdc12f_op_an vdd vsrc pch W=2.4e-06 L=5e-07
ncdc12f_op_sh2n cdc12f_op_aq cdc12f_op_an 0 0 nch W=1.2e-06 L=5e-07
ncdc12f_op_abp cdc12f_op_aqb cdc12f_op_aq vdd vsrc pch W=2.4e-06 L=5e-07
ncdc12f_op_abn cdc12f_op_aqb cdc12f_op_aq 0 0 nch W=1.2e-06 L=5e-07
rcdc12f_op_dr cdc12f_op_aq cdc12f_op_ad 1e+06
ccdc12f_op_dc cdc12f_op_ad 0 3.3e-07
ncdc12f_op_d2p cdc12f_op_adn cdc12f_op_ad vdd vsrc pch W=2.4e-06 L=5e-07
ncdc12f_op_d2n cdc12f_op_adn cdc12f_op_ad 0 0 nch W=1.2e-06 L=5e-07
ncdc12f_op_gpa cdc12f_op_pb cdc12f_op_aq vdd vsrc pch W=2.4e-06 L=5e-07
ncdc12f_op_gpb cdc12f_op_pb cdc12f_op_adn vdd vsrc pch W=2.4e-06 L=5e-07
ncdc12f_op_gna cdc12f_op_pb cdc12f_op_aq cdc12f_op_gx 0 nch W=2.4e-06 L=5e-07
ncdc12f_op_gnb cdc12f_op_gx cdc12f_op_adn 0 0 nch W=2.4e-06 L=5e-07
ncdc12f_op_op cdc12f_op_p cdc12f_op_pb vdd vsrc pch W=2.4e-06 L=5e-07
ncdc12f_op_on cdc12f_op_p cdc12f_op_pb 0 0 nch W=1.2e-06 L=5e-07
ncdc12f_st_mh cdc12f_mi cdc12f_hs cdc12f_st_x 0 nch W=2e-06 L=4e-06
ncdc12f_st_mp cdc12f_st_x thc12f_op_aq 0 0 nch W=4e-06 L=1e-06
ncdc12f_rm_md cdc12f_mi cdc12f_mi vdd vsrc pch W=4e-06 L=2e-06
ncdc12f_rm_mo cdc12f_vm cdc12f_mi vdd vsrc pch W=1e-06 L=8e-06
ncdc12f_kh cdc12f_vm cdc12f_hc cdc12f_kx 0 nch W=2e-06 L=4e-06
va_ncdc12f_kp_s vrest ncdc12f_kp_s 0
ncdc12f_kp cdc12f_kx thc12f_op_aq ncdc12f_kp_s 0 nch W=4e-06 L=1e-06
ncdc12r_hsf_sw cdc12r_hsf_sd sgc12r_op_aqb vdd vsrc pch W=4e-06 L=5e-07
rcdc12r_hsf_rr cdc12r_hsf_sd cdc12r_hsf_h1 100000
ccdc12r_hsf_c1 cdc12r_hsf_h1 0 1e-06
rcdc12r_hsf_r2 cdc12r_hsf_h1 cdc12r_hs 1e+06
ccdc12r_hsf_c2 cdc12r_hs 0 4.7e-07
rcdc12r_hsf_rl cdc12r_hs 0 4.7e+06
ncdc12r_hcf_sw cdc12r_hcf_sd sgc12f_op_aqb vdd vsrc pch W=4e-06 L=5e-07
rcdc12r_hcf_rr cdc12r_hcf_sd cdc12r_hcf_h1 100000
ccdc12r_hcf_c1 cdc12r_hcf_h1 0 1e-06
rcdc12r_hcf_r2 cdc12r_hcf_h1 cdc12r_hc 1e+06
ccdc12r_hcf_c2 cdc12r_hc 0 4.7e-07
rcdc12r_hcf_rl cdc12r_hc 0 4.7e+06
ccdc12r_cm cdc12r_vm 0 1.5e-06
va_rcdc12r_rm_n vrest rcdc12r_rm_n 0
rcdc12r_rm cdc12r_vm rcdc12r_rm_n 1e+06
rcdc12r_kb vdd cdc12r_knb 1e+06
ncdc12r_kmb cdc12r_knb cdc12r_knb 0 0 nch W=4e-06 L=4e-06
ncdc12r_kmt cdc12r_ktail cdc12r_knb 0 0 nch W=4e-06 L=4e-06
ncdc12r_km1 cdc12r_kd1 cdc12r_vm cdc12r_ktail 0 nch W=4e-06 L=4e-06
ncdc12r_km2 cdc12r_ko1 cdc12r_h cdc12r_ktail 0 nch W=4e-06 L=4e-06
ncdc12r_km3 cdc12r_kd1 cdc12r_kd1 vdd vsrc pch W=4e-06 L=4e-06
ncdc12r_km4 cdc12r_ko1 cdc12r_kd1 vdd vsrc pch W=4e-06 L=4e-06
ncdc12r_kporclamp cdc12r_ko1 por_hold 0 0 nch W=4e-06 L=1e-06
ncdc12r_ki1p cdc12r_qb cdc12r_ko1 vdd vsrc pch W=2.4e-06 L=5e-07
ncdc12r_ki1n cdc12r_qb cdc12r_ko1 0 0 nch W=1.2e-06 L=5e-07
ncdc12r_ki2p cdc12r_q cdc12r_qb vdd vsrc pch W=2.4e-06 L=5e-07
ncdc12r_ki2n cdc12r_q cdc12r_qb 0 0 nch W=1.2e-06 L=5e-07
rcdc12r_hra cdc12r_h vthr 1e+06
rcdc12r_hrf cdc12r_h cdc12r_qb 1.9e+07
ccdc12r_hc cdc12r_h 0 2.1e-09
ncdc12r_dis cdc12r_vm cdc12r_q cdc12r_vmd 0 nch W=4e-06 L=1e-06
va_rcdc12r_rdis_n vrest rcdc12r_rdis_n 0
rcdc12r_rdis cdc12r_vmd rcdc12r_rdis_n 12000
ncdc12r_rp cdc12r_rt cdc12r_qb vdd vsrc pch W=2e-06 L=1e-06
rcdc12r_rrc cdc12r_rt cdc12r_rec 10000
ccdc12r_rc cdc12r_rec 0 1e-07
rcdc12r_rr cdc12r_rec 0 8.2e+06
ncdc12r_sh1 cdc12r_vm cdc12r_rec cdc12r_vms 0 nch W=2e-06 L=1e-06
va_ncdc12r_sh2_s vrest ncdc12r_sh2_s 0
ncdc12r_sh2 cdc12r_vms cdc12r_qb ncdc12r_sh2_s 0 nch W=2e-06 L=1e-06
ncdc12r_porh cdc12r_h por_hold vthr 0 nch W=2e-06 L=1e-06
va_ncdc12r_porm_s vrest ncdc12r_porm_s 0
ncdc12r_porm cdc12r_vm por_hold ncdc12r_porm_s 0 nch W=2e-06 L=1e-06
ncdc12r_op_tsw cdc12r_op_tt cdc12r_qb vdd vsrc pch W=2e-06 L=1e-06
rcdc12r_op_trc cdc12r_op_tt cdc12r_op_at 10000
ccdc12r_op_tc cdc12r_op_at 0 1e-07
rcdc12r_op_trl cdc12r_op_at 0 2.2e+07
ncdc12r_op_sh1p cdc12r_op_an cdc12r_op_at vdd vsrc pch W=2.4e-06 L=5e-07
ncdc12r_op_sh1n cdc12r_op_an cdc12r_op_at 0 0 nch W=1.2e-06 L=5e-07
ncdc12r_op_sh2p cdc12r_op_aq cdc12r_op_an vdd vsrc pch W=2.4e-06 L=5e-07
ncdc12r_op_sh2n cdc12r_op_aq cdc12r_op_an 0 0 nch W=1.2e-06 L=5e-07
ncdc12r_op_abp cdc12r_op_aqb cdc12r_op_aq vdd vsrc pch W=2.4e-06 L=5e-07
ncdc12r_op_abn cdc12r_op_aqb cdc12r_op_aq 0 0 nch W=1.2e-06 L=5e-07
rcdc12r_op_dr cdc12r_op_aq cdc12r_op_ad 1e+06
ccdc12r_op_dc cdc12r_op_ad 0 3.3e-07
ncdc12r_op_d2p cdc12r_op_adn cdc12r_op_ad vdd vsrc pch W=2.4e-06 L=5e-07
ncdc12r_op_d2n cdc12r_op_adn cdc12r_op_ad 0 0 nch W=1.2e-06 L=5e-07
ncdc12r_op_gpa cdc12r_op_pb cdc12r_op_aq vdd vsrc pch W=2.4e-06 L=5e-07
ncdc12r_op_gpb cdc12r_op_pb cdc12r_op_adn vdd vsrc pch W=2.4e-06 L=5e-07
ncdc12r_op_gna cdc12r_op_pb cdc12r_op_aq cdc12r_op_gx 0 nch W=2.4e-06 L=5e-07
ncdc12r_op_gnb cdc12r_op_gx cdc12r_op_adn 0 0 nch W=2.4e-06 L=5e-07
ncdc12r_op_op cdc12r_op_p cdc12r_op_pb vdd vsrc pch W=2.4e-06 L=5e-07
ncdc12r_op_on cdc12r_op_p cdc12r_op_pb 0 0 nch W=1.2e-06 L=5e-07
ncdc12r_st_mh cdc12r_mi cdc12r_hs cdc12r_st_x 0 nch W=2e-06 L=4e-06
ncdc12r_st_mp cdc12r_st_x thc12r_op_aq 0 0 nch W=4e-06 L=1e-06
ncdc12r_rm_md cdc12r_mi cdc12r_mi vdd vsrc pch W=4e-06 L=2e-06
ncdc12r_rm_mo cdc12r_vm cdc12r_mi vdd vsrc pch W=1e-06 L=8e-06
ncdc12r_kh cdc12r_vm cdc12r_hc cdc12r_kx 0 nch W=2e-06 L=4e-06
va_ncdc12r_kp_s vrest ncdc12r_kp_s 0
ncdc12r_kp cdc12r_kx thc12r_op_aq ncdc12r_kp_s 0 nch W=4e-06 L=1e-06
ncdc23f_hsf_sw cdc23f_hsf_sd sgc23f_op_aqb vdd vsrc pch W=4e-06 L=5e-07
rcdc23f_hsf_rr cdc23f_hsf_sd cdc23f_hsf_h1 100000
ccdc23f_hsf_c1 cdc23f_hsf_h1 0 1e-06
rcdc23f_hsf_r2 cdc23f_hsf_h1 cdc23f_hs 1e+06
ccdc23f_hsf_c2 cdc23f_hs 0 4.7e-07
rcdc23f_hsf_rl cdc23f_hs 0 4.7e+06
ncdc23f_hcf_sw cdc23f_hcf_sd sgc23r_op_aqb vdd vsrc pch W=4e-06 L=5e-07
rcdc23f_hcf_rr cdc23f_hcf_sd cdc23f_hcf_h1 100000
ccdc23f_hcf_c1 cdc23f_hcf_h1 0 1e-06
rcdc23f_hcf_r2 cdc23f_hcf_h1 cdc23f_hc 1e+06
ccdc23f_hcf_c2 cdc23f_hc 0 4.7e-07
rcdc23f_hcf_rl cdc23f_hc 0 4.7e+06
ccdc23f_cm cdc23f_vm 0 1.5e-06
va_rcdc23f_rm_n vrest rcdc23f_rm_n 0
rcdc23f_rm cdc23f_vm rcdc23f_rm_n 1e+06
rcdc23f_kb vdd cdc23f_knb 1e+06
ncdc23f_kmb cdc23f_knb cdc23f_knb 0 0 nch W=4e-06 L=4e-06
ncdc23f_kmt cdc23f_ktail cdc23f_knb 0 0 nch W=4e-06 L=4e-06
ncdc23f_km1 cdc23f_kd1 cdc23f_vm cdc23f_ktail 0 nch W=4e-06 L=4e-06
ncdc23f_km2 cdc23f_ko1 cdc23f_h cdc23f_ktail 0 nch W=4e-06 L=4e-06
ncdc23f_km3 cdc23f_kd1 cdc23f_kd1 vdd vsrc pch W=4e-06 L=4e-06
ncdc23f_km4 cdc23f_ko1 cdc23f_kd1 vdd vsrc pch W=4e-06 L=4e-06
ncdc23f_kporclamp cdc23f_ko1 por_hold 0 0 nch W=4e-06 L=1e-06
ncdc23f_ki1p cdc23f_qb cdc23f_ko1 vdd vsrc pch W=2.4e-06 L=5e-07
ncdc23f_ki1n cdc23f_qb cdc23f_ko1 0 0 nch W=1.2e-06 L=5e-07
ncdc23f_ki2p cdc23f_q cdc23f_qb vdd vsrc pch W=2.4e-06 L=5e-07
ncdc23f_ki2n cdc23f_q cdc23f_qb 0 0 nch W=1.2e-06 L=5e-07
rcdc23f_hra cdc23f_h vthr 1e+06
rcdc23f_hrf cdc23f_h cdc23f_qb 1.9e+07
ccdc23f_hc cdc23f_h 0 2.1e-09
ncdc23f_dis cdc23f_vm cdc23f_q cdc23f_vmd 0 nch W=4e-06 L=1e-06
va_rcdc23f_rdis_n vrest rcdc23f_rdis_n 0
rcdc23f_rdis cdc23f_vmd rcdc23f_rdis_n 12000
ncdc23f_rp cdc23f_rt cdc23f_qb vdd vsrc pch W=2e-06 L=1e-06
rcdc23f_rrc cdc23f_rt cdc23f_rec 10000
ccdc23f_rc cdc23f_rec 0 1e-07
rcdc23f_rr cdc23f_rec 0 8.2e+06
ncdc23f_sh1 cdc23f_vm cdc23f_rec cdc23f_vms 0 nch W=2e-06 L=1e-06
va_ncdc23f_sh2_s vrest ncdc23f_sh2_s 0
ncdc23f_sh2 cdc23f_vms cdc23f_qb ncdc23f_sh2_s 0 nch W=2e-06 L=1e-06
ncdc23f_porh cdc23f_h por_hold vthr 0 nch W=2e-06 L=1e-06
va_ncdc23f_porm_s vrest ncdc23f_porm_s 0
ncdc23f_porm cdc23f_vm por_hold ncdc23f_porm_s 0 nch W=2e-06 L=1e-06
ncdc23f_op_tsw cdc23f_op_tt cdc23f_qb vdd vsrc pch W=2e-06 L=1e-06
rcdc23f_op_trc cdc23f_op_tt cdc23f_op_at 10000
ccdc23f_op_tc cdc23f_op_at 0 1e-07
rcdc23f_op_trl cdc23f_op_at 0 2.2e+07
ncdc23f_op_sh1p cdc23f_op_an cdc23f_op_at vdd vsrc pch W=2.4e-06 L=5e-07
ncdc23f_op_sh1n cdc23f_op_an cdc23f_op_at 0 0 nch W=1.2e-06 L=5e-07
ncdc23f_op_sh2p cdc23f_op_aq cdc23f_op_an vdd vsrc pch W=2.4e-06 L=5e-07
ncdc23f_op_sh2n cdc23f_op_aq cdc23f_op_an 0 0 nch W=1.2e-06 L=5e-07
ncdc23f_op_abp cdc23f_op_aqb cdc23f_op_aq vdd vsrc pch W=2.4e-06 L=5e-07
ncdc23f_op_abn cdc23f_op_aqb cdc23f_op_aq 0 0 nch W=1.2e-06 L=5e-07
rcdc23f_op_dr cdc23f_op_aq cdc23f_op_ad 1e+06
ccdc23f_op_dc cdc23f_op_ad 0 3.3e-07
ncdc23f_op_d2p cdc23f_op_adn cdc23f_op_ad vdd vsrc pch W=2.4e-06 L=5e-07
ncdc23f_op_d2n cdc23f_op_adn cdc23f_op_ad 0 0 nch W=1.2e-06 L=5e-07
ncdc23f_op_gpa cdc23f_op_pb cdc23f_op_aq vdd vsrc pch W=2.4e-06 L=5e-07
ncdc23f_op_gpb cdc23f_op_pb cdc23f_op_adn vdd vsrc pch W=2.4e-06 L=5e-07
ncdc23f_op_gna cdc23f_op_pb cdc23f_op_aq cdc23f_op_gx 0 nch W=2.4e-06 L=5e-07
ncdc23f_op_gnb cdc23f_op_gx cdc23f_op_adn 0 0 nch W=2.4e-06 L=5e-07
ncdc23f_op_op cdc23f_op_p cdc23f_op_pb vdd vsrc pch W=2.4e-06 L=5e-07
ncdc23f_op_on cdc23f_op_p cdc23f_op_pb 0 0 nch W=1.2e-06 L=5e-07
ncdc23f_st_mh cdc23f_mi cdc23f_hs cdc23f_st_x 0 nch W=2e-06 L=4e-06
ncdc23f_st_mp cdc23f_st_x thc23f_op_aq 0 0 nch W=4e-06 L=1e-06
ncdc23f_rm_md cdc23f_mi cdc23f_mi vdd vsrc pch W=4e-06 L=2e-06
ncdc23f_rm_mo cdc23f_vm cdc23f_mi vdd vsrc pch W=1e-06 L=8e-06
ncdc23f_kh cdc23f_vm cdc23f_hc cdc23f_kx 0 nch W=2e-06 L=4e-06
va_ncdc23f_kp_s vrest ncdc23f_kp_s 0
ncdc23f_kp cdc23f_kx thc23f_op_aq ncdc23f_kp_s 0 nch W=4e-06 L=1e-06
ncdc23r_hsf_sw cdc23r_hsf_sd sgc23r_op_aqb vdd vsrc pch W=4e-06 L=5e-07
rcdc23r_hsf_rr cdc23r_hsf_sd cdc23r_hsf_h1 100000
ccdc23r_hsf_c1 cdc23r_hsf_h1 0 1e-06
rcdc23r_hsf_r2 cdc23r_hsf_h1 cdc23r_hs 1e+06
ccdc23r_hsf_c2 cdc23r_hs 0 4.7e-07
rcdc23r_hsf_rl cdc23r_hs 0 4.7e+06
ncdc23r_hcf_sw cdc23r_hcf_sd sgc23f_op_aqb vdd vsrc pch W=4e-06 L=5e-07
rcdc23r_hcf_rr cdc23r_hcf_sd cdc23r_hcf_h1 100000
ccdc23r_hcf_c1 cdc23r_hcf_h1 0 1e-06
rcdc23r_hcf_r2 cdc23r_hcf_h1 cdc23r_hc 1e+06
ccdc23r_hcf_c2 cdc23r_hc 0 4.7e-07
rcdc23r_hcf_rl cdc23r_hc 0 4.7e+06
ccdc23r_cm cdc23r_vm 0 1.5e-06
va_rcdc23r_rm_n vrest rcdc23r_rm_n 0
rcdc23r_rm cdc23r_vm rcdc23r_rm_n 1e+06
rcdc23r_kb vdd cdc23r_knb 1e+06
ncdc23r_kmb cdc23r_knb cdc23r_knb 0 0 nch W=4e-06 L=4e-06
ncdc23r_kmt cdc23r_ktail cdc23r_knb 0 0 nch W=4e-06 L=4e-06
ncdc23r_km1 cdc23r_kd1 cdc23r_vm cdc23r_ktail 0 nch W=4e-06 L=4e-06
ncdc23r_km2 cdc23r_ko1 cdc23r_h cdc23r_ktail 0 nch W=4e-06 L=4e-06
ncdc23r_km3 cdc23r_kd1 cdc23r_kd1 vdd vsrc pch W=4e-06 L=4e-06
ncdc23r_km4 cdc23r_ko1 cdc23r_kd1 vdd vsrc pch W=4e-06 L=4e-06
ncdc23r_kporclamp cdc23r_ko1 por_hold 0 0 nch W=4e-06 L=1e-06
ncdc23r_ki1p cdc23r_qb cdc23r_ko1 vdd vsrc pch W=2.4e-06 L=5e-07
ncdc23r_ki1n cdc23r_qb cdc23r_ko1 0 0 nch W=1.2e-06 L=5e-07
ncdc23r_ki2p cdc23r_q cdc23r_qb vdd vsrc pch W=2.4e-06 L=5e-07
ncdc23r_ki2n cdc23r_q cdc23r_qb 0 0 nch W=1.2e-06 L=5e-07
rcdc23r_hra cdc23r_h vthr 1e+06
rcdc23r_hrf cdc23r_h cdc23r_qb 1.9e+07
ccdc23r_hc cdc23r_h 0 2.1e-09
ncdc23r_dis cdc23r_vm cdc23r_q cdc23r_vmd 0 nch W=4e-06 L=1e-06
va_rcdc23r_rdis_n vrest rcdc23r_rdis_n 0
rcdc23r_rdis cdc23r_vmd rcdc23r_rdis_n 12000
ncdc23r_rp cdc23r_rt cdc23r_qb vdd vsrc pch W=2e-06 L=1e-06
rcdc23r_rrc cdc23r_rt cdc23r_rec 10000
ccdc23r_rc cdc23r_rec 0 1e-07
rcdc23r_rr cdc23r_rec 0 8.2e+06
ncdc23r_sh1 cdc23r_vm cdc23r_rec cdc23r_vms 0 nch W=2e-06 L=1e-06
va_ncdc23r_sh2_s vrest ncdc23r_sh2_s 0
ncdc23r_sh2 cdc23r_vms cdc23r_qb ncdc23r_sh2_s 0 nch W=2e-06 L=1e-06
ncdc23r_porh cdc23r_h por_hold vthr 0 nch W=2e-06 L=1e-06
va_ncdc23r_porm_s vrest ncdc23r_porm_s 0
ncdc23r_porm cdc23r_vm por_hold ncdc23r_porm_s 0 nch W=2e-06 L=1e-06
ncdc23r_op_tsw cdc23r_op_tt cdc23r_qb vdd vsrc pch W=2e-06 L=1e-06
rcdc23r_op_trc cdc23r_op_tt cdc23r_op_at 10000
ccdc23r_op_tc cdc23r_op_at 0 1e-07
rcdc23r_op_trl cdc23r_op_at 0 2.2e+07
ncdc23r_op_sh1p cdc23r_op_an cdc23r_op_at vdd vsrc pch W=2.4e-06 L=5e-07
ncdc23r_op_sh1n cdc23r_op_an cdc23r_op_at 0 0 nch W=1.2e-06 L=5e-07
ncdc23r_op_sh2p cdc23r_op_aq cdc23r_op_an vdd vsrc pch W=2.4e-06 L=5e-07
ncdc23r_op_sh2n cdc23r_op_aq cdc23r_op_an 0 0 nch W=1.2e-06 L=5e-07
ncdc23r_op_abp cdc23r_op_aqb cdc23r_op_aq vdd vsrc pch W=2.4e-06 L=5e-07
ncdc23r_op_abn cdc23r_op_aqb cdc23r_op_aq 0 0 nch W=1.2e-06 L=5e-07
rcdc23r_op_dr cdc23r_op_aq cdc23r_op_ad 1e+06
ccdc23r_op_dc cdc23r_op_ad 0 3.3e-07
ncdc23r_op_d2p cdc23r_op_adn cdc23r_op_ad vdd vsrc pch W=2.4e-06 L=5e-07
ncdc23r_op_d2n cdc23r_op_adn cdc23r_op_ad 0 0 nch W=1.2e-06 L=5e-07
ncdc23r_op_gpa cdc23r_op_pb cdc23r_op_aq vdd vsrc pch W=2.4e-06 L=5e-07
ncdc23r_op_gpb cdc23r_op_pb cdc23r_op_adn vdd vsrc pch W=2.4e-06 L=5e-07
ncdc23r_op_gna cdc23r_op_pb cdc23r_op_aq cdc23r_op_gx 0 nch W=2.4e-06 L=5e-07
ncdc23r_op_gnb cdc23r_op_gx cdc23r_op_adn 0 0 nch W=2.4e-06 L=5e-07
ncdc23r_op_op cdc23r_op_p cdc23r_op_pb vdd vsrc pch W=2.4e-06 L=5e-07
ncdc23r_op_on cdc23r_op_p cdc23r_op_pb 0 0 nch W=1.2e-06 L=5e-07
ncdc23r_st_mh cdc23r_mi cdc23r_hs cdc23r_st_x 0 nch W=2e-06 L=4e-06
ncdc23r_st_mp cdc23r_st_x thc23r_op_aq 0 0 nch W=4e-06 L=1e-06
ncdc23r_rm_md cdc23r_mi cdc23r_mi vdd vsrc pch W=4e-06 L=2e-06
ncdc23r_rm_mo cdc23r_vm cdc23r_mi vdd vsrc pch W=1e-06 L=8e-06
ncdc23r_kh cdc23r_vm cdc23r_hc cdc23r_kx 0 nch W=2e-06 L=4e-06
va_ncdc23r_kp_s vrest ncdc23r_kp_s 0
ncdc23r_kp cdc23r_kx thc23r_op_aq ncdc23r_kp_s 0 nch W=4e-06 L=1e-06
ncdc34f_hsf_sw cdc34f_hsf_sd sgc34f_op_aqb vdd vsrc pch W=4e-06 L=5e-07
rcdc34f_hsf_rr cdc34f_hsf_sd cdc34f_hsf_h1 100000
ccdc34f_hsf_c1 cdc34f_hsf_h1 0 1e-06
rcdc34f_hsf_r2 cdc34f_hsf_h1 cdc34f_hs 1e+06
ccdc34f_hsf_c2 cdc34f_hs 0 4.7e-07
rcdc34f_hsf_rl cdc34f_hs 0 4.7e+06
ncdc34f_hcf_sw cdc34f_hcf_sd sgc34r_op_aqb vdd vsrc pch W=4e-06 L=5e-07
rcdc34f_hcf_rr cdc34f_hcf_sd cdc34f_hcf_h1 100000
ccdc34f_hcf_c1 cdc34f_hcf_h1 0 1e-06
rcdc34f_hcf_r2 cdc34f_hcf_h1 cdc34f_hc 1e+06
ccdc34f_hcf_c2 cdc34f_hc 0 4.7e-07
rcdc34f_hcf_rl cdc34f_hc 0 4.7e+06
ccdc34f_cm cdc34f_vm 0 1.5e-06
va_rcdc34f_rm_n vrest rcdc34f_rm_n 0
rcdc34f_rm cdc34f_vm rcdc34f_rm_n 1e+06
rcdc34f_kb vdd cdc34f_knb 1e+06
ncdc34f_kmb cdc34f_knb cdc34f_knb 0 0 nch W=4e-06 L=4e-06
ncdc34f_kmt cdc34f_ktail cdc34f_knb 0 0 nch W=4e-06 L=4e-06
ncdc34f_km1 cdc34f_kd1 cdc34f_vm cdc34f_ktail 0 nch W=4e-06 L=4e-06
ncdc34f_km2 cdc34f_ko1 cdc34f_h cdc34f_ktail 0 nch W=4e-06 L=4e-06
ncdc34f_km3 cdc34f_kd1 cdc34f_kd1 vdd vsrc pch W=4e-06 L=4e-06
ncdc34f_km4 cdc34f_ko1 cdc34f_kd1 vdd vsrc pch W=4e-06 L=4e-06
ncdc34f_kporclamp cdc34f_ko1 por_hold 0 0 nch W=4e-06 L=1e-06
ncdc34f_ki1p cdc34f_qb cdc34f_ko1 vdd vsrc pch W=2.4e-06 L=5e-07
ncdc34f_ki1n cdc34f_qb cdc34f_ko1 0 0 nch W=1.2e-06 L=5e-07
ncdc34f_ki2p cdc34f_q cdc34f_qb vdd vsrc pch W=2.4e-06 L=5e-07
ncdc34f_ki2n cdc34f_q cdc34f_qb 0 0 nch W=1.2e-06 L=5e-07
rcdc34f_hra cdc34f_h vthr 1e+06
rcdc34f_hrf cdc34f_h cdc34f_qb 1.9e+07
ccdc34f_hc cdc34f_h 0 2.1e-09
ncdc34f_dis cdc34f_vm cdc34f_q cdc34f_vmd 0 nch W=4e-06 L=1e-06
va_rcdc34f_rdis_n vrest rcdc34f_rdis_n 0
rcdc34f_rdis cdc34f_vmd rcdc34f_rdis_n 12000
ncdc34f_rp cdc34f_rt cdc34f_qb vdd vsrc pch W=2e-06 L=1e-06
rcdc34f_rrc cdc34f_rt cdc34f_rec 10000
ccdc34f_rc cdc34f_rec 0 1e-07
rcdc34f_rr cdc34f_rec 0 8.2e+06
ncdc34f_sh1 cdc34f_vm cdc34f_rec cdc34f_vms 0 nch W=2e-06 L=1e-06
va_ncdc34f_sh2_s vrest ncdc34f_sh2_s 0
ncdc34f_sh2 cdc34f_vms cdc34f_qb ncdc34f_sh2_s 0 nch W=2e-06 L=1e-06
ncdc34f_porh cdc34f_h por_hold vthr 0 nch W=2e-06 L=1e-06
va_ncdc34f_porm_s vrest ncdc34f_porm_s 0
ncdc34f_porm cdc34f_vm por_hold ncdc34f_porm_s 0 nch W=2e-06 L=1e-06
ncdc34f_op_tsw cdc34f_op_tt cdc34f_qb vdd vsrc pch W=2e-06 L=1e-06
rcdc34f_op_trc cdc34f_op_tt cdc34f_op_at 10000
ccdc34f_op_tc cdc34f_op_at 0 1e-07
rcdc34f_op_trl cdc34f_op_at 0 2.2e+07
ncdc34f_op_sh1p cdc34f_op_an cdc34f_op_at vdd vsrc pch W=2.4e-06 L=5e-07
ncdc34f_op_sh1n cdc34f_op_an cdc34f_op_at 0 0 nch W=1.2e-06 L=5e-07
ncdc34f_op_sh2p cdc34f_op_aq cdc34f_op_an vdd vsrc pch W=2.4e-06 L=5e-07
ncdc34f_op_sh2n cdc34f_op_aq cdc34f_op_an 0 0 nch W=1.2e-06 L=5e-07
ncdc34f_op_abp cdc34f_op_aqb cdc34f_op_aq vdd vsrc pch W=2.4e-06 L=5e-07
ncdc34f_op_abn cdc34f_op_aqb cdc34f_op_aq 0 0 nch W=1.2e-06 L=5e-07
rcdc34f_op_dr cdc34f_op_aq cdc34f_op_ad 1e+06
ccdc34f_op_dc cdc34f_op_ad 0 3.3e-07
ncdc34f_op_d2p cdc34f_op_adn cdc34f_op_ad vdd vsrc pch W=2.4e-06 L=5e-07
ncdc34f_op_d2n cdc34f_op_adn cdc34f_op_ad 0 0 nch W=1.2e-06 L=5e-07
ncdc34f_op_gpa cdc34f_op_pb cdc34f_op_aq vdd vsrc pch W=2.4e-06 L=5e-07
ncdc34f_op_gpb cdc34f_op_pb cdc34f_op_adn vdd vsrc pch W=2.4e-06 L=5e-07
ncdc34f_op_gna cdc34f_op_pb cdc34f_op_aq cdc34f_op_gx 0 nch W=2.4e-06 L=5e-07
ncdc34f_op_gnb cdc34f_op_gx cdc34f_op_adn 0 0 nch W=2.4e-06 L=5e-07
ncdc34f_op_op cdc34f_op_p cdc34f_op_pb vdd vsrc pch W=2.4e-06 L=5e-07
ncdc34f_op_on cdc34f_op_p cdc34f_op_pb 0 0 nch W=1.2e-06 L=5e-07
ncdc34f_st_mh cdc34f_mi cdc34f_hs cdc34f_st_x 0 nch W=2e-06 L=4e-06
ncdc34f_st_mp cdc34f_st_x thc34f_op_aq 0 0 nch W=4e-06 L=1e-06
ncdc34f_rm_md cdc34f_mi cdc34f_mi vdd vsrc pch W=4e-06 L=2e-06
ncdc34f_rm_mo cdc34f_vm cdc34f_mi vdd vsrc pch W=1e-06 L=8e-06
ncdc34f_kh cdc34f_vm cdc34f_hc cdc34f_kx 0 nch W=2e-06 L=4e-06
va_ncdc34f_kp_s vrest ncdc34f_kp_s 0
ncdc34f_kp cdc34f_kx thc34f_op_aq ncdc34f_kp_s 0 nch W=4e-06 L=1e-06
ncdc34r_hsf_sw cdc34r_hsf_sd sgc34r_op_aqb vdd vsrc pch W=4e-06 L=5e-07
rcdc34r_hsf_rr cdc34r_hsf_sd cdc34r_hsf_h1 100000
ccdc34r_hsf_c1 cdc34r_hsf_h1 0 1e-06
rcdc34r_hsf_r2 cdc34r_hsf_h1 cdc34r_hs 1e+06
ccdc34r_hsf_c2 cdc34r_hs 0 4.7e-07
rcdc34r_hsf_rl cdc34r_hs 0 4.7e+06
ncdc34r_hcf_sw cdc34r_hcf_sd sgc34f_op_aqb vdd vsrc pch W=4e-06 L=5e-07
rcdc34r_hcf_rr cdc34r_hcf_sd cdc34r_hcf_h1 100000
ccdc34r_hcf_c1 cdc34r_hcf_h1 0 1e-06
rcdc34r_hcf_r2 cdc34r_hcf_h1 cdc34r_hc 1e+06
ccdc34r_hcf_c2 cdc34r_hc 0 4.7e-07
rcdc34r_hcf_rl cdc34r_hc 0 4.7e+06
ccdc34r_cm cdc34r_vm 0 1.5e-06
va_rcdc34r_rm_n vrest rcdc34r_rm_n 0
rcdc34r_rm cdc34r_vm rcdc34r_rm_n 1e+06
rcdc34r_kb vdd cdc34r_knb 1e+06
ncdc34r_kmb cdc34r_knb cdc34r_knb 0 0 nch W=4e-06 L=4e-06
ncdc34r_kmt cdc34r_ktail cdc34r_knb 0 0 nch W=4e-06 L=4e-06
ncdc34r_km1 cdc34r_kd1 cdc34r_vm cdc34r_ktail 0 nch W=4e-06 L=4e-06
ncdc34r_km2 cdc34r_ko1 cdc34r_h cdc34r_ktail 0 nch W=4e-06 L=4e-06
ncdc34r_km3 cdc34r_kd1 cdc34r_kd1 vdd vsrc pch W=4e-06 L=4e-06
ncdc34r_km4 cdc34r_ko1 cdc34r_kd1 vdd vsrc pch W=4e-06 L=4e-06
ncdc34r_kporclamp cdc34r_ko1 por_hold 0 0 nch W=4e-06 L=1e-06
ncdc34r_ki1p cdc34r_qb cdc34r_ko1 vdd vsrc pch W=2.4e-06 L=5e-07
ncdc34r_ki1n cdc34r_qb cdc34r_ko1 0 0 nch W=1.2e-06 L=5e-07
ncdc34r_ki2p cdc34r_q cdc34r_qb vdd vsrc pch W=2.4e-06 L=5e-07
ncdc34r_ki2n cdc34r_q cdc34r_qb 0 0 nch W=1.2e-06 L=5e-07
rcdc34r_hra cdc34r_h vthr 1e+06
rcdc34r_hrf cdc34r_h cdc34r_qb 1.9e+07
ccdc34r_hc cdc34r_h 0 2.1e-09
ncdc34r_dis cdc34r_vm cdc34r_q cdc34r_vmd 0 nch W=4e-06 L=1e-06
va_rcdc34r_rdis_n vrest rcdc34r_rdis_n 0
rcdc34r_rdis cdc34r_vmd rcdc34r_rdis_n 12000
ncdc34r_rp cdc34r_rt cdc34r_qb vdd vsrc pch W=2e-06 L=1e-06
rcdc34r_rrc cdc34r_rt cdc34r_rec 10000
ccdc34r_rc cdc34r_rec 0 1e-07
rcdc34r_rr cdc34r_rec 0 8.2e+06
ncdc34r_sh1 cdc34r_vm cdc34r_rec cdc34r_vms 0 nch W=2e-06 L=1e-06
va_ncdc34r_sh2_s vrest ncdc34r_sh2_s 0
ncdc34r_sh2 cdc34r_vms cdc34r_qb ncdc34r_sh2_s 0 nch W=2e-06 L=1e-06
ncdc34r_porh cdc34r_h por_hold vthr 0 nch W=2e-06 L=1e-06
va_ncdc34r_porm_s vrest ncdc34r_porm_s 0
ncdc34r_porm cdc34r_vm por_hold ncdc34r_porm_s 0 nch W=2e-06 L=1e-06
ncdc34r_op_tsw cdc34r_op_tt cdc34r_qb vdd vsrc pch W=2e-06 L=1e-06
rcdc34r_op_trc cdc34r_op_tt cdc34r_op_at 10000
ccdc34r_op_tc cdc34r_op_at 0 1e-07
rcdc34r_op_trl cdc34r_op_at 0 2.2e+07
ncdc34r_op_sh1p cdc34r_op_an cdc34r_op_at vdd vsrc pch W=2.4e-06 L=5e-07
ncdc34r_op_sh1n cdc34r_op_an cdc34r_op_at 0 0 nch W=1.2e-06 L=5e-07
ncdc34r_op_sh2p cdc34r_op_aq cdc34r_op_an vdd vsrc pch W=2.4e-06 L=5e-07
ncdc34r_op_sh2n cdc34r_op_aq cdc34r_op_an 0 0 nch W=1.2e-06 L=5e-07
ncdc34r_op_abp cdc34r_op_aqb cdc34r_op_aq vdd vsrc pch W=2.4e-06 L=5e-07
ncdc34r_op_abn cdc34r_op_aqb cdc34r_op_aq 0 0 nch W=1.2e-06 L=5e-07
rcdc34r_op_dr cdc34r_op_aq cdc34r_op_ad 1e+06
ccdc34r_op_dc cdc34r_op_ad 0 3.3e-07
ncdc34r_op_d2p cdc34r_op_adn cdc34r_op_ad vdd vsrc pch W=2.4e-06 L=5e-07
ncdc34r_op_d2n cdc34r_op_adn cdc34r_op_ad 0 0 nch W=1.2e-06 L=5e-07
ncdc34r_op_gpa cdc34r_op_pb cdc34r_op_aq vdd vsrc pch W=2.4e-06 L=5e-07
ncdc34r_op_gpb cdc34r_op_pb cdc34r_op_adn vdd vsrc pch W=2.4e-06 L=5e-07
ncdc34r_op_gna cdc34r_op_pb cdc34r_op_aq cdc34r_op_gx 0 nch W=2.4e-06 L=5e-07
ncdc34r_op_gnb cdc34r_op_gx cdc34r_op_adn 0 0 nch W=2.4e-06 L=5e-07
ncdc34r_op_op cdc34r_op_p cdc34r_op_pb vdd vsrc pch W=2.4e-06 L=5e-07
ncdc34r_op_on cdc34r_op_p cdc34r_op_pb 0 0 nch W=1.2e-06 L=5e-07
ncdc34r_st_mh cdc34r_mi cdc34r_hs cdc34r_st_x 0 nch W=2e-06 L=4e-06
ncdc34r_st_mp cdc34r_st_x thc34r_op_aq 0 0 nch W=4e-06 L=1e-06
ncdc34r_rm_md cdc34r_mi cdc34r_mi vdd vsrc pch W=4e-06 L=2e-06
ncdc34r_rm_mo cdc34r_vm cdc34r_mi vdd vsrc pch W=1e-06 L=8e-06
ncdc34r_kh cdc34r_vm cdc34r_hc cdc34r_kx 0 nch W=2e-06 L=4e-06
va_ncdc34r_kp_s vrest ncdc34r_kp_s 0
ncdc34r_kp cdc34r_kx thc34r_op_aq ncdc34r_kp_s 0 nch W=4e-06 L=1e-06
cldpos load_pos vmid 1e-06
rldpos load_pos vmid 100000
nagw12f_eni_p agw12f_ena cdw12f_op_aqb vdd vsrc pch W=2.4e-06 L=5e-07
nagw12f_eni_n agw12f_ena cdw12f_op_aqb 0 0 nch W=1.2e-06 L=5e-07
nagw12f_cp load_pos agw12f_cg vdd vsrc pch W=4e-06 L=4e-06
nagw12f_bias irefp_n cdw12f_op_aqb agw12f_cg vsrc pch W=1.2e-06 L=1e-06
nagw12f_off agw12f_cg agw12f_ena vdd vsrc pch W=2.4e-06 L=1e-06
nagw23f_eni_p agw23f_ena cdw23f_op_aqb vdd vsrc pch W=2.4e-06 L=5e-07
nagw23f_eni_n agw23f_ena cdw23f_op_aqb 0 0 nch W=1.2e-06 L=5e-07
nagw23f_cp load_pos agw23f_cg vdd vsrc pch W=4e-06 L=4e-06
nagw23f_bias irefp_n cdw23f_op_aqb agw23f_cg vsrc pch W=1.2e-06 L=1e-06
nagw23f_off agw23f_cg agw23f_ena vdd vsrc pch W=2.4e-06 L=1e-06
nagw34f_eni_p agw34f_ena cdw34f_op_aqb vdd vsrc pch W=2.4e-06 L=5e-07
nagw34f_eni_n agw34f_ena cdw34f_op_aqb 0 0 nch W=1.2e-06 L=5e-07
nagw34f_cp load_pos agw34f_cg vdd vsrc pch W=4e-06 L=4e-06
nagw34f_bias irefp_n cdw34f_op_aqb agw34f_cg vsrc pch W=1.2e-06 L=1e-06
nagw34f_off agw34f_cg agw34f_ena vdd vsrc pch W=2.4e-06 L=1e-06
nagc12f_eni_p agc12f_ena cdc12f_op_aqb vdd vsrc pch W=2.4e-06 L=5e-07
nagc12f_eni_n agc12f_ena cdc12f_op_aqb 0 0 nch W=1.2e-06 L=5e-07
nagc12f_cp load_pos agc12f_cg vdd vsrc pch W=4e-06 L=4e-06
nagc12f_bias irefp_n cdc12f_op_aqb agc12f_cg vsrc pch W=1.2e-06 L=1e-06
nagc12f_off agc12f_cg agc12f_ena vdd vsrc pch W=2.4e-06 L=1e-06
nagc23f_eni_p agc23f_ena cdc23f_op_aqb vdd vsrc pch W=2.4e-06 L=5e-07
nagc23f_eni_n agc23f_ena cdc23f_op_aqb 0 0 nch W=1.2e-06 L=5e-07
nagc23f_cp load_pos agc23f_cg vdd vsrc pch W=4e-06 L=4e-06
nagc23f_bias irefp_n cdc23f_op_aqb agc23f_cg vsrc pch W=1.2e-06 L=1e-06
nagc23f_off agc23f_cg agc23f_ena vdd vsrc pch W=2.4e-06 L=1e-06
nagc34f_eni_p agc34f_ena cdc34f_op_aqb vdd vsrc pch W=2.4e-06 L=5e-07
nagc34f_eni_n agc34f_ena cdc34f_op_aqb 0 0 nch W=1.2e-06 L=5e-07
nagc34f_cp load_pos agc34f_cg vdd vsrc pch W=4e-06 L=4e-06
nagc34f_bias irefp_n cdc34f_op_aqb agc34f_cg vsrc pch W=1.2e-06 L=1e-06
nagc34f_off agc34f_cg agc34f_ena vdd vsrc pch W=2.4e-06 L=1e-06
cldneg load_neg vmid 1e-06
rldneg load_neg vmid 100000
nagw12r_eni_p agw12r_ena cdw12r_op_aqb vdd vsrc pch W=2.4e-06 L=5e-07
nagw12r_eni_n agw12r_ena cdw12r_op_aqb 0 0 nch W=1.2e-06 L=5e-07
nagw12r_cp load_neg agw12r_cg vdd vsrc pch W=4e-06 L=4e-06
nagw12r_bias irefp_n cdw12r_op_aqb agw12r_cg vsrc pch W=1.2e-06 L=1e-06
nagw12r_off agw12r_cg agw12r_ena vdd vsrc pch W=2.4e-06 L=1e-06
nagw23r_eni_p agw23r_ena cdw23r_op_aqb vdd vsrc pch W=2.4e-06 L=5e-07
nagw23r_eni_n agw23r_ena cdw23r_op_aqb 0 0 nch W=1.2e-06 L=5e-07
nagw23r_cp load_neg agw23r_cg vdd vsrc pch W=4e-06 L=4e-06
nagw23r_bias irefp_n cdw23r_op_aqb agw23r_cg vsrc pch W=1.2e-06 L=1e-06
nagw23r_off agw23r_cg agw23r_ena vdd vsrc pch W=2.4e-06 L=1e-06
nagw34r_eni_p agw34r_ena cdw34r_op_aqb vdd vsrc pch W=2.4e-06 L=5e-07
nagw34r_eni_n agw34r_ena cdw34r_op_aqb 0 0 nch W=1.2e-06 L=5e-07
nagw34r_cp load_neg agw34r_cg vdd vsrc pch W=4e-06 L=4e-06
nagw34r_bias irefp_n cdw34r_op_aqb agw34r_cg vsrc pch W=1.2e-06 L=1e-06
nagw34r_off agw34r_cg agw34r_ena vdd vsrc pch W=2.4e-06 L=1e-06
nagc12r_eni_p agc12r_ena cdc12r_op_aqb vdd vsrc pch W=2.4e-06 L=5e-07
nagc12r_eni_n agc12r_ena cdc12r_op_aqb 0 0 nch W=1.2e-06 L=5e-07
nagc12r_cp load_neg agc12r_cg vdd vsrc pch W=4e-06 L=4e-06
nagc12r_bias irefp_n cdc12r_op_aqb agc12r_cg vsrc pch W=1.2e-06 L=1e-06
nagc12r_off agc12r_cg agc12r_ena vdd vsrc pch W=2.4e-06 L=1e-06
nagc23r_eni_p agc23r_ena cdc23r_op_aqb vdd vsrc pch W=2.4e-06 L=5e-07
nagc23r_eni_n agc23r_ena cdc23r_op_aqb 0 0 nch W=1.2e-06 L=5e-07
nagc23r_cp load_neg agc23r_cg vdd vsrc pch W=4e-06 L=4e-06
nagc23r_bias irefp_n cdc23r_op_aqb agc23r_cg vsrc pch W=1.2e-06 L=1e-06
nagc23r_off agc23r_cg agc23r_ena vdd vsrc pch W=2.4e-06 L=1e-06
nagc34r_eni_p agc34r_ena cdc34r_op_aqb vdd vsrc pch W=2.4e-06 L=5e-07
nagc34r_eni_n agc34r_ena cdc34r_op_aqb 0 0 nch W=1.2e-06 L=5e-07
nagc34r_cp load_neg agc34r_cg vdd vsrc pch W=4e-06 L=4e-06
nagc34r_bias irefp_n cdc34r_op_aqb agc34r_cg vsrc pch W=1.2e-06 L=1e-06
nagc34r_off agc34r_cg agc34r_ena vdd vsrc pch W=2.4e-06 L=1e-06
cpar_agc12f_cg agc12f_cg 0 5e-14
cpar_agc12f_ena agc12f_ena 0 5e-14
cpar_agc12r_cg agc12r_cg 0 5e-14
cpar_agc12r_ena agc12r_ena 0 5e-14
cpar_agc23f_cg agc23f_cg 0 5e-14
cpar_agc23f_ena agc23f_ena 0 5e-14
cpar_agc23r_cg agc23r_cg 0 5e-14
cpar_agc23r_ena agc23r_ena 0 5e-14
cpar_agc34f_cg agc34f_cg 0 5e-14
cpar_agc34f_ena agc34f_ena 0 5e-14
cpar_agc34r_cg agc34r_cg 0 5e-14
cpar_agc34r_ena agc34r_ena 0 5e-14
cpar_agw12f_cg agw12f_cg 0 5e-14
cpar_agw12f_ena agw12f_ena 0 5e-14
cpar_agw12r_cg agw12r_cg 0 5e-14
cpar_agw12r_ena agw12r_ena 0 5e-14
cpar_agw23f_cg agw23f_cg 0 5e-14
cpar_agw23f_ena agw23f_ena 0 5e-14
cpar_agw23r_cg agw23r_cg 0 5e-14
cpar_agw23r_ena agw23r_ena 0 5e-14
cpar_agw34f_cg agw34f_cg 0 5e-14
cpar_agw34f_ena agw34f_ena 0 5e-14
cpar_agw34r_cg agw34r_cg 0 5e-14
cpar_agw34r_ena agw34r_ena 0 5e-14
cpar_cdc12f_h cdc12f_h 0 5e-14
cpar_cdc12f_hc cdc12f_hc 0 5e-14
cpar_cdc12f_hcf_h1 cdc12f_hcf_h1 0 5e-14
cpar_cdc12f_hcf_sd cdc12f_hcf_sd 0 5e-14
cpar_cdc12f_hs cdc12f_hs 0 5e-14
cpar_cdc12f_hsf_h1 cdc12f_hsf_h1 0 5e-14
cpar_cdc12f_hsf_sd cdc12f_hsf_sd 0 5e-14
cpar_cdc12f_kd1 cdc12f_kd1 0 5e-14
cpar_cdc12f_knb cdc12f_knb 0 5e-14
cpar_cdc12f_ko1 cdc12f_ko1 0 5e-14
cpar_cdc12f_ktail cdc12f_ktail 0 5e-14
cpar_cdc12f_kx cdc12f_kx 0 5e-14
cpar_cdc12f_mi cdc12f_mi 0 5e-14
cpar_cdc12f_op_ad cdc12f_op_ad 0 5e-14
cpar_cdc12f_op_adn cdc12f_op_adn 0 5e-14
cpar_cdc12f_op_an cdc12f_op_an 0 5e-14
cpar_cdc12f_op_aq cdc12f_op_aq 0 5e-14
cpar_cdc12f_op_aqb cdc12f_op_aqb 0 5e-14
cpar_cdc12f_op_at cdc12f_op_at 0 5e-14
cpar_cdc12f_op_gx cdc12f_op_gx 0 5e-14
cpar_cdc12f_op_p cdc12f_op_p 0 5e-14
cpar_cdc12f_op_pb cdc12f_op_pb 0 5e-14
cpar_cdc12f_op_tt cdc12f_op_tt 0 5e-14
cpar_cdc12f_q cdc12f_q 0 5e-14
cpar_cdc12f_qb cdc12f_qb 0 5e-14
cpar_cdc12f_rec cdc12f_rec 0 5e-14
cpar_cdc12f_rt cdc12f_rt 0 5e-14
cpar_cdc12f_st_x cdc12f_st_x 0 5e-14
cpar_cdc12f_vm cdc12f_vm 0 5e-14
cpar_cdc12f_vmd cdc12f_vmd 0 5e-14
cpar_cdc12f_vms cdc12f_vms 0 5e-14
cpar_cdc12r_h cdc12r_h 0 5e-14
cpar_cdc12r_hc cdc12r_hc 0 5e-14
cpar_cdc12r_hcf_h1 cdc12r_hcf_h1 0 5e-14
cpar_cdc12r_hcf_sd cdc12r_hcf_sd 0 5e-14
cpar_cdc12r_hs cdc12r_hs 0 5e-14
cpar_cdc12r_hsf_h1 cdc12r_hsf_h1 0 5e-14
cpar_cdc12r_hsf_sd cdc12r_hsf_sd 0 5e-14
cpar_cdc12r_kd1 cdc12r_kd1 0 5e-14
cpar_cdc12r_knb cdc12r_knb 0 5e-14
cpar_cdc12r_ko1 cdc12r_ko1 0 5e-14
cpar_cdc12r_ktail cdc12r_ktail 0 5e-14
cpar_cdc12r_kx cdc12r_kx 0 5e-14
cpar_cdc12r_mi cdc12r_mi 0 5e-14
cpar_cdc12r_op_ad cdc12r_op_ad 0 5e-14
cpar_cdc12r_op_adn cdc12r_op_adn 0 5e-14
cpar_cdc12r_op_an cdc12r_op_an 0 5e-14
cpar_cdc12r_op_aq cdc12r_op_aq 0 5e-14
cpar_cdc12r_op_aqb cdc12r_op_aqb 0 5e-14
cpar_cdc12r_op_at cdc12r_op_at 0 5e-14
cpar_cdc12r_op_gx cdc12r_op_gx 0 5e-14
cpar_cdc12r_op_p cdc12r_op_p 0 5e-14
cpar_cdc12r_op_pb cdc12r_op_pb 0 5e-14
cpar_cdc12r_op_tt cdc12r_op_tt 0 5e-14
cpar_cdc12r_q cdc12r_q 0 5e-14
cpar_cdc12r_qb cdc12r_qb 0 5e-14
cpar_cdc12r_rec cdc12r_rec 0 5e-14
cpar_cdc12r_rt cdc12r_rt 0 5e-14
cpar_cdc12r_st_x cdc12r_st_x 0 5e-14
cpar_cdc12r_vm cdc12r_vm 0 5e-14
cpar_cdc12r_vmd cdc12r_vmd 0 5e-14
cpar_cdc12r_vms cdc12r_vms 0 5e-14
cpar_cdc23f_h cdc23f_h 0 5e-14
cpar_cdc23f_hc cdc23f_hc 0 5e-14
cpar_cdc23f_hcf_h1 cdc23f_hcf_h1 0 5e-14
cpar_cdc23f_hcf_sd cdc23f_hcf_sd 0 5e-14
cpar_cdc23f_hs cdc23f_hs 0 5e-14
cpar_cdc23f_hsf_h1 cdc23f_hsf_h1 0 5e-14
cpar_cdc23f_hsf_sd cdc23f_hsf_sd 0 5e-14
cpar_cdc23f_kd1 cdc23f_kd1 0 5e-14
cpar_cdc23f_knb cdc23f_knb 0 5e-14
cpar_cdc23f_ko1 cdc23f_ko1 0 5e-14
cpar_cdc23f_ktail cdc23f_ktail 0 5e-14
cpar_cdc23f_kx cdc23f_kx 0 5e-14
cpar_cdc23f_mi cdc23f_mi 0 5e-14
cpar_cdc23f_op_ad cdc23f_op_ad 0 5e-14
cpar_cdc23f_op_adn cdc23f_op_adn 0 5e-14
cpar_cdc23f_op_an cdc23f_op_an 0 5e-14
cpar_cdc23f_op_aq cdc23f_op_aq 0 5e-14
cpar_cdc23f_op_aqb cdc23f_op_aqb 0 5e-14
cpar_cdc23f_op_at cdc23f_op_at 0 5e-14
cpar_cdc23f_op_gx cdc23f_op_gx 0 5e-14
cpar_cdc23f_op_p cdc23f_op_p 0 5e-14
cpar_cdc23f_op_pb cdc23f_op_pb 0 5e-14
cpar_cdc23f_op_tt cdc23f_op_tt 0 5e-14
cpar_cdc23f_q cdc23f_q 0 5e-14
cpar_cdc23f_qb cdc23f_qb 0 5e-14
cpar_cdc23f_rec cdc23f_rec 0 5e-14
cpar_cdc23f_rt cdc23f_rt 0 5e-14
cpar_cdc23f_st_x cdc23f_st_x 0 5e-14
cpar_cdc23f_vm cdc23f_vm 0 5e-14
cpar_cdc23f_vmd cdc23f_vmd 0 5e-14
cpar_cdc23f_vms cdc23f_vms 0 5e-14
cpar_cdc23r_h cdc23r_h 0 5e-14
cpar_cdc23r_hc cdc23r_hc 0 5e-14
cpar_cdc23r_hcf_h1 cdc23r_hcf_h1 0 5e-14
cpar_cdc23r_hcf_sd cdc23r_hcf_sd 0 5e-14
cpar_cdc23r_hs cdc23r_hs 0 5e-14
cpar_cdc23r_hsf_h1 cdc23r_hsf_h1 0 5e-14
cpar_cdc23r_hsf_sd cdc23r_hsf_sd 0 5e-14
cpar_cdc23r_kd1 cdc23r_kd1 0 5e-14
cpar_cdc23r_knb cdc23r_knb 0 5e-14
cpar_cdc23r_ko1 cdc23r_ko1 0 5e-14
cpar_cdc23r_ktail cdc23r_ktail 0 5e-14
cpar_cdc23r_kx cdc23r_kx 0 5e-14
cpar_cdc23r_mi cdc23r_mi 0 5e-14
cpar_cdc23r_op_ad cdc23r_op_ad 0 5e-14
cpar_cdc23r_op_adn cdc23r_op_adn 0 5e-14
cpar_cdc23r_op_an cdc23r_op_an 0 5e-14
cpar_cdc23r_op_aq cdc23r_op_aq 0 5e-14
cpar_cdc23r_op_aqb cdc23r_op_aqb 0 5e-14
cpar_cdc23r_op_at cdc23r_op_at 0 5e-14
cpar_cdc23r_op_gx cdc23r_op_gx 0 5e-14
cpar_cdc23r_op_p cdc23r_op_p 0 5e-14
cpar_cdc23r_op_pb cdc23r_op_pb 0 5e-14
cpar_cdc23r_op_tt cdc23r_op_tt 0 5e-14
cpar_cdc23r_q cdc23r_q 0 5e-14
cpar_cdc23r_qb cdc23r_qb 0 5e-14
cpar_cdc23r_rec cdc23r_rec 0 5e-14
cpar_cdc23r_rt cdc23r_rt 0 5e-14
cpar_cdc23r_st_x cdc23r_st_x 0 5e-14
cpar_cdc23r_vm cdc23r_vm 0 5e-14
cpar_cdc23r_vmd cdc23r_vmd 0 5e-14
cpar_cdc23r_vms cdc23r_vms 0 5e-14
cpar_cdc34f_h cdc34f_h 0 5e-14
cpar_cdc34f_hc cdc34f_hc 0 5e-14
cpar_cdc34f_hcf_h1 cdc34f_hcf_h1 0 5e-14
cpar_cdc34f_hcf_sd cdc34f_hcf_sd 0 5e-14
cpar_cdc34f_hs cdc34f_hs 0 5e-14
cpar_cdc34f_hsf_h1 cdc34f_hsf_h1 0 5e-14
cpar_cdc34f_hsf_sd cdc34f_hsf_sd 0 5e-14
cpar_cdc34f_kd1 cdc34f_kd1 0 5e-14
cpar_cdc34f_knb cdc34f_knb 0 5e-14
cpar_cdc34f_ko1 cdc34f_ko1 0 5e-14
cpar_cdc34f_ktail cdc34f_ktail 0 5e-14
cpar_cdc34f_kx cdc34f_kx 0 5e-14
cpar_cdc34f_mi cdc34f_mi 0 5e-14
cpar_cdc34f_op_ad cdc34f_op_ad 0 5e-14
cpar_cdc34f_op_adn cdc34f_op_adn 0 5e-14
cpar_cdc34f_op_an cdc34f_op_an 0 5e-14
cpar_cdc34f_op_aq cdc34f_op_aq 0 5e-14
cpar_cdc34f_op_aqb cdc34f_op_aqb 0 5e-14
cpar_cdc34f_op_at cdc34f_op_at 0 5e-14
cpar_cdc34f_op_gx cdc34f_op_gx 0 5e-14
cpar_cdc34f_op_p cdc34f_op_p 0 5e-14
cpar_cdc34f_op_pb cdc34f_op_pb 0 5e-14
cpar_cdc34f_op_tt cdc34f_op_tt 0 5e-14
cpar_cdc34f_q cdc34f_q 0 5e-14
cpar_cdc34f_qb cdc34f_qb 0 5e-14
cpar_cdc34f_rec cdc34f_rec 0 5e-14
cpar_cdc34f_rt cdc34f_rt 0 5e-14
cpar_cdc34f_st_x cdc34f_st_x 0 5e-14
cpar_cdc34f_vm cdc34f_vm 0 5e-14
cpar_cdc34f_vmd cdc34f_vmd 0 5e-14
cpar_cdc34f_vms cdc34f_vms 0 5e-14
cpar_cdc34r_h cdc34r_h 0 5e-14
cpar_cdc34r_hc cdc34r_hc 0 5e-14
cpar_cdc34r_hcf_h1 cdc34r_hcf_h1 0 5e-14
cpar_cdc34r_hcf_sd cdc34r_hcf_sd 0 5e-14
cpar_cdc34r_hs cdc34r_hs 0 5e-14
cpar_cdc34r_hsf_h1 cdc34r_hsf_h1 0 5e-14
cpar_cdc34r_hsf_sd cdc34r_hsf_sd 0 5e-14
cpar_cdc34r_kd1 cdc34r_kd1 0 5e-14
cpar_cdc34r_knb cdc34r_knb 0 5e-14
cpar_cdc34r_ko1 cdc34r_ko1 0 5e-14
cpar_cdc34r_ktail cdc34r_ktail 0 5e-14
cpar_cdc34r_kx cdc34r_kx 0 5e-14
cpar_cdc34r_mi cdc34r_mi 0 5e-14
cpar_cdc34r_op_ad cdc34r_op_ad 0 5e-14
cpar_cdc34r_op_adn cdc34r_op_adn 0 5e-14
cpar_cdc34r_op_an cdc34r_op_an 0 5e-14
cpar_cdc34r_op_aq cdc34r_op_aq 0 5e-14
cpar_cdc34r_op_aqb cdc34r_op_aqb 0 5e-14
cpar_cdc34r_op_at cdc34r_op_at 0 5e-14
cpar_cdc34r_op_gx cdc34r_op_gx 0 5e-14
cpar_cdc34r_op_p cdc34r_op_p 0 5e-14
cpar_cdc34r_op_pb cdc34r_op_pb 0 5e-14
cpar_cdc34r_op_tt cdc34r_op_tt 0 5e-14
cpar_cdc34r_q cdc34r_q 0 5e-14
cpar_cdc34r_qb cdc34r_qb 0 5e-14
cpar_cdc34r_rec cdc34r_rec 0 5e-14
cpar_cdc34r_rt cdc34r_rt 0 5e-14
cpar_cdc34r_st_x cdc34r_st_x 0 5e-14
cpar_cdc34r_vm cdc34r_vm 0 5e-14
cpar_cdc34r_vmd cdc34r_vmd 0 5e-14
cpar_cdc34r_vms cdc34r_vms 0 5e-14
cpar_cdw12f_h cdw12f_h 0 5e-14
cpar_cdw12f_hc cdw12f_hc 0 5e-14
cpar_cdw12f_hcf_h1 cdw12f_hcf_h1 0 5e-14
cpar_cdw12f_hcf_sd cdw12f_hcf_sd 0 5e-14
cpar_cdw12f_hs cdw12f_hs 0 5e-14
cpar_cdw12f_hsf_h1 cdw12f_hsf_h1 0 5e-14
cpar_cdw12f_hsf_sd cdw12f_hsf_sd 0 5e-14
cpar_cdw12f_kd1 cdw12f_kd1 0 5e-14
cpar_cdw12f_knb cdw12f_knb 0 5e-14
cpar_cdw12f_ko1 cdw12f_ko1 0 5e-14
cpar_cdw12f_ktail cdw12f_ktail 0 5e-14
cpar_cdw12f_kx cdw12f_kx 0 5e-14
cpar_cdw12f_mi cdw12f_mi 0 5e-14
cpar_cdw12f_op_ad cdw12f_op_ad 0 5e-14
cpar_cdw12f_op_adn cdw12f_op_adn 0 5e-14
cpar_cdw12f_op_an cdw12f_op_an 0 5e-14
cpar_cdw12f_op_aq cdw12f_op_aq 0 5e-14
cpar_cdw12f_op_aqb cdw12f_op_aqb 0 5e-14
cpar_cdw12f_op_at cdw12f_op_at 0 5e-14
cpar_cdw12f_op_gx cdw12f_op_gx 0 5e-14
cpar_cdw12f_op_p cdw12f_op_p 0 5e-14
cpar_cdw12f_op_pb cdw12f_op_pb 0 5e-14
cpar_cdw12f_op_tt cdw12f_op_tt 0 5e-14
cpar_cdw12f_q cdw12f_q 0 5e-14
cpar_cdw12f_qb cdw12f_qb 0 5e-14
cpar_cdw12f_rec cdw12f_rec 0 5e-14
cpar_cdw12f_rt cdw12f_rt 0 5e-14
cpar_cdw12f_st_x cdw12f_st_x 0 5e-14
cpar_cdw12f_vm cdw12f_vm 0 5e-14
cpar_cdw12f_vmd cdw12f_vmd 0 5e-14
cpar_cdw12f_vms cdw12f_vms 0 5e-14
cpar_cdw12r_h cdw12r_h 0 5e-14
cpar_cdw12r_hc cdw12r_hc 0 5e-14
cpar_cdw12r_hcf_h1 cdw12r_hcf_h1 0 5e-14
cpar_cdw12r_hcf_sd cdw12r_hcf_sd 0 5e-14
cpar_cdw12r_hs cdw12r_hs 0 5e-14
cpar_cdw12r_hsf_h1 cdw12r_hsf_h1 0 5e-14
cpar_cdw12r_hsf_sd cdw12r_hsf_sd 0 5e-14
cpar_cdw12r_kd1 cdw12r_kd1 0 5e-14
cpar_cdw12r_knb cdw12r_knb 0 5e-14
cpar_cdw12r_ko1 cdw12r_ko1 0 5e-14
cpar_cdw12r_ktail cdw12r_ktail 0 5e-14
cpar_cdw12r_kx cdw12r_kx 0 5e-14
cpar_cdw12r_mi cdw12r_mi 0 5e-14
cpar_cdw12r_op_ad cdw12r_op_ad 0 5e-14
cpar_cdw12r_op_adn cdw12r_op_adn 0 5e-14
cpar_cdw12r_op_an cdw12r_op_an 0 5e-14
cpar_cdw12r_op_aq cdw12r_op_aq 0 5e-14
cpar_cdw12r_op_aqb cdw12r_op_aqb 0 5e-14
cpar_cdw12r_op_at cdw12r_op_at 0 5e-14
cpar_cdw12r_op_gx cdw12r_op_gx 0 5e-14
cpar_cdw12r_op_p cdw12r_op_p 0 5e-14
cpar_cdw12r_op_pb cdw12r_op_pb 0 5e-14
cpar_cdw12r_op_tt cdw12r_op_tt 0 5e-14
cpar_cdw12r_q cdw12r_q 0 5e-14
cpar_cdw12r_qb cdw12r_qb 0 5e-14
cpar_cdw12r_rec cdw12r_rec 0 5e-14
cpar_cdw12r_rt cdw12r_rt 0 5e-14
cpar_cdw12r_st_x cdw12r_st_x 0 5e-14
cpar_cdw12r_vm cdw12r_vm 0 5e-14
cpar_cdw12r_vmd cdw12r_vmd 0 5e-14
cpar_cdw12r_vms cdw12r_vms 0 5e-14
cpar_cdw23f_h cdw23f_h 0 5e-14
cpar_cdw23f_hc cdw23f_hc 0 5e-14
cpar_cdw23f_hcf_h1 cdw23f_hcf_h1 0 5e-14
cpar_cdw23f_hcf_sd cdw23f_hcf_sd 0 5e-14
cpar_cdw23f_hs cdw23f_hs 0 5e-14
cpar_cdw23f_hsf_h1 cdw23f_hsf_h1 0 5e-14
cpar_cdw23f_hsf_sd cdw23f_hsf_sd 0 5e-14
cpar_cdw23f_kd1 cdw23f_kd1 0 5e-14
cpar_cdw23f_knb cdw23f_knb 0 5e-14
cpar_cdw23f_ko1 cdw23f_ko1 0 5e-14
cpar_cdw23f_ktail cdw23f_ktail 0 5e-14
cpar_cdw23f_kx cdw23f_kx 0 5e-14
cpar_cdw23f_mi cdw23f_mi 0 5e-14
cpar_cdw23f_op_ad cdw23f_op_ad 0 5e-14
cpar_cdw23f_op_adn cdw23f_op_adn 0 5e-14
cpar_cdw23f_op_an cdw23f_op_an 0 5e-14
cpar_cdw23f_op_aq cdw23f_op_aq 0 5e-14
cpar_cdw23f_op_aqb cdw23f_op_aqb 0 5e-14
cpar_cdw23f_op_at cdw23f_op_at 0 5e-14
cpar_cdw23f_op_gx cdw23f_op_gx 0 5e-14
cpar_cdw23f_op_p cdw23f_op_p 0 5e-14
cpar_cdw23f_op_pb cdw23f_op_pb 0 5e-14
cpar_cdw23f_op_tt cdw23f_op_tt 0 5e-14
cpar_cdw23f_q cdw23f_q 0 5e-14
cpar_cdw23f_qb cdw23f_qb 0 5e-14
cpar_cdw23f_rec cdw23f_rec 0 5e-14
cpar_cdw23f_rt cdw23f_rt 0 5e-14
cpar_cdw23f_st_x cdw23f_st_x 0 5e-14
cpar_cdw23f_vm cdw23f_vm 0 5e-14
cpar_cdw23f_vmd cdw23f_vmd 0 5e-14
cpar_cdw23f_vms cdw23f_vms 0 5e-14
cpar_cdw23r_h cdw23r_h 0 5e-14
cpar_cdw23r_hc cdw23r_hc 0 5e-14
cpar_cdw23r_hcf_h1 cdw23r_hcf_h1 0 5e-14
cpar_cdw23r_hcf_sd cdw23r_hcf_sd 0 5e-14
cpar_cdw23r_hs cdw23r_hs 0 5e-14
cpar_cdw23r_hsf_h1 cdw23r_hsf_h1 0 5e-14
cpar_cdw23r_hsf_sd cdw23r_hsf_sd 0 5e-14
cpar_cdw23r_kd1 cdw23r_kd1 0 5e-14
cpar_cdw23r_knb cdw23r_knb 0 5e-14
cpar_cdw23r_ko1 cdw23r_ko1 0 5e-14
cpar_cdw23r_ktail cdw23r_ktail 0 5e-14
cpar_cdw23r_kx cdw23r_kx 0 5e-14
cpar_cdw23r_mi cdw23r_mi 0 5e-14
cpar_cdw23r_op_ad cdw23r_op_ad 0 5e-14
cpar_cdw23r_op_adn cdw23r_op_adn 0 5e-14
cpar_cdw23r_op_an cdw23r_op_an 0 5e-14
cpar_cdw23r_op_aq cdw23r_op_aq 0 5e-14
cpar_cdw23r_op_aqb cdw23r_op_aqb 0 5e-14
cpar_cdw23r_op_at cdw23r_op_at 0 5e-14
cpar_cdw23r_op_gx cdw23r_op_gx 0 5e-14
cpar_cdw23r_op_p cdw23r_op_p 0 5e-14
cpar_cdw23r_op_pb cdw23r_op_pb 0 5e-14
cpar_cdw23r_op_tt cdw23r_op_tt 0 5e-14
cpar_cdw23r_q cdw23r_q 0 5e-14
cpar_cdw23r_qb cdw23r_qb 0 5e-14
cpar_cdw23r_rec cdw23r_rec 0 5e-14
cpar_cdw23r_rt cdw23r_rt 0 5e-14
cpar_cdw23r_st_x cdw23r_st_x 0 5e-14
cpar_cdw23r_vm cdw23r_vm 0 5e-14
cpar_cdw23r_vmd cdw23r_vmd 0 5e-14
cpar_cdw23r_vms cdw23r_vms 0 5e-14
cpar_cdw34f_h cdw34f_h 0 5e-14
cpar_cdw34f_hc cdw34f_hc 0 5e-14
cpar_cdw34f_hcf_h1 cdw34f_hcf_h1 0 5e-14
cpar_cdw34f_hcf_sd cdw34f_hcf_sd 0 5e-14
cpar_cdw34f_hs cdw34f_hs 0 5e-14
cpar_cdw34f_hsf_h1 cdw34f_hsf_h1 0 5e-14
cpar_cdw34f_hsf_sd cdw34f_hsf_sd 0 5e-14
cpar_cdw34f_kd1 cdw34f_kd1 0 5e-14
cpar_cdw34f_knb cdw34f_knb 0 5e-14
cpar_cdw34f_ko1 cdw34f_ko1 0 5e-14
cpar_cdw34f_ktail cdw34f_ktail 0 5e-14
cpar_cdw34f_kx cdw34f_kx 0 5e-14
cpar_cdw34f_mi cdw34f_mi 0 5e-14
cpar_cdw34f_op_ad cdw34f_op_ad 0 5e-14
cpar_cdw34f_op_adn cdw34f_op_adn 0 5e-14
cpar_cdw34f_op_an cdw34f_op_an 0 5e-14
cpar_cdw34f_op_aq cdw34f_op_aq 0 5e-14
cpar_cdw34f_op_aqb cdw34f_op_aqb 0 5e-14
cpar_cdw34f_op_at cdw34f_op_at 0 5e-14
cpar_cdw34f_op_gx cdw34f_op_gx 0 5e-14
cpar_cdw34f_op_p cdw34f_op_p 0 5e-14
cpar_cdw34f_op_pb cdw34f_op_pb 0 5e-14
cpar_cdw34f_op_tt cdw34f_op_tt 0 5e-14
cpar_cdw34f_q cdw34f_q 0 5e-14
cpar_cdw34f_qb cdw34f_qb 0 5e-14
cpar_cdw34f_rec cdw34f_rec 0 5e-14
cpar_cdw34f_rt cdw34f_rt 0 5e-14
cpar_cdw34f_st_x cdw34f_st_x 0 5e-14
cpar_cdw34f_vm cdw34f_vm 0 5e-14
cpar_cdw34f_vmd cdw34f_vmd 0 5e-14
cpar_cdw34f_vms cdw34f_vms 0 5e-14
cpar_cdw34r_h cdw34r_h 0 5e-14
cpar_cdw34r_hc cdw34r_hc 0 5e-14
cpar_cdw34r_hcf_h1 cdw34r_hcf_h1 0 5e-14
cpar_cdw34r_hcf_sd cdw34r_hcf_sd 0 5e-14
cpar_cdw34r_hs cdw34r_hs 0 5e-14
cpar_cdw34r_hsf_h1 cdw34r_hsf_h1 0 5e-14
cpar_cdw34r_hsf_sd cdw34r_hsf_sd 0 5e-14
cpar_cdw34r_kd1 cdw34r_kd1 0 5e-14
cpar_cdw34r_knb cdw34r_knb 0 5e-14
cpar_cdw34r_ko1 cdw34r_ko1 0 5e-14
cpar_cdw34r_ktail cdw34r_ktail 0 5e-14
cpar_cdw34r_kx cdw34r_kx 0 5e-14
cpar_cdw34r_mi cdw34r_mi 0 5e-14
cpar_cdw34r_op_ad cdw34r_op_ad 0 5e-14
cpar_cdw34r_op_adn cdw34r_op_adn 0 5e-14
cpar_cdw34r_op_an cdw34r_op_an 0 5e-14
cpar_cdw34r_op_aq cdw34r_op_aq 0 5e-14
cpar_cdw34r_op_aqb cdw34r_op_aqb 0 5e-14
cpar_cdw34r_op_at cdw34r_op_at 0 5e-14
cpar_cdw34r_op_gx cdw34r_op_gx 0 5e-14
cpar_cdw34r_op_p cdw34r_op_p 0 5e-14
cpar_cdw34r_op_pb cdw34r_op_pb 0 5e-14
cpar_cdw34r_op_tt cdw34r_op_tt 0 5e-14
cpar_cdw34r_q cdw34r_q 0 5e-14
cpar_cdw34r_qb cdw34r_qb 0 5e-14
cpar_cdw34r_rec cdw34r_rec 0 5e-14
cpar_cdw34r_rt cdw34r_rt 0 5e-14
cpar_cdw34r_st_x cdw34r_st_x 0 5e-14
cpar_cdw34r_vm cdw34r_vm 0 5e-14
cpar_cdw34r_vmd cdw34r_vmd 0 5e-14
cpar_cdw34r_vms cdw34r_vms 0 5e-14
cpar_gc1_and_a0_nb gc1_and_a0_nb 0 5e-14
cpar_gc1_and_a0_nx gc1_and_a0_nx 0 5e-14
cpar_gc1_and_a1_nb gc1_and_a1_nb 0 5e-14
cpar_gc1_and_a1_nx gc1_and_a1_nx 0 5e-14
cpar_gc1_and_a2_nb gc1_and_a2_nb 0 5e-14
cpar_gc1_and_a2_nx gc1_and_a2_nx 0 5e-14
cpar_gc1_and_a3_nb gc1_and_a3_nb 0 5e-14
cpar_gc1_and_a3_nx gc1_and_a3_nx 0 5e-14
cpar_gc1_and_a4_nb gc1_and_a4_nb 0 5e-14
cpar_gc1_and_a4_nx gc1_and_a4_nx 0 5e-14
cpar_gc1_and_a5_nb gc1_and_a5_nb 0 5e-14
cpar_gc1_and_a5_nx gc1_and_a5_nx 0 5e-14
cpar_gc1_and_a6_nb gc1_and_a6_nb 0 5e-14
cpar_gc1_and_a6_nx gc1_and_a6_nx 0 5e-14
cpar_gc1_and_a7_nb gc1_and_a7_nb 0 5e-14
cpar_gc1_and_a7_nx gc1_and_a7_nx 0 5e-14
cpar_gc1_and_a8_nb gc1_and_a8_nb 0 5e-14
cpar_gc1_and_a8_nx gc1_and_a8_nx 0 5e-14
cpar_gc1_and_g0 gc1_and_g0 0 5e-14
cpar_gc1_and_g1 gc1_and_g1 0 5e-14
cpar_gc1_and_g2 gc1_and_g2 0 5e-14
cpar_gc1_and_g3 gc1_and_g3 0 5e-14
cpar_gc1_and_g4 gc1_and_g4 0 5e-14
cpar_gc1_and_g5 gc1_and_g5 0 5e-14
cpar_gc1_and_g6 gc1_and_g6 0 5e-14
cpar_gc1_and_g7 gc1_and_g7 0 5e-14
cpar_gc1_and_g8 gc1_and_g8 0 5e-14
cpar_gc1_b1 gc1_b1 0 5e-14
cpar_gc1_b10 gc1_b10 0 5e-14
cpar_gc1_b10_n gc1_b10_n 0 5e-14
cpar_gc1_b10_q gc1_b10_q 0 5e-14
cpar_gc1_b10_t gc1_b10_t 0 5e-14
cpar_gc1_b1_n gc1_b1_n 0 5e-14
cpar_gc1_b1_q gc1_b1_q 0 5e-14
cpar_gc1_b1_t gc1_b1_t 0 5e-14
cpar_gc1_b2 gc1_b2 0 5e-14
cpar_gc1_b2_n gc1_b2_n 0 5e-14
cpar_gc1_b2_q gc1_b2_q 0 5e-14
cpar_gc1_b2_t gc1_b2_t 0 5e-14
cpar_gc1_b3 gc1_b3 0 5e-14
cpar_gc1_b3_n gc1_b3_n 0 5e-14
cpar_gc1_b3_q gc1_b3_q 0 5e-14
cpar_gc1_b3_t gc1_b3_t 0 5e-14
cpar_gc1_b4 gc1_b4 0 5e-14
cpar_gc1_b4_n gc1_b4_n 0 5e-14
cpar_gc1_b4_q gc1_b4_q 0 5e-14
cpar_gc1_b4_t gc1_b4_t 0 5e-14
cpar_gc1_b5 gc1_b5 0 5e-14
cpar_gc1_b5_n gc1_b5_n 0 5e-14
cpar_gc1_b5_q gc1_b5_q 0 5e-14
cpar_gc1_b5_t gc1_b5_t 0 5e-14
cpar_gc1_b6 gc1_b6 0 5e-14
cpar_gc1_b6_n gc1_b6_n 0 5e-14
cpar_gc1_b6_q gc1_b6_q 0 5e-14
cpar_gc1_b6_t gc1_b6_t 0 5e-14
cpar_gc1_b7 gc1_b7 0 5e-14
cpar_gc1_b7_n gc1_b7_n 0 5e-14
cpar_gc1_b7_q gc1_b7_q 0 5e-14
cpar_gc1_b7_t gc1_b7_t 0 5e-14
cpar_gc1_b8 gc1_b8 0 5e-14
cpar_gc1_b8_n gc1_b8_n 0 5e-14
cpar_gc1_b8_q gc1_b8_q 0 5e-14
cpar_gc1_b8_t gc1_b8_t 0 5e-14
cpar_gc1_b9 gc1_b9 0 5e-14
cpar_gc1_b9_n gc1_b9_n 0 5e-14
cpar_gc1_b9_q gc1_b9_q 0 5e-14
cpar_gc1_b9_t gc1_b9_t 0 5e-14
cpar_gc1_cin_cg gc1_cin_cg 0 5e-14
cpar_gc1_cin_ena gc1_cin_ena 0 5e-14
cpar_gc1_col_h gc1_col_h 0 5e-14
cpar_gc1_col_kd1 gc1_col_kd1 0 5e-14
cpar_gc1_col_knb gc1_col_knb 0 5e-14
cpar_gc1_col_ko1 gc1_col_ko1 0 5e-14
cpar_gc1_col_ktail gc1_col_ktail 0 5e-14
cpar_gc1_col_q gc1_col_q 0 5e-14
cpar_gc1_col_qb gc1_col_qb 0 5e-14
cpar_gc1_col_rec gc1_col_rec 0 5e-14
cpar_gc1_col_rt gc1_col_rt 0 5e-14
cpar_gc1_col_vm gc1_col_vm 0 5e-14
cpar_gc1_col_vmd gc1_col_vmd 0 5e-14
cpar_gc1_col_vms gc1_col_vms 0 5e-14
cpar_gc1_e10_h gc1_e10_h 0 5e-14
cpar_gc1_e10_kd1 gc1_e10_kd1 0 5e-14
cpar_gc1_e10_knb gc1_e10_knb 0 5e-14
cpar_gc1_e10_ko1 gc1_e10_ko1 0 5e-14
cpar_gc1_e10_ktail gc1_e10_ktail 0 5e-14
cpar_gc1_e10_q gc1_e10_q 0 5e-14
cpar_gc1_e10_qb gc1_e10_qb 0 5e-14
cpar_gc1_e10_rec gc1_e10_rec 0 5e-14
cpar_gc1_e10_rt gc1_e10_rt 0 5e-14
cpar_gc1_e10_vm gc1_e10_vm 0 5e-14
cpar_gc1_e10_vmd gc1_e10_vmd 0 5e-14
cpar_gc1_e10_vms gc1_e10_vms 0 5e-14
cpar_gc1_e1_h gc1_e1_h 0 5e-14
cpar_gc1_e1_kd1 gc1_e1_kd1 0 5e-14
cpar_gc1_e1_knb gc1_e1_knb 0 5e-14
cpar_gc1_e1_ko1 gc1_e1_ko1 0 5e-14
cpar_gc1_e1_ktail gc1_e1_ktail 0 5e-14
cpar_gc1_e1_q gc1_e1_q 0 5e-14
cpar_gc1_e1_qb gc1_e1_qb 0 5e-14
cpar_gc1_e1_rec gc1_e1_rec 0 5e-14
cpar_gc1_e1_rt gc1_e1_rt 0 5e-14
cpar_gc1_e1_vm gc1_e1_vm 0 5e-14
cpar_gc1_e1_vmd gc1_e1_vmd 0 5e-14
cpar_gc1_e1_vms gc1_e1_vms 0 5e-14
cpar_gc1_e2_h gc1_e2_h 0 5e-14
cpar_gc1_e2_kd1 gc1_e2_kd1 0 5e-14
cpar_gc1_e2_knb gc1_e2_knb 0 5e-14
cpar_gc1_e2_ko1 gc1_e2_ko1 0 5e-14
cpar_gc1_e2_ktail gc1_e2_ktail 0 5e-14
cpar_gc1_e2_q gc1_e2_q 0 5e-14
cpar_gc1_e2_qb gc1_e2_qb 0 5e-14
cpar_gc1_e2_rec gc1_e2_rec 0 5e-14
cpar_gc1_e2_rt gc1_e2_rt 0 5e-14
cpar_gc1_e2_vm gc1_e2_vm 0 5e-14
cpar_gc1_e2_vmd gc1_e2_vmd 0 5e-14
cpar_gc1_e2_vms gc1_e2_vms 0 5e-14
cpar_gc1_e3_h gc1_e3_h 0 5e-14
cpar_gc1_e3_kd1 gc1_e3_kd1 0 5e-14
cpar_gc1_e3_knb gc1_e3_knb 0 5e-14
cpar_gc1_e3_ko1 gc1_e3_ko1 0 5e-14
cpar_gc1_e3_ktail gc1_e3_ktail 0 5e-14
cpar_gc1_e3_q gc1_e3_q 0 5e-14
cpar_gc1_e3_qb gc1_e3_qb 0 5e-14
cpar_gc1_e3_rec gc1_e3_rec 0 5e-14
cpar_gc1_e3_rt gc1_e3_rt 0 5e-14
cpar_gc1_e3_vm gc1_e3_vm 0 5e-14
cpar_gc1_e3_vmd gc1_e3_vmd 0 5e-14
cpar_gc1_e3_vms gc1_e3_vms 0 5e-14
cpar_gc1_e4_h gc1_e4_h 0 5e-14
cpar_gc1_e4_kd1 gc1_e4_kd1 0 5e-14
cpar_gc1_e4_knb gc1_e4_knb 0 5e-14
cpar_gc1_e4_ko1 gc1_e4_ko1 0 5e-14
cpar_gc1_e4_ktail gc1_e4_ktail 0 5e-14
cpar_gc1_e4_q gc1_e4_q 0 5e-14
cpar_gc1_e4_qb gc1_e4_qb 0 5e-14
cpar_gc1_e4_rec gc1_e4_rec 0 5e-14
cpar_gc1_e4_rt gc1_e4_rt 0 5e-14
cpar_gc1_e4_vm gc1_e4_vm 0 5e-14
cpar_gc1_e4_vmd gc1_e4_vmd 0 5e-14
cpar_gc1_e4_vms gc1_e4_vms 0 5e-14
cpar_gc1_e5_h gc1_e5_h 0 5e-14
cpar_gc1_e5_kd1 gc1_e5_kd1 0 5e-14
cpar_gc1_e5_knb gc1_e5_knb 0 5e-14
cpar_gc1_e5_ko1 gc1_e5_ko1 0 5e-14
cpar_gc1_e5_ktail gc1_e5_ktail 0 5e-14
cpar_gc1_e5_q gc1_e5_q 0 5e-14
cpar_gc1_e5_qb gc1_e5_qb 0 5e-14
cpar_gc1_e5_rec gc1_e5_rec 0 5e-14
cpar_gc1_e5_rt gc1_e5_rt 0 5e-14
cpar_gc1_e5_vm gc1_e5_vm 0 5e-14
cpar_gc1_e5_vmd gc1_e5_vmd 0 5e-14
cpar_gc1_e5_vms gc1_e5_vms 0 5e-14
cpar_gc1_e6_h gc1_e6_h 0 5e-14
cpar_gc1_e6_kd1 gc1_e6_kd1 0 5e-14
cpar_gc1_e6_knb gc1_e6_knb 0 5e-14
cpar_gc1_e6_ko1 gc1_e6_ko1 0 5e-14
cpar_gc1_e6_ktail gc1_e6_ktail 0 5e-14
cpar_gc1_e6_q gc1_e6_q 0 5e-14
cpar_gc1_e6_qb gc1_e6_qb 0 5e-14
cpar_gc1_e6_rec gc1_e6_rec 0 5e-14
cpar_gc1_e6_rt gc1_e6_rt 0 5e-14
cpar_gc1_e6_vm gc1_e6_vm 0 5e-14
cpar_gc1_e6_vmd gc1_e6_vmd 0 5e-14
cpar_gc1_e6_vms gc1_e6_vms 0 5e-14
cpar_gc1_e7_h gc1_e7_h 0 5e-14
cpar_gc1_e7_kd1 gc1_e7_kd1 0 5e-14
cpar_gc1_e7_knb gc1_e7_knb 0 5e-14
cpar_gc1_e7_ko1 gc1_e7_ko1 0 5e-14
cpar_gc1_e7_ktail gc1_e7_ktail 0 5e-14
cpar_gc1_e7_q gc1_e7_q 0 5e-14
cpar_gc1_e7_qb gc1_e7_qb 0 5e-14
cpar_gc1_e7_rec gc1_e7_rec 0 5e-14
cpar_gc1_e7_rt gc1_e7_rt 0 5e-14
cpar_gc1_e7_vm gc1_e7_vm 0 5e-14
cpar_gc1_e7_vmd gc1_e7_vmd 0 5e-14
cpar_gc1_e7_vms gc1_e7_vms 0 5e-14
cpar_gc1_e8_h gc1_e8_h 0 5e-14
cpar_gc1_e8_kd1 gc1_e8_kd1 0 5e-14
cpar_gc1_e8_knb gc1_e8_knb 0 5e-14
cpar_gc1_e8_ko1 gc1_e8_ko1 0 5e-14
cpar_gc1_e8_ktail gc1_e8_ktail 0 5e-14
cpar_gc1_e8_q gc1_e8_q 0 5e-14
cpar_gc1_e8_qb gc1_e8_qb 0 5e-14
cpar_gc1_e8_rec gc1_e8_rec 0 5e-14
cpar_gc1_e8_rt gc1_e8_rt 0 5e-14
cpar_gc1_e8_vm gc1_e8_vm 0 5e-14
cpar_gc1_e8_vmd gc1_e8_vmd 0 5e-14
cpar_gc1_e8_vms gc1_e8_vms 0 5e-14
cpar_gc1_e9_h gc1_e9_h 0 5e-14
cpar_gc1_e9_kd1 gc1_e9_kd1 0 5e-14
cpar_gc1_e9_knb gc1_e9_knb 0 5e-14
cpar_gc1_e9_ko1 gc1_e9_ko1 0 5e-14
cpar_gc1_e9_ktail gc1_e9_ktail 0 5e-14
cpar_gc1_e9_q gc1_e9_q 0 5e-14
cpar_gc1_e9_qb gc1_e9_qb 0 5e-14
cpar_gc1_e9_rec gc1_e9_rec 0 5e-14
cpar_gc1_e9_rt gc1_e9_rt 0 5e-14
cpar_gc1_e9_vm gc1_e9_vm 0 5e-14
cpar_gc1_e9_vmd gc1_e9_vmd 0 5e-14
cpar_gc1_e9_vms gc1_e9_vms 0 5e-14
cpar_gc1_gb gc1_gb 0 5e-14
cpar_gc1_op_ad gc1_op_ad 0 5e-14
cpar_gc1_op_adn gc1_op_adn 0 5e-14
cpar_gc1_op_an gc1_op_an 0 5e-14
cpar_gc1_op_aq gc1_op_aq 0 5e-14
cpar_gc1_op_aqb gc1_op_aqb 0 5e-14
cpar_gc1_op_at gc1_op_at 0 5e-14
cpar_gc1_op_gx gc1_op_gx 0 5e-14
cpar_gc1_op_p gc1_op_p 0 5e-14
cpar_gc1_op_pb gc1_op_pb 0 5e-14
cpar_gc1_op_tt gc1_op_tt 0 5e-14
cpar_gc2_and_a0_nb gc2_and_a0_nb 0 5e-14
cpar_gc2_and_a0_nx gc2_and_a0_nx 0 5e-14
cpar_gc2_and_a1_nb gc2_and_a1_nb 0 5e-14
cpar_gc2_and_a1_nx gc2_and_a1_nx 0 5e-14
cpar_gc2_and_a2_nb gc2_and_a2_nb 0 5e-14
cpar_gc2_and_a2_nx gc2_and_a2_nx 0 5e-14
cpar_gc2_and_a3_nb gc2_and_a3_nb 0 5e-14
cpar_gc2_and_a3_nx gc2_and_a3_nx 0 5e-14
cpar_gc2_and_a4_nb gc2_and_a4_nb 0 5e-14
cpar_gc2_and_a4_nx gc2_and_a4_nx 0 5e-14
cpar_gc2_and_a5_nb gc2_and_a5_nb 0 5e-14
cpar_gc2_and_a5_nx gc2_and_a5_nx 0 5e-14
cpar_gc2_and_a6_nb gc2_and_a6_nb 0 5e-14
cpar_gc2_and_a6_nx gc2_and_a6_nx 0 5e-14
cpar_gc2_and_a7_nb gc2_and_a7_nb 0 5e-14
cpar_gc2_and_a7_nx gc2_and_a7_nx 0 5e-14
cpar_gc2_and_a8_nb gc2_and_a8_nb 0 5e-14
cpar_gc2_and_a8_nx gc2_and_a8_nx 0 5e-14
cpar_gc2_and_g0 gc2_and_g0 0 5e-14
cpar_gc2_and_g1 gc2_and_g1 0 5e-14
cpar_gc2_and_g2 gc2_and_g2 0 5e-14
cpar_gc2_and_g3 gc2_and_g3 0 5e-14
cpar_gc2_and_g4 gc2_and_g4 0 5e-14
cpar_gc2_and_g5 gc2_and_g5 0 5e-14
cpar_gc2_and_g6 gc2_and_g6 0 5e-14
cpar_gc2_and_g7 gc2_and_g7 0 5e-14
cpar_gc2_and_g8 gc2_and_g8 0 5e-14
cpar_gc2_b1 gc2_b1 0 5e-14
cpar_gc2_b10 gc2_b10 0 5e-14
cpar_gc2_b10_n gc2_b10_n 0 5e-14
cpar_gc2_b10_q gc2_b10_q 0 5e-14
cpar_gc2_b10_t gc2_b10_t 0 5e-14
cpar_gc2_b1_n gc2_b1_n 0 5e-14
cpar_gc2_b1_q gc2_b1_q 0 5e-14
cpar_gc2_b1_t gc2_b1_t 0 5e-14
cpar_gc2_b2 gc2_b2 0 5e-14
cpar_gc2_b2_n gc2_b2_n 0 5e-14
cpar_gc2_b2_q gc2_b2_q 0 5e-14
cpar_gc2_b2_t gc2_b2_t 0 5e-14
cpar_gc2_b3 gc2_b3 0 5e-14
cpar_gc2_b3_n gc2_b3_n 0 5e-14
cpar_gc2_b3_q gc2_b3_q 0 5e-14
cpar_gc2_b3_t gc2_b3_t 0 5e-14
cpar_gc2_b4 gc2_b4 0 5e-14
cpar_gc2_b4_n gc2_b4_n 0 5e-14
cpar_gc2_b4_q gc2_b4_q 0 5e-14
cpar_gc2_b4_t gc2_b4_t 0 5e-14
cpar_gc2_b5 gc2_b5 0 5e-14
cpar_gc2_b5_n gc2_b5_n 0 5e-14
cpar_gc2_b5_q gc2_b5_q 0 5e-14
cpar_gc2_b5_t gc2_b5_t 0 5e-14
cpar_gc2_b6 gc2_b6 0 5e-14
cpar_gc2_b6_n gc2_b6_n 0 5e-14
cpar_gc2_b6_q gc2_b6_q 0 5e-14
cpar_gc2_b6_t gc2_b6_t 0 5e-14
cpar_gc2_b7 gc2_b7 0 5e-14
cpar_gc2_b7_n gc2_b7_n 0 5e-14
cpar_gc2_b7_q gc2_b7_q 0 5e-14
cpar_gc2_b7_t gc2_b7_t 0 5e-14
cpar_gc2_b8 gc2_b8 0 5e-14
cpar_gc2_b8_n gc2_b8_n 0 5e-14
cpar_gc2_b8_q gc2_b8_q 0 5e-14
cpar_gc2_b8_t gc2_b8_t 0 5e-14
cpar_gc2_b9 gc2_b9 0 5e-14
cpar_gc2_b9_n gc2_b9_n 0 5e-14
cpar_gc2_b9_q gc2_b9_q 0 5e-14
cpar_gc2_b9_t gc2_b9_t 0 5e-14
cpar_gc2_cin_cg gc2_cin_cg 0 5e-14
cpar_gc2_cin_ena gc2_cin_ena 0 5e-14
cpar_gc2_col_h gc2_col_h 0 5e-14
cpar_gc2_col_kd1 gc2_col_kd1 0 5e-14
cpar_gc2_col_knb gc2_col_knb 0 5e-14
cpar_gc2_col_ko1 gc2_col_ko1 0 5e-14
cpar_gc2_col_ktail gc2_col_ktail 0 5e-14
cpar_gc2_col_q gc2_col_q 0 5e-14
cpar_gc2_col_qb gc2_col_qb 0 5e-14
cpar_gc2_col_rec gc2_col_rec 0 5e-14
cpar_gc2_col_rt gc2_col_rt 0 5e-14
cpar_gc2_col_vm gc2_col_vm 0 5e-14
cpar_gc2_col_vmd gc2_col_vmd 0 5e-14
cpar_gc2_col_vms gc2_col_vms 0 5e-14
cpar_gc2_e10_h gc2_e10_h 0 5e-14
cpar_gc2_e10_kd1 gc2_e10_kd1 0 5e-14
cpar_gc2_e10_knb gc2_e10_knb 0 5e-14
cpar_gc2_e10_ko1 gc2_e10_ko1 0 5e-14
cpar_gc2_e10_ktail gc2_e10_ktail 0 5e-14
cpar_gc2_e10_q gc2_e10_q 0 5e-14
cpar_gc2_e10_qb gc2_e10_qb 0 5e-14
cpar_gc2_e10_rec gc2_e10_rec 0 5e-14
cpar_gc2_e10_rt gc2_e10_rt 0 5e-14
cpar_gc2_e10_vm gc2_e10_vm 0 5e-14
cpar_gc2_e10_vmd gc2_e10_vmd 0 5e-14
cpar_gc2_e10_vms gc2_e10_vms 0 5e-14
cpar_gc2_e1_h gc2_e1_h 0 5e-14
cpar_gc2_e1_kd1 gc2_e1_kd1 0 5e-14
cpar_gc2_e1_knb gc2_e1_knb 0 5e-14
cpar_gc2_e1_ko1 gc2_e1_ko1 0 5e-14
cpar_gc2_e1_ktail gc2_e1_ktail 0 5e-14
cpar_gc2_e1_q gc2_e1_q 0 5e-14
cpar_gc2_e1_qb gc2_e1_qb 0 5e-14
cpar_gc2_e1_rec gc2_e1_rec 0 5e-14
cpar_gc2_e1_rt gc2_e1_rt 0 5e-14
cpar_gc2_e1_vm gc2_e1_vm 0 5e-14
cpar_gc2_e1_vmd gc2_e1_vmd 0 5e-14
cpar_gc2_e1_vms gc2_e1_vms 0 5e-14
cpar_gc2_e2_h gc2_e2_h 0 5e-14
cpar_gc2_e2_kd1 gc2_e2_kd1 0 5e-14
cpar_gc2_e2_knb gc2_e2_knb 0 5e-14
cpar_gc2_e2_ko1 gc2_e2_ko1 0 5e-14
cpar_gc2_e2_ktail gc2_e2_ktail 0 5e-14
cpar_gc2_e2_q gc2_e2_q 0 5e-14
cpar_gc2_e2_qb gc2_e2_qb 0 5e-14
cpar_gc2_e2_rec gc2_e2_rec 0 5e-14
cpar_gc2_e2_rt gc2_e2_rt 0 5e-14
cpar_gc2_e2_vm gc2_e2_vm 0 5e-14
cpar_gc2_e2_vmd gc2_e2_vmd 0 5e-14
cpar_gc2_e2_vms gc2_e2_vms 0 5e-14
cpar_gc2_e3_h gc2_e3_h 0 5e-14
cpar_gc2_e3_kd1 gc2_e3_kd1 0 5e-14
cpar_gc2_e3_knb gc2_e3_knb 0 5e-14
cpar_gc2_e3_ko1 gc2_e3_ko1 0 5e-14
cpar_gc2_e3_ktail gc2_e3_ktail 0 5e-14
cpar_gc2_e3_q gc2_e3_q 0 5e-14
cpar_gc2_e3_qb gc2_e3_qb 0 5e-14
cpar_gc2_e3_rec gc2_e3_rec 0 5e-14
cpar_gc2_e3_rt gc2_e3_rt 0 5e-14
cpar_gc2_e3_vm gc2_e3_vm 0 5e-14
cpar_gc2_e3_vmd gc2_e3_vmd 0 5e-14
cpar_gc2_e3_vms gc2_e3_vms 0 5e-14
cpar_gc2_e4_h gc2_e4_h 0 5e-14
cpar_gc2_e4_kd1 gc2_e4_kd1 0 5e-14
cpar_gc2_e4_knb gc2_e4_knb 0 5e-14
cpar_gc2_e4_ko1 gc2_e4_ko1 0 5e-14
cpar_gc2_e4_ktail gc2_e4_ktail 0 5e-14
cpar_gc2_e4_q gc2_e4_q 0 5e-14
cpar_gc2_e4_qb gc2_e4_qb 0 5e-14
cpar_gc2_e4_rec gc2_e4_rec 0 5e-14
cpar_gc2_e4_rt gc2_e4_rt 0 5e-14
cpar_gc2_e4_vm gc2_e4_vm 0 5e-14
cpar_gc2_e4_vmd gc2_e4_vmd 0 5e-14
cpar_gc2_e4_vms gc2_e4_vms 0 5e-14
cpar_gc2_e5_h gc2_e5_h 0 5e-14
cpar_gc2_e5_kd1 gc2_e5_kd1 0 5e-14
cpar_gc2_e5_knb gc2_e5_knb 0 5e-14
cpar_gc2_e5_ko1 gc2_e5_ko1 0 5e-14
cpar_gc2_e5_ktail gc2_e5_ktail 0 5e-14
cpar_gc2_e5_q gc2_e5_q 0 5e-14
cpar_gc2_e5_qb gc2_e5_qb 0 5e-14
cpar_gc2_e5_rec gc2_e5_rec 0 5e-14
cpar_gc2_e5_rt gc2_e5_rt 0 5e-14
cpar_gc2_e5_vm gc2_e5_vm 0 5e-14
cpar_gc2_e5_vmd gc2_e5_vmd 0 5e-14
cpar_gc2_e5_vms gc2_e5_vms 0 5e-14
cpar_gc2_e6_h gc2_e6_h 0 5e-14
cpar_gc2_e6_kd1 gc2_e6_kd1 0 5e-14
cpar_gc2_e6_knb gc2_e6_knb 0 5e-14
cpar_gc2_e6_ko1 gc2_e6_ko1 0 5e-14
cpar_gc2_e6_ktail gc2_e6_ktail 0 5e-14
cpar_gc2_e6_q gc2_e6_q 0 5e-14
cpar_gc2_e6_qb gc2_e6_qb 0 5e-14
cpar_gc2_e6_rec gc2_e6_rec 0 5e-14
cpar_gc2_e6_rt gc2_e6_rt 0 5e-14
cpar_gc2_e6_vm gc2_e6_vm 0 5e-14
cpar_gc2_e6_vmd gc2_e6_vmd 0 5e-14
cpar_gc2_e6_vms gc2_e6_vms 0 5e-14
cpar_gc2_e7_h gc2_e7_h 0 5e-14
cpar_gc2_e7_kd1 gc2_e7_kd1 0 5e-14
cpar_gc2_e7_knb gc2_e7_knb 0 5e-14
cpar_gc2_e7_ko1 gc2_e7_ko1 0 5e-14
cpar_gc2_e7_ktail gc2_e7_ktail 0 5e-14
cpar_gc2_e7_q gc2_e7_q 0 5e-14
cpar_gc2_e7_qb gc2_e7_qb 0 5e-14
cpar_gc2_e7_rec gc2_e7_rec 0 5e-14
cpar_gc2_e7_rt gc2_e7_rt 0 5e-14
cpar_gc2_e7_vm gc2_e7_vm 0 5e-14
cpar_gc2_e7_vmd gc2_e7_vmd 0 5e-14
cpar_gc2_e7_vms gc2_e7_vms 0 5e-14
cpar_gc2_e8_h gc2_e8_h 0 5e-14
cpar_gc2_e8_kd1 gc2_e8_kd1 0 5e-14
cpar_gc2_e8_knb gc2_e8_knb 0 5e-14
cpar_gc2_e8_ko1 gc2_e8_ko1 0 5e-14
cpar_gc2_e8_ktail gc2_e8_ktail 0 5e-14
cpar_gc2_e8_q gc2_e8_q 0 5e-14
cpar_gc2_e8_qb gc2_e8_qb 0 5e-14
cpar_gc2_e8_rec gc2_e8_rec 0 5e-14
cpar_gc2_e8_rt gc2_e8_rt 0 5e-14
cpar_gc2_e8_vm gc2_e8_vm 0 5e-14
cpar_gc2_e8_vmd gc2_e8_vmd 0 5e-14
cpar_gc2_e8_vms gc2_e8_vms 0 5e-14
cpar_gc2_e9_h gc2_e9_h 0 5e-14
cpar_gc2_e9_kd1 gc2_e9_kd1 0 5e-14
cpar_gc2_e9_knb gc2_e9_knb 0 5e-14
cpar_gc2_e9_ko1 gc2_e9_ko1 0 5e-14
cpar_gc2_e9_ktail gc2_e9_ktail 0 5e-14
cpar_gc2_e9_q gc2_e9_q 0 5e-14
cpar_gc2_e9_qb gc2_e9_qb 0 5e-14
cpar_gc2_e9_rec gc2_e9_rec 0 5e-14
cpar_gc2_e9_rt gc2_e9_rt 0 5e-14
cpar_gc2_e9_vm gc2_e9_vm 0 5e-14
cpar_gc2_e9_vmd gc2_e9_vmd 0 5e-14
cpar_gc2_e9_vms gc2_e9_vms 0 5e-14
cpar_gc2_gb gc2_gb 0 5e-14
cpar_gc2_op_ad gc2_op_ad 0 5e-14
cpar_gc2_op_adn gc2_op_adn 0 5e-14
cpar_gc2_op_an gc2_op_an 0 5e-14
cpar_gc2_op_aq gc2_op_aq 0 5e-14
cpar_gc2_op_aqb gc2_op_aqb 0 5e-14
cpar_gc2_op_at gc2_op_at 0 5e-14
cpar_gc2_op_gx gc2_op_gx 0 5e-14
cpar_gc2_op_p gc2_op_p 0 5e-14
cpar_gc2_op_pb gc2_op_pb 0 5e-14
cpar_gc2_op_tt gc2_op_tt 0 5e-14
cpar_gc3_and_a0_nb gc3_and_a0_nb 0 5e-14
cpar_gc3_and_a0_nx gc3_and_a0_nx 0 5e-14
cpar_gc3_and_a1_nb gc3_and_a1_nb 0 5e-14
cpar_gc3_and_a1_nx gc3_and_a1_nx 0 5e-14
cpar_gc3_and_a2_nb gc3_and_a2_nb 0 5e-14
cpar_gc3_and_a2_nx gc3_and_a2_nx 0 5e-14
cpar_gc3_and_a3_nb gc3_and_a3_nb 0 5e-14
cpar_gc3_and_a3_nx gc3_and_a3_nx 0 5e-14
cpar_gc3_and_a4_nb gc3_and_a4_nb 0 5e-14
cpar_gc3_and_a4_nx gc3_and_a4_nx 0 5e-14
cpar_gc3_and_a5_nb gc3_and_a5_nb 0 5e-14
cpar_gc3_and_a5_nx gc3_and_a5_nx 0 5e-14
cpar_gc3_and_a6_nb gc3_and_a6_nb 0 5e-14
cpar_gc3_and_a6_nx gc3_and_a6_nx 0 5e-14
cpar_gc3_and_a7_nb gc3_and_a7_nb 0 5e-14
cpar_gc3_and_a7_nx gc3_and_a7_nx 0 5e-14
cpar_gc3_and_a8_nb gc3_and_a8_nb 0 5e-14
cpar_gc3_and_a8_nx gc3_and_a8_nx 0 5e-14
cpar_gc3_and_g0 gc3_and_g0 0 5e-14
cpar_gc3_and_g1 gc3_and_g1 0 5e-14
cpar_gc3_and_g2 gc3_and_g2 0 5e-14
cpar_gc3_and_g3 gc3_and_g3 0 5e-14
cpar_gc3_and_g4 gc3_and_g4 0 5e-14
cpar_gc3_and_g5 gc3_and_g5 0 5e-14
cpar_gc3_and_g6 gc3_and_g6 0 5e-14
cpar_gc3_and_g7 gc3_and_g7 0 5e-14
cpar_gc3_and_g8 gc3_and_g8 0 5e-14
cpar_gc3_b1 gc3_b1 0 5e-14
cpar_gc3_b10 gc3_b10 0 5e-14
cpar_gc3_b10_n gc3_b10_n 0 5e-14
cpar_gc3_b10_q gc3_b10_q 0 5e-14
cpar_gc3_b10_t gc3_b10_t 0 5e-14
cpar_gc3_b1_n gc3_b1_n 0 5e-14
cpar_gc3_b1_q gc3_b1_q 0 5e-14
cpar_gc3_b1_t gc3_b1_t 0 5e-14
cpar_gc3_b2 gc3_b2 0 5e-14
cpar_gc3_b2_n gc3_b2_n 0 5e-14
cpar_gc3_b2_q gc3_b2_q 0 5e-14
cpar_gc3_b2_t gc3_b2_t 0 5e-14
cpar_gc3_b3 gc3_b3 0 5e-14
cpar_gc3_b3_n gc3_b3_n 0 5e-14
cpar_gc3_b3_q gc3_b3_q 0 5e-14
cpar_gc3_b3_t gc3_b3_t 0 5e-14
cpar_gc3_b4 gc3_b4 0 5e-14
cpar_gc3_b4_n gc3_b4_n 0 5e-14
cpar_gc3_b4_q gc3_b4_q 0 5e-14
cpar_gc3_b4_t gc3_b4_t 0 5e-14
cpar_gc3_b5 gc3_b5 0 5e-14
cpar_gc3_b5_n gc3_b5_n 0 5e-14
cpar_gc3_b5_q gc3_b5_q 0 5e-14
cpar_gc3_b5_t gc3_b5_t 0 5e-14
cpar_gc3_b6 gc3_b6 0 5e-14
cpar_gc3_b6_n gc3_b6_n 0 5e-14
cpar_gc3_b6_q gc3_b6_q 0 5e-14
cpar_gc3_b6_t gc3_b6_t 0 5e-14
cpar_gc3_b7 gc3_b7 0 5e-14
cpar_gc3_b7_n gc3_b7_n 0 5e-14
cpar_gc3_b7_q gc3_b7_q 0 5e-14
cpar_gc3_b7_t gc3_b7_t 0 5e-14
cpar_gc3_b8 gc3_b8 0 5e-14
cpar_gc3_b8_n gc3_b8_n 0 5e-14
cpar_gc3_b8_q gc3_b8_q 0 5e-14
cpar_gc3_b8_t gc3_b8_t 0 5e-14
cpar_gc3_b9 gc3_b9 0 5e-14
cpar_gc3_b9_n gc3_b9_n 0 5e-14
cpar_gc3_b9_q gc3_b9_q 0 5e-14
cpar_gc3_b9_t gc3_b9_t 0 5e-14
cpar_gc3_cin_cg gc3_cin_cg 0 5e-14
cpar_gc3_cin_ena gc3_cin_ena 0 5e-14
cpar_gc3_col_h gc3_col_h 0 5e-14
cpar_gc3_col_kd1 gc3_col_kd1 0 5e-14
cpar_gc3_col_knb gc3_col_knb 0 5e-14
cpar_gc3_col_ko1 gc3_col_ko1 0 5e-14
cpar_gc3_col_ktail gc3_col_ktail 0 5e-14
cpar_gc3_col_q gc3_col_q 0 5e-14
cpar_gc3_col_qb gc3_col_qb 0 5e-14
cpar_gc3_col_rec gc3_col_rec 0 5e-14
cpar_gc3_col_rt gc3_col_rt 0 5e-14
cpar_gc3_col_vm gc3_col_vm 0 5e-14
cpar_gc3_col_vmd gc3_col_vmd 0 5e-14
cpar_gc3_col_vms gc3_col_vms 0 5e-14
cpar_gc3_e10_h gc3_e10_h 0 5e-14
cpar_gc3_e10_kd1 gc3_e10_kd1 0 5e-14
cpar_gc3_e10_knb gc3_e10_knb 0 5e-14
cpar_gc3_e10_ko1 gc3_e10_ko1 0 5e-14
cpar_gc3_e10_ktail gc3_e10_ktail 0 5e-14
cpar_gc3_e10_q gc3_e10_q 0 5e-14
cpar_gc3_e10_qb gc3_e10_qb 0 5e-14
cpar_gc3_e10_rec gc3_e10_rec 0 5e-14
cpar_gc3_e10_rt gc3_e10_rt 0 5e-14
cpar_gc3_e10_vm gc3_e10_vm 0 5e-14
cpar_gc3_e10_vmd gc3_e10_vmd 0 5e-14
cpar_gc3_e10_vms gc3_e10_vms 0 5e-14
cpar_gc3_e1_h gc3_e1_h 0 5e-14
cpar_gc3_e1_kd1 gc3_e1_kd1 0 5e-14
cpar_gc3_e1_knb gc3_e1_knb 0 5e-14
cpar_gc3_e1_ko1 gc3_e1_ko1 0 5e-14
cpar_gc3_e1_ktail gc3_e1_ktail 0 5e-14
cpar_gc3_e1_q gc3_e1_q 0 5e-14
cpar_gc3_e1_qb gc3_e1_qb 0 5e-14
cpar_gc3_e1_rec gc3_e1_rec 0 5e-14
cpar_gc3_e1_rt gc3_e1_rt 0 5e-14
cpar_gc3_e1_vm gc3_e1_vm 0 5e-14
cpar_gc3_e1_vmd gc3_e1_vmd 0 5e-14
cpar_gc3_e1_vms gc3_e1_vms 0 5e-14
cpar_gc3_e2_h gc3_e2_h 0 5e-14
cpar_gc3_e2_kd1 gc3_e2_kd1 0 5e-14
cpar_gc3_e2_knb gc3_e2_knb 0 5e-14
cpar_gc3_e2_ko1 gc3_e2_ko1 0 5e-14
cpar_gc3_e2_ktail gc3_e2_ktail 0 5e-14
cpar_gc3_e2_q gc3_e2_q 0 5e-14
cpar_gc3_e2_qb gc3_e2_qb 0 5e-14
cpar_gc3_e2_rec gc3_e2_rec 0 5e-14
cpar_gc3_e2_rt gc3_e2_rt 0 5e-14
cpar_gc3_e2_vm gc3_e2_vm 0 5e-14
cpar_gc3_e2_vmd gc3_e2_vmd 0 5e-14
cpar_gc3_e2_vms gc3_e2_vms 0 5e-14
cpar_gc3_e3_h gc3_e3_h 0 5e-14
cpar_gc3_e3_kd1 gc3_e3_kd1 0 5e-14
cpar_gc3_e3_knb gc3_e3_knb 0 5e-14
cpar_gc3_e3_ko1 gc3_e3_ko1 0 5e-14
cpar_gc3_e3_ktail gc3_e3_ktail 0 5e-14
cpar_gc3_e3_q gc3_e3_q 0 5e-14
cpar_gc3_e3_qb gc3_e3_qb 0 5e-14
cpar_gc3_e3_rec gc3_e3_rec 0 5e-14
cpar_gc3_e3_rt gc3_e3_rt 0 5e-14
cpar_gc3_e3_vm gc3_e3_vm 0 5e-14
cpar_gc3_e3_vmd gc3_e3_vmd 0 5e-14
cpar_gc3_e3_vms gc3_e3_vms 0 5e-14
cpar_gc3_e4_h gc3_e4_h 0 5e-14
cpar_gc3_e4_kd1 gc3_e4_kd1 0 5e-14
cpar_gc3_e4_knb gc3_e4_knb 0 5e-14
cpar_gc3_e4_ko1 gc3_e4_ko1 0 5e-14
cpar_gc3_e4_ktail gc3_e4_ktail 0 5e-14
cpar_gc3_e4_q gc3_e4_q 0 5e-14
cpar_gc3_e4_qb gc3_e4_qb 0 5e-14
cpar_gc3_e4_rec gc3_e4_rec 0 5e-14
cpar_gc3_e4_rt gc3_e4_rt 0 5e-14
cpar_gc3_e4_vm gc3_e4_vm 0 5e-14
cpar_gc3_e4_vmd gc3_e4_vmd 0 5e-14
cpar_gc3_e4_vms gc3_e4_vms 0 5e-14
cpar_gc3_e5_h gc3_e5_h 0 5e-14
cpar_gc3_e5_kd1 gc3_e5_kd1 0 5e-14
cpar_gc3_e5_knb gc3_e5_knb 0 5e-14
cpar_gc3_e5_ko1 gc3_e5_ko1 0 5e-14
cpar_gc3_e5_ktail gc3_e5_ktail 0 5e-14
cpar_gc3_e5_q gc3_e5_q 0 5e-14
cpar_gc3_e5_qb gc3_e5_qb 0 5e-14
cpar_gc3_e5_rec gc3_e5_rec 0 5e-14
cpar_gc3_e5_rt gc3_e5_rt 0 5e-14
cpar_gc3_e5_vm gc3_e5_vm 0 5e-14
cpar_gc3_e5_vmd gc3_e5_vmd 0 5e-14
cpar_gc3_e5_vms gc3_e5_vms 0 5e-14
cpar_gc3_e6_h gc3_e6_h 0 5e-14
cpar_gc3_e6_kd1 gc3_e6_kd1 0 5e-14
cpar_gc3_e6_knb gc3_e6_knb 0 5e-14
cpar_gc3_e6_ko1 gc3_e6_ko1 0 5e-14
cpar_gc3_e6_ktail gc3_e6_ktail 0 5e-14
cpar_gc3_e6_q gc3_e6_q 0 5e-14
cpar_gc3_e6_qb gc3_e6_qb 0 5e-14
cpar_gc3_e6_rec gc3_e6_rec 0 5e-14
cpar_gc3_e6_rt gc3_e6_rt 0 5e-14
cpar_gc3_e6_vm gc3_e6_vm 0 5e-14
cpar_gc3_e6_vmd gc3_e6_vmd 0 5e-14
cpar_gc3_e6_vms gc3_e6_vms 0 5e-14
cpar_gc3_e7_h gc3_e7_h 0 5e-14
cpar_gc3_e7_kd1 gc3_e7_kd1 0 5e-14
cpar_gc3_e7_knb gc3_e7_knb 0 5e-14
cpar_gc3_e7_ko1 gc3_e7_ko1 0 5e-14
cpar_gc3_e7_ktail gc3_e7_ktail 0 5e-14
cpar_gc3_e7_q gc3_e7_q 0 5e-14
cpar_gc3_e7_qb gc3_e7_qb 0 5e-14
cpar_gc3_e7_rec gc3_e7_rec 0 5e-14
cpar_gc3_e7_rt gc3_e7_rt 0 5e-14
cpar_gc3_e7_vm gc3_e7_vm 0 5e-14
cpar_gc3_e7_vmd gc3_e7_vmd 0 5e-14
cpar_gc3_e7_vms gc3_e7_vms 0 5e-14
cpar_gc3_e8_h gc3_e8_h 0 5e-14
cpar_gc3_e8_kd1 gc3_e8_kd1 0 5e-14
cpar_gc3_e8_knb gc3_e8_knb 0 5e-14
cpar_gc3_e8_ko1 gc3_e8_ko1 0 5e-14
cpar_gc3_e8_ktail gc3_e8_ktail 0 5e-14
cpar_gc3_e8_q gc3_e8_q 0 5e-14
cpar_gc3_e8_qb gc3_e8_qb 0 5e-14
cpar_gc3_e8_rec gc3_e8_rec 0 5e-14
cpar_gc3_e8_rt gc3_e8_rt 0 5e-14
cpar_gc3_e8_vm gc3_e8_vm 0 5e-14
cpar_gc3_e8_vmd gc3_e8_vmd 0 5e-14
cpar_gc3_e8_vms gc3_e8_vms 0 5e-14
cpar_gc3_e9_h gc3_e9_h 0 5e-14
cpar_gc3_e9_kd1 gc3_e9_kd1 0 5e-14
cpar_gc3_e9_knb gc3_e9_knb 0 5e-14
cpar_gc3_e9_ko1 gc3_e9_ko1 0 5e-14
cpar_gc3_e9_ktail gc3_e9_ktail 0 5e-14
cpar_gc3_e9_q gc3_e9_q 0 5e-14
cpar_gc3_e9_qb gc3_e9_qb 0 5e-14
cpar_gc3_e9_rec gc3_e9_rec 0 5e-14
cpar_gc3_e9_rt gc3_e9_rt 0 5e-14
cpar_gc3_e9_vm gc3_e9_vm 0 5e-14
cpar_gc3_e9_vmd gc3_e9_vmd 0 5e-14
cpar_gc3_e9_vms gc3_e9_vms 0 5e-14
cpar_gc3_gb gc3_gb 0 5e-14
cpar_gc3_op_ad gc3_op_ad 0 5e-14
cpar_gc3_op_adn gc3_op_adn 0 5e-14
cpar_gc3_op_an gc3_op_an 0 5e-14
cpar_gc3_op_aq gc3_op_aq 0 5e-14
cpar_gc3_op_aqb gc3_op_aqb 0 5e-14
cpar_gc3_op_at gc3_op_at 0 5e-14
cpar_gc3_op_gx gc3_op_gx 0 5e-14
cpar_gc3_op_p gc3_op_p 0 5e-14
cpar_gc3_op_pb gc3_op_pb 0 5e-14
cpar_gc3_op_tt gc3_op_tt 0 5e-14
cpar_gc4_and_a0_nb gc4_and_a0_nb 0 5e-14
cpar_gc4_and_a0_nx gc4_and_a0_nx 0 5e-14
cpar_gc4_and_a1_nb gc4_and_a1_nb 0 5e-14
cpar_gc4_and_a1_nx gc4_and_a1_nx 0 5e-14
cpar_gc4_and_a2_nb gc4_and_a2_nb 0 5e-14
cpar_gc4_and_a2_nx gc4_and_a2_nx 0 5e-14
cpar_gc4_and_a3_nb gc4_and_a3_nb 0 5e-14
cpar_gc4_and_a3_nx gc4_and_a3_nx 0 5e-14
cpar_gc4_and_a4_nb gc4_and_a4_nb 0 5e-14
cpar_gc4_and_a4_nx gc4_and_a4_nx 0 5e-14
cpar_gc4_and_a5_nb gc4_and_a5_nb 0 5e-14
cpar_gc4_and_a5_nx gc4_and_a5_nx 0 5e-14
cpar_gc4_and_a6_nb gc4_and_a6_nb 0 5e-14
cpar_gc4_and_a6_nx gc4_and_a6_nx 0 5e-14
cpar_gc4_and_a7_nb gc4_and_a7_nb 0 5e-14
cpar_gc4_and_a7_nx gc4_and_a7_nx 0 5e-14
cpar_gc4_and_a8_nb gc4_and_a8_nb 0 5e-14
cpar_gc4_and_a8_nx gc4_and_a8_nx 0 5e-14
cpar_gc4_and_g0 gc4_and_g0 0 5e-14
cpar_gc4_and_g1 gc4_and_g1 0 5e-14
cpar_gc4_and_g2 gc4_and_g2 0 5e-14
cpar_gc4_and_g3 gc4_and_g3 0 5e-14
cpar_gc4_and_g4 gc4_and_g4 0 5e-14
cpar_gc4_and_g5 gc4_and_g5 0 5e-14
cpar_gc4_and_g6 gc4_and_g6 0 5e-14
cpar_gc4_and_g7 gc4_and_g7 0 5e-14
cpar_gc4_and_g8 gc4_and_g8 0 5e-14
cpar_gc4_b1 gc4_b1 0 5e-14
cpar_gc4_b10 gc4_b10 0 5e-14
cpar_gc4_b10_n gc4_b10_n 0 5e-14
cpar_gc4_b10_q gc4_b10_q 0 5e-14
cpar_gc4_b10_t gc4_b10_t 0 5e-14
cpar_gc4_b1_n gc4_b1_n 0 5e-14
cpar_gc4_b1_q gc4_b1_q 0 5e-14
cpar_gc4_b1_t gc4_b1_t 0 5e-14
cpar_gc4_b2 gc4_b2 0 5e-14
cpar_gc4_b2_n gc4_b2_n 0 5e-14
cpar_gc4_b2_q gc4_b2_q 0 5e-14
cpar_gc4_b2_t gc4_b2_t 0 5e-14
cpar_gc4_b3 gc4_b3 0 5e-14
cpar_gc4_b3_n gc4_b3_n 0 5e-14
cpar_gc4_b3_q gc4_b3_q 0 5e-14
cpar_gc4_b3_t gc4_b3_t 0 5e-14
cpar_gc4_b4 gc4_b4 0 5e-14
cpar_gc4_b4_n gc4_b4_n 0 5e-14
cpar_gc4_b4_q gc4_b4_q 0 5e-14
cpar_gc4_b4_t gc4_b4_t 0 5e-14
cpar_gc4_b5 gc4_b5 0 5e-14
cpar_gc4_b5_n gc4_b5_n 0 5e-14
cpar_gc4_b5_q gc4_b5_q 0 5e-14
cpar_gc4_b5_t gc4_b5_t 0 5e-14
cpar_gc4_b6 gc4_b6 0 5e-14
cpar_gc4_b6_n gc4_b6_n 0 5e-14
cpar_gc4_b6_q gc4_b6_q 0 5e-14
cpar_gc4_b6_t gc4_b6_t 0 5e-14
cpar_gc4_b7 gc4_b7 0 5e-14
cpar_gc4_b7_n gc4_b7_n 0 5e-14
cpar_gc4_b7_q gc4_b7_q 0 5e-14
cpar_gc4_b7_t gc4_b7_t 0 5e-14
cpar_gc4_b8 gc4_b8 0 5e-14
cpar_gc4_b8_n gc4_b8_n 0 5e-14
cpar_gc4_b8_q gc4_b8_q 0 5e-14
cpar_gc4_b8_t gc4_b8_t 0 5e-14
cpar_gc4_b9 gc4_b9 0 5e-14
cpar_gc4_b9_n gc4_b9_n 0 5e-14
cpar_gc4_b9_q gc4_b9_q 0 5e-14
cpar_gc4_b9_t gc4_b9_t 0 5e-14
cpar_gc4_cin_cg gc4_cin_cg 0 5e-14
cpar_gc4_cin_ena gc4_cin_ena 0 5e-14
cpar_gc4_col_h gc4_col_h 0 5e-14
cpar_gc4_col_kd1 gc4_col_kd1 0 5e-14
cpar_gc4_col_knb gc4_col_knb 0 5e-14
cpar_gc4_col_ko1 gc4_col_ko1 0 5e-14
cpar_gc4_col_ktail gc4_col_ktail 0 5e-14
cpar_gc4_col_q gc4_col_q 0 5e-14
cpar_gc4_col_qb gc4_col_qb 0 5e-14
cpar_gc4_col_rec gc4_col_rec 0 5e-14
cpar_gc4_col_rt gc4_col_rt 0 5e-14
cpar_gc4_col_vm gc4_col_vm 0 5e-14
cpar_gc4_col_vmd gc4_col_vmd 0 5e-14
cpar_gc4_col_vms gc4_col_vms 0 5e-14
cpar_gc4_e10_h gc4_e10_h 0 5e-14
cpar_gc4_e10_kd1 gc4_e10_kd1 0 5e-14
cpar_gc4_e10_knb gc4_e10_knb 0 5e-14
cpar_gc4_e10_ko1 gc4_e10_ko1 0 5e-14
cpar_gc4_e10_ktail gc4_e10_ktail 0 5e-14
cpar_gc4_e10_q gc4_e10_q 0 5e-14
cpar_gc4_e10_qb gc4_e10_qb 0 5e-14
cpar_gc4_e10_rec gc4_e10_rec 0 5e-14
cpar_gc4_e10_rt gc4_e10_rt 0 5e-14
cpar_gc4_e10_vm gc4_e10_vm 0 5e-14
cpar_gc4_e10_vmd gc4_e10_vmd 0 5e-14
cpar_gc4_e10_vms gc4_e10_vms 0 5e-14
cpar_gc4_e1_h gc4_e1_h 0 5e-14
cpar_gc4_e1_kd1 gc4_e1_kd1 0 5e-14
cpar_gc4_e1_knb gc4_e1_knb 0 5e-14
cpar_gc4_e1_ko1 gc4_e1_ko1 0 5e-14
cpar_gc4_e1_ktail gc4_e1_ktail 0 5e-14
cpar_gc4_e1_q gc4_e1_q 0 5e-14
cpar_gc4_e1_qb gc4_e1_qb 0 5e-14
cpar_gc4_e1_rec gc4_e1_rec 0 5e-14
cpar_gc4_e1_rt gc4_e1_rt 0 5e-14
cpar_gc4_e1_vm gc4_e1_vm 0 5e-14
cpar_gc4_e1_vmd gc4_e1_vmd 0 5e-14
cpar_gc4_e1_vms gc4_e1_vms 0 5e-14
cpar_gc4_e2_h gc4_e2_h 0 5e-14
cpar_gc4_e2_kd1 gc4_e2_kd1 0 5e-14
cpar_gc4_e2_knb gc4_e2_knb 0 5e-14
cpar_gc4_e2_ko1 gc4_e2_ko1 0 5e-14
cpar_gc4_e2_ktail gc4_e2_ktail 0 5e-14
cpar_gc4_e2_q gc4_e2_q 0 5e-14
cpar_gc4_e2_qb gc4_e2_qb 0 5e-14
cpar_gc4_e2_rec gc4_e2_rec 0 5e-14
cpar_gc4_e2_rt gc4_e2_rt 0 5e-14
cpar_gc4_e2_vm gc4_e2_vm 0 5e-14
cpar_gc4_e2_vmd gc4_e2_vmd 0 5e-14
cpar_gc4_e2_vms gc4_e2_vms 0 5e-14
cpar_gc4_e3_h gc4_e3_h 0 5e-14
cpar_gc4_e3_kd1 gc4_e3_kd1 0 5e-14
cpar_gc4_e3_knb gc4_e3_knb 0 5e-14
cpar_gc4_e3_ko1 gc4_e3_ko1 0 5e-14
cpar_gc4_e3_ktail gc4_e3_ktail 0 5e-14
cpar_gc4_e3_q gc4_e3_q 0 5e-14
cpar_gc4_e3_qb gc4_e3_qb 0 5e-14
cpar_gc4_e3_rec gc4_e3_rec 0 5e-14
cpar_gc4_e3_rt gc4_e3_rt 0 5e-14
cpar_gc4_e3_vm gc4_e3_vm 0 5e-14
cpar_gc4_e3_vmd gc4_e3_vmd 0 5e-14
cpar_gc4_e3_vms gc4_e3_vms 0 5e-14
cpar_gc4_e4_h gc4_e4_h 0 5e-14
cpar_gc4_e4_kd1 gc4_e4_kd1 0 5e-14
cpar_gc4_e4_knb gc4_e4_knb 0 5e-14
cpar_gc4_e4_ko1 gc4_e4_ko1 0 5e-14
cpar_gc4_e4_ktail gc4_e4_ktail 0 5e-14
cpar_gc4_e4_q gc4_e4_q 0 5e-14
cpar_gc4_e4_qb gc4_e4_qb 0 5e-14
cpar_gc4_e4_rec gc4_e4_rec 0 5e-14
cpar_gc4_e4_rt gc4_e4_rt 0 5e-14
cpar_gc4_e4_vm gc4_e4_vm 0 5e-14
cpar_gc4_e4_vmd gc4_e4_vmd 0 5e-14
cpar_gc4_e4_vms gc4_e4_vms 0 5e-14
cpar_gc4_e5_h gc4_e5_h 0 5e-14
cpar_gc4_e5_kd1 gc4_e5_kd1 0 5e-14
cpar_gc4_e5_knb gc4_e5_knb 0 5e-14
cpar_gc4_e5_ko1 gc4_e5_ko1 0 5e-14
cpar_gc4_e5_ktail gc4_e5_ktail 0 5e-14
cpar_gc4_e5_q gc4_e5_q 0 5e-14
cpar_gc4_e5_qb gc4_e5_qb 0 5e-14
cpar_gc4_e5_rec gc4_e5_rec 0 5e-14
cpar_gc4_e5_rt gc4_e5_rt 0 5e-14
cpar_gc4_e5_vm gc4_e5_vm 0 5e-14
cpar_gc4_e5_vmd gc4_e5_vmd 0 5e-14
cpar_gc4_e5_vms gc4_e5_vms 0 5e-14
cpar_gc4_e6_h gc4_e6_h 0 5e-14
cpar_gc4_e6_kd1 gc4_e6_kd1 0 5e-14
cpar_gc4_e6_knb gc4_e6_knb 0 5e-14
cpar_gc4_e6_ko1 gc4_e6_ko1 0 5e-14
cpar_gc4_e6_ktail gc4_e6_ktail 0 5e-14
cpar_gc4_e6_q gc4_e6_q 0 5e-14
cpar_gc4_e6_qb gc4_e6_qb 0 5e-14
cpar_gc4_e6_rec gc4_e6_rec 0 5e-14
cpar_gc4_e6_rt gc4_e6_rt 0 5e-14
cpar_gc4_e6_vm gc4_e6_vm 0 5e-14
cpar_gc4_e6_vmd gc4_e6_vmd 0 5e-14
cpar_gc4_e6_vms gc4_e6_vms 0 5e-14
cpar_gc4_e7_h gc4_e7_h 0 5e-14
cpar_gc4_e7_kd1 gc4_e7_kd1 0 5e-14
cpar_gc4_e7_knb gc4_e7_knb 0 5e-14
cpar_gc4_e7_ko1 gc4_e7_ko1 0 5e-14
cpar_gc4_e7_ktail gc4_e7_ktail 0 5e-14
cpar_gc4_e7_q gc4_e7_q 0 5e-14
cpar_gc4_e7_qb gc4_e7_qb 0 5e-14
cpar_gc4_e7_rec gc4_e7_rec 0 5e-14
cpar_gc4_e7_rt gc4_e7_rt 0 5e-14
cpar_gc4_e7_vm gc4_e7_vm 0 5e-14
cpar_gc4_e7_vmd gc4_e7_vmd 0 5e-14
cpar_gc4_e7_vms gc4_e7_vms 0 5e-14
cpar_gc4_e8_h gc4_e8_h 0 5e-14
cpar_gc4_e8_kd1 gc4_e8_kd1 0 5e-14
cpar_gc4_e8_knb gc4_e8_knb 0 5e-14
cpar_gc4_e8_ko1 gc4_e8_ko1 0 5e-14
cpar_gc4_e8_ktail gc4_e8_ktail 0 5e-14
cpar_gc4_e8_q gc4_e8_q 0 5e-14
cpar_gc4_e8_qb gc4_e8_qb 0 5e-14
cpar_gc4_e8_rec gc4_e8_rec 0 5e-14
cpar_gc4_e8_rt gc4_e8_rt 0 5e-14
cpar_gc4_e8_vm gc4_e8_vm 0 5e-14
cpar_gc4_e8_vmd gc4_e8_vmd 0 5e-14
cpar_gc4_e8_vms gc4_e8_vms 0 5e-14
cpar_gc4_e9_h gc4_e9_h 0 5e-14
cpar_gc4_e9_kd1 gc4_e9_kd1 0 5e-14
cpar_gc4_e9_knb gc4_e9_knb 0 5e-14
cpar_gc4_e9_ko1 gc4_e9_ko1 0 5e-14
cpar_gc4_e9_ktail gc4_e9_ktail 0 5e-14
cpar_gc4_e9_q gc4_e9_q 0 5e-14
cpar_gc4_e9_qb gc4_e9_qb 0 5e-14
cpar_gc4_e9_rec gc4_e9_rec 0 5e-14
cpar_gc4_e9_rt gc4_e9_rt 0 5e-14
cpar_gc4_e9_vm gc4_e9_vm 0 5e-14
cpar_gc4_e9_vmd gc4_e9_vmd 0 5e-14
cpar_gc4_e9_vms gc4_e9_vms 0 5e-14
cpar_gc4_gb gc4_gb 0 5e-14
cpar_gc4_op_ad gc4_op_ad 0 5e-14
cpar_gc4_op_adn gc4_op_adn 0 5e-14
cpar_gc4_op_an gc4_op_an 0 5e-14
cpar_gc4_op_aq gc4_op_aq 0 5e-14
cpar_gc4_op_aqb gc4_op_aqb 0 5e-14
cpar_gc4_op_at gc4_op_at 0 5e-14
cpar_gc4_op_gx gc4_op_gx 0 5e-14
cpar_gc4_op_p gc4_op_p 0 5e-14
cpar_gc4_op_pb gc4_op_pb 0 5e-14
cpar_gc4_op_tt gc4_op_tt 0 5e-14
cpar_gw1_and_a0_nb gw1_and_a0_nb 0 5e-14
cpar_gw1_and_a0_nx gw1_and_a0_nx 0 5e-14
cpar_gw1_and_a1_nb gw1_and_a1_nb 0 5e-14
cpar_gw1_and_a1_nx gw1_and_a1_nx 0 5e-14
cpar_gw1_and_a2_nb gw1_and_a2_nb 0 5e-14
cpar_gw1_and_a2_nx gw1_and_a2_nx 0 5e-14
cpar_gw1_and_a3_nb gw1_and_a3_nb 0 5e-14
cpar_gw1_and_a3_nx gw1_and_a3_nx 0 5e-14
cpar_gw1_and_a4_nb gw1_and_a4_nb 0 5e-14
cpar_gw1_and_a4_nx gw1_and_a4_nx 0 5e-14
cpar_gw1_and_a5_nb gw1_and_a5_nb 0 5e-14
cpar_gw1_and_a5_nx gw1_and_a5_nx 0 5e-14
cpar_gw1_and_a6_nb gw1_and_a6_nb 0 5e-14
cpar_gw1_and_a6_nx gw1_and_a6_nx 0 5e-14
cpar_gw1_and_a7_nb gw1_and_a7_nb 0 5e-14
cpar_gw1_and_a7_nx gw1_and_a7_nx 0 5e-14
cpar_gw1_and_a8_nb gw1_and_a8_nb 0 5e-14
cpar_gw1_and_a8_nx gw1_and_a8_nx 0 5e-14
cpar_gw1_and_g0 gw1_and_g0 0 5e-14
cpar_gw1_and_g1 gw1_and_g1 0 5e-14
cpar_gw1_and_g2 gw1_and_g2 0 5e-14
cpar_gw1_and_g3 gw1_and_g3 0 5e-14
cpar_gw1_and_g4 gw1_and_g4 0 5e-14
cpar_gw1_and_g5 gw1_and_g5 0 5e-14
cpar_gw1_and_g6 gw1_and_g6 0 5e-14
cpar_gw1_and_g7 gw1_and_g7 0 5e-14
cpar_gw1_and_g8 gw1_and_g8 0 5e-14
cpar_gw1_b1 gw1_b1 0 5e-14
cpar_gw1_b10 gw1_b10 0 5e-14
cpar_gw1_b10_n gw1_b10_n 0 5e-14
cpar_gw1_b10_q gw1_b10_q 0 5e-14
cpar_gw1_b10_t gw1_b10_t 0 5e-14
cpar_gw1_b1_n gw1_b1_n 0 5e-14
cpar_gw1_b1_q gw1_b1_q 0 5e-14
cpar_gw1_b1_t gw1_b1_t 0 5e-14
cpar_gw1_b2 gw1_b2 0 5e-14
cpar_gw1_b2_n gw1_b2_n 0 5e-14
cpar_gw1_b2_q gw1_b2_q 0 5e-14
cpar_gw1_b2_t gw1_b2_t 0 5e-14
cpar_gw1_b3 gw1_b3 0 5e-14
cpar_gw1_b3_n gw1_b3_n 0 5e-14
cpar_gw1_b3_q gw1_b3_q 0 5e-14
cpar_gw1_b3_t gw1_b3_t 0 5e-14
cpar_gw1_b4 gw1_b4 0 5e-14
cpar_gw1_b4_n gw1_b4_n 0 5e-14
cpar_gw1_b4_q gw1_b4_q 0 5e-14
cpar_gw1_b4_t gw1_b4_t 0 5e-14
cpar_gw1_b5 gw1_b5 0 5e-14
cpar_gw1_b5_n gw1_b5_n 0 5e-14
cpar_gw1_b5_q gw1_b5_q 0 5e-14
cpar_gw1_b5_t gw1_b5_t 0 5e-14
cpar_gw1_b6 gw1_b6 0 5e-14
cpar_gw1_b6_n gw1_b6_n 0 5e-14
cpar_gw1_b6_q gw1_b6_q 0 5e-14
cpar_gw1_b6_t gw1_b6_t 0 5e-14
cpar_gw1_b7 gw1_b7 0 5e-14
cpar_gw1_b7_n gw1_b7_n 0 5e-14
cpar_gw1_b7_q gw1_b7_q 0 5e-14
cpar_gw1_b7_t gw1_b7_t 0 5e-14
cpar_gw1_b8 gw1_b8 0 5e-14
cpar_gw1_b8_n gw1_b8_n 0 5e-14
cpar_gw1_b8_q gw1_b8_q 0 5e-14
cpar_gw1_b8_t gw1_b8_t 0 5e-14
cpar_gw1_b9 gw1_b9 0 5e-14
cpar_gw1_b9_n gw1_b9_n 0 5e-14
cpar_gw1_b9_q gw1_b9_q 0 5e-14
cpar_gw1_b9_t gw1_b9_t 0 5e-14
cpar_gw1_cin_cg gw1_cin_cg 0 5e-14
cpar_gw1_cin_ena gw1_cin_ena 0 5e-14
cpar_gw1_col_h gw1_col_h 0 5e-14
cpar_gw1_col_kd1 gw1_col_kd1 0 5e-14
cpar_gw1_col_knb gw1_col_knb 0 5e-14
cpar_gw1_col_ko1 gw1_col_ko1 0 5e-14
cpar_gw1_col_ktail gw1_col_ktail 0 5e-14
cpar_gw1_col_q gw1_col_q 0 5e-14
cpar_gw1_col_qb gw1_col_qb 0 5e-14
cpar_gw1_col_rec gw1_col_rec 0 5e-14
cpar_gw1_col_rt gw1_col_rt 0 5e-14
cpar_gw1_col_vm gw1_col_vm 0 5e-14
cpar_gw1_col_vmd gw1_col_vmd 0 5e-14
cpar_gw1_col_vms gw1_col_vms 0 5e-14
cpar_gw1_e10_h gw1_e10_h 0 5e-14
cpar_gw1_e10_kd1 gw1_e10_kd1 0 5e-14
cpar_gw1_e10_knb gw1_e10_knb 0 5e-14
cpar_gw1_e10_ko1 gw1_e10_ko1 0 5e-14
cpar_gw1_e10_ktail gw1_e10_ktail 0 5e-14
cpar_gw1_e10_q gw1_e10_q 0 5e-14
cpar_gw1_e10_qb gw1_e10_qb 0 5e-14
cpar_gw1_e10_rec gw1_e10_rec 0 5e-14
cpar_gw1_e10_rt gw1_e10_rt 0 5e-14
cpar_gw1_e10_vm gw1_e10_vm 0 5e-14
cpar_gw1_e10_vmd gw1_e10_vmd 0 5e-14
cpar_gw1_e10_vms gw1_e10_vms 0 5e-14
cpar_gw1_e1_h gw1_e1_h 0 5e-14
cpar_gw1_e1_kd1 gw1_e1_kd1 0 5e-14
cpar_gw1_e1_knb gw1_e1_knb 0 5e-14
cpar_gw1_e1_ko1 gw1_e1_ko1 0 5e-14
cpar_gw1_e1_ktail gw1_e1_ktail 0 5e-14
cpar_gw1_e1_q gw1_e1_q 0 5e-14
cpar_gw1_e1_qb gw1_e1_qb 0 5e-14
cpar_gw1_e1_rec gw1_e1_rec 0 5e-14
cpar_gw1_e1_rt gw1_e1_rt 0 5e-14
cpar_gw1_e1_vm gw1_e1_vm 0 5e-14
cpar_gw1_e1_vmd gw1_e1_vmd 0 5e-14
cpar_gw1_e1_vms gw1_e1_vms 0 5e-14
cpar_gw1_e2_h gw1_e2_h 0 5e-14
cpar_gw1_e2_kd1 gw1_e2_kd1 0 5e-14
cpar_gw1_e2_knb gw1_e2_knb 0 5e-14
cpar_gw1_e2_ko1 gw1_e2_ko1 0 5e-14
cpar_gw1_e2_ktail gw1_e2_ktail 0 5e-14
cpar_gw1_e2_q gw1_e2_q 0 5e-14
cpar_gw1_e2_qb gw1_e2_qb 0 5e-14
cpar_gw1_e2_rec gw1_e2_rec 0 5e-14
cpar_gw1_e2_rt gw1_e2_rt 0 5e-14
cpar_gw1_e2_vm gw1_e2_vm 0 5e-14
cpar_gw1_e2_vmd gw1_e2_vmd 0 5e-14
cpar_gw1_e2_vms gw1_e2_vms 0 5e-14
cpar_gw1_e3_h gw1_e3_h 0 5e-14
cpar_gw1_e3_kd1 gw1_e3_kd1 0 5e-14
cpar_gw1_e3_knb gw1_e3_knb 0 5e-14
cpar_gw1_e3_ko1 gw1_e3_ko1 0 5e-14
cpar_gw1_e3_ktail gw1_e3_ktail 0 5e-14
cpar_gw1_e3_q gw1_e3_q 0 5e-14
cpar_gw1_e3_qb gw1_e3_qb 0 5e-14
cpar_gw1_e3_rec gw1_e3_rec 0 5e-14
cpar_gw1_e3_rt gw1_e3_rt 0 5e-14
cpar_gw1_e3_vm gw1_e3_vm 0 5e-14
cpar_gw1_e3_vmd gw1_e3_vmd 0 5e-14
cpar_gw1_e3_vms gw1_e3_vms 0 5e-14
cpar_gw1_e4_h gw1_e4_h 0 5e-14
cpar_gw1_e4_kd1 gw1_e4_kd1 0 5e-14
cpar_gw1_e4_knb gw1_e4_knb 0 5e-14
cpar_gw1_e4_ko1 gw1_e4_ko1 0 5e-14
cpar_gw1_e4_ktail gw1_e4_ktail 0 5e-14
cpar_gw1_e4_q gw1_e4_q 0 5e-14
cpar_gw1_e4_qb gw1_e4_qb 0 5e-14
cpar_gw1_e4_rec gw1_e4_rec 0 5e-14
cpar_gw1_e4_rt gw1_e4_rt 0 5e-14
cpar_gw1_e4_vm gw1_e4_vm 0 5e-14
cpar_gw1_e4_vmd gw1_e4_vmd 0 5e-14
cpar_gw1_e4_vms gw1_e4_vms 0 5e-14
cpar_gw1_e5_h gw1_e5_h 0 5e-14
cpar_gw1_e5_kd1 gw1_e5_kd1 0 5e-14
cpar_gw1_e5_knb gw1_e5_knb 0 5e-14
cpar_gw1_e5_ko1 gw1_e5_ko1 0 5e-14
cpar_gw1_e5_ktail gw1_e5_ktail 0 5e-14
cpar_gw1_e5_q gw1_e5_q 0 5e-14
cpar_gw1_e5_qb gw1_e5_qb 0 5e-14
cpar_gw1_e5_rec gw1_e5_rec 0 5e-14
cpar_gw1_e5_rt gw1_e5_rt 0 5e-14
cpar_gw1_e5_vm gw1_e5_vm 0 5e-14
cpar_gw1_e5_vmd gw1_e5_vmd 0 5e-14
cpar_gw1_e5_vms gw1_e5_vms 0 5e-14
cpar_gw1_e6_h gw1_e6_h 0 5e-14
cpar_gw1_e6_kd1 gw1_e6_kd1 0 5e-14
cpar_gw1_e6_knb gw1_e6_knb 0 5e-14
cpar_gw1_e6_ko1 gw1_e6_ko1 0 5e-14
cpar_gw1_e6_ktail gw1_e6_ktail 0 5e-14
cpar_gw1_e6_q gw1_e6_q 0 5e-14
cpar_gw1_e6_qb gw1_e6_qb 0 5e-14
cpar_gw1_e6_rec gw1_e6_rec 0 5e-14
cpar_gw1_e6_rt gw1_e6_rt 0 5e-14
cpar_gw1_e6_vm gw1_e6_vm 0 5e-14
cpar_gw1_e6_vmd gw1_e6_vmd 0 5e-14
cpar_gw1_e6_vms gw1_e6_vms 0 5e-14
cpar_gw1_e7_h gw1_e7_h 0 5e-14
cpar_gw1_e7_kd1 gw1_e7_kd1 0 5e-14
cpar_gw1_e7_knb gw1_e7_knb 0 5e-14
cpar_gw1_e7_ko1 gw1_e7_ko1 0 5e-14
cpar_gw1_e7_ktail gw1_e7_ktail 0 5e-14
cpar_gw1_e7_q gw1_e7_q 0 5e-14
cpar_gw1_e7_qb gw1_e7_qb 0 5e-14
cpar_gw1_e7_rec gw1_e7_rec 0 5e-14
cpar_gw1_e7_rt gw1_e7_rt 0 5e-14
cpar_gw1_e7_vm gw1_e7_vm 0 5e-14
cpar_gw1_e7_vmd gw1_e7_vmd 0 5e-14
cpar_gw1_e7_vms gw1_e7_vms 0 5e-14
cpar_gw1_e8_h gw1_e8_h 0 5e-14
cpar_gw1_e8_kd1 gw1_e8_kd1 0 5e-14
cpar_gw1_e8_knb gw1_e8_knb 0 5e-14
cpar_gw1_e8_ko1 gw1_e8_ko1 0 5e-14
cpar_gw1_e8_ktail gw1_e8_ktail 0 5e-14
cpar_gw1_e8_q gw1_e8_q 0 5e-14
cpar_gw1_e8_qb gw1_e8_qb 0 5e-14
cpar_gw1_e8_rec gw1_e8_rec 0 5e-14
cpar_gw1_e8_rt gw1_e8_rt 0 5e-14
cpar_gw1_e8_vm gw1_e8_vm 0 5e-14
cpar_gw1_e8_vmd gw1_e8_vmd 0 5e-14
cpar_gw1_e8_vms gw1_e8_vms 0 5e-14
cpar_gw1_e9_h gw1_e9_h 0 5e-14
cpar_gw1_e9_kd1 gw1_e9_kd1 0 5e-14
cpar_gw1_e9_knb gw1_e9_knb 0 5e-14
cpar_gw1_e9_ko1 gw1_e9_ko1 0 5e-14
cpar_gw1_e9_ktail gw1_e9_ktail 0 5e-14
cpar_gw1_e9_q gw1_e9_q 0 5e-14
cpar_gw1_e9_qb gw1_e9_qb 0 5e-14
cpar_gw1_e9_rec gw1_e9_rec 0 5e-14
cpar_gw1_e9_rt gw1_e9_rt 0 5e-14
cpar_gw1_e9_vm gw1_e9_vm 0 5e-14
cpar_gw1_e9_vmd gw1_e9_vmd 0 5e-14
cpar_gw1_e9_vms gw1_e9_vms 0 5e-14
cpar_gw1_gb gw1_gb 0 5e-14
cpar_gw1_op_ad gw1_op_ad 0 5e-14
cpar_gw1_op_adn gw1_op_adn 0 5e-14
cpar_gw1_op_an gw1_op_an 0 5e-14
cpar_gw1_op_aq gw1_op_aq 0 5e-14
cpar_gw1_op_aqb gw1_op_aqb 0 5e-14
cpar_gw1_op_at gw1_op_at 0 5e-14
cpar_gw1_op_gx gw1_op_gx 0 5e-14
cpar_gw1_op_p gw1_op_p 0 5e-14
cpar_gw1_op_pb gw1_op_pb 0 5e-14
cpar_gw1_op_tt gw1_op_tt 0 5e-14
cpar_gw2_and_a0_nb gw2_and_a0_nb 0 5e-14
cpar_gw2_and_a0_nx gw2_and_a0_nx 0 5e-14
cpar_gw2_and_a1_nb gw2_and_a1_nb 0 5e-14
cpar_gw2_and_a1_nx gw2_and_a1_nx 0 5e-14
cpar_gw2_and_a2_nb gw2_and_a2_nb 0 5e-14
cpar_gw2_and_a2_nx gw2_and_a2_nx 0 5e-14
cpar_gw2_and_a3_nb gw2_and_a3_nb 0 5e-14
cpar_gw2_and_a3_nx gw2_and_a3_nx 0 5e-14
cpar_gw2_and_a4_nb gw2_and_a4_nb 0 5e-14
cpar_gw2_and_a4_nx gw2_and_a4_nx 0 5e-14
cpar_gw2_and_a5_nb gw2_and_a5_nb 0 5e-14
cpar_gw2_and_a5_nx gw2_and_a5_nx 0 5e-14
cpar_gw2_and_a6_nb gw2_and_a6_nb 0 5e-14
cpar_gw2_and_a6_nx gw2_and_a6_nx 0 5e-14
cpar_gw2_and_a7_nb gw2_and_a7_nb 0 5e-14
cpar_gw2_and_a7_nx gw2_and_a7_nx 0 5e-14
cpar_gw2_and_a8_nb gw2_and_a8_nb 0 5e-14
cpar_gw2_and_a8_nx gw2_and_a8_nx 0 5e-14
cpar_gw2_and_g0 gw2_and_g0 0 5e-14
cpar_gw2_and_g1 gw2_and_g1 0 5e-14
cpar_gw2_and_g2 gw2_and_g2 0 5e-14
cpar_gw2_and_g3 gw2_and_g3 0 5e-14
cpar_gw2_and_g4 gw2_and_g4 0 5e-14
cpar_gw2_and_g5 gw2_and_g5 0 5e-14
cpar_gw2_and_g6 gw2_and_g6 0 5e-14
cpar_gw2_and_g7 gw2_and_g7 0 5e-14
cpar_gw2_and_g8 gw2_and_g8 0 5e-14
cpar_gw2_b1 gw2_b1 0 5e-14
cpar_gw2_b10 gw2_b10 0 5e-14
cpar_gw2_b10_n gw2_b10_n 0 5e-14
cpar_gw2_b10_q gw2_b10_q 0 5e-14
cpar_gw2_b10_t gw2_b10_t 0 5e-14
cpar_gw2_b1_n gw2_b1_n 0 5e-14
cpar_gw2_b1_q gw2_b1_q 0 5e-14
cpar_gw2_b1_t gw2_b1_t 0 5e-14
cpar_gw2_b2 gw2_b2 0 5e-14
cpar_gw2_b2_n gw2_b2_n 0 5e-14
cpar_gw2_b2_q gw2_b2_q 0 5e-14
cpar_gw2_b2_t gw2_b2_t 0 5e-14
cpar_gw2_b3 gw2_b3 0 5e-14
cpar_gw2_b3_n gw2_b3_n 0 5e-14
cpar_gw2_b3_q gw2_b3_q 0 5e-14
cpar_gw2_b3_t gw2_b3_t 0 5e-14
cpar_gw2_b4 gw2_b4 0 5e-14
cpar_gw2_b4_n gw2_b4_n 0 5e-14
cpar_gw2_b4_q gw2_b4_q 0 5e-14
cpar_gw2_b4_t gw2_b4_t 0 5e-14
cpar_gw2_b5 gw2_b5 0 5e-14
cpar_gw2_b5_n gw2_b5_n 0 5e-14
cpar_gw2_b5_q gw2_b5_q 0 5e-14
cpar_gw2_b5_t gw2_b5_t 0 5e-14
cpar_gw2_b6 gw2_b6 0 5e-14
cpar_gw2_b6_n gw2_b6_n 0 5e-14
cpar_gw2_b6_q gw2_b6_q 0 5e-14
cpar_gw2_b6_t gw2_b6_t 0 5e-14
cpar_gw2_b7 gw2_b7 0 5e-14
cpar_gw2_b7_n gw2_b7_n 0 5e-14
cpar_gw2_b7_q gw2_b7_q 0 5e-14
cpar_gw2_b7_t gw2_b7_t 0 5e-14
cpar_gw2_b8 gw2_b8 0 5e-14
cpar_gw2_b8_n gw2_b8_n 0 5e-14
cpar_gw2_b8_q gw2_b8_q 0 5e-14
cpar_gw2_b8_t gw2_b8_t 0 5e-14
cpar_gw2_b9 gw2_b9 0 5e-14
cpar_gw2_b9_n gw2_b9_n 0 5e-14
cpar_gw2_b9_q gw2_b9_q 0 5e-14
cpar_gw2_b9_t gw2_b9_t 0 5e-14
cpar_gw2_cin_cg gw2_cin_cg 0 5e-14
cpar_gw2_cin_ena gw2_cin_ena 0 5e-14
cpar_gw2_col_h gw2_col_h 0 5e-14
cpar_gw2_col_kd1 gw2_col_kd1 0 5e-14
cpar_gw2_col_knb gw2_col_knb 0 5e-14
cpar_gw2_col_ko1 gw2_col_ko1 0 5e-14
cpar_gw2_col_ktail gw2_col_ktail 0 5e-14
cpar_gw2_col_q gw2_col_q 0 5e-14
cpar_gw2_col_qb gw2_col_qb 0 5e-14
cpar_gw2_col_rec gw2_col_rec 0 5e-14
cpar_gw2_col_rt gw2_col_rt 0 5e-14
cpar_gw2_col_vm gw2_col_vm 0 5e-14
cpar_gw2_col_vmd gw2_col_vmd 0 5e-14
cpar_gw2_col_vms gw2_col_vms 0 5e-14
cpar_gw2_e10_h gw2_e10_h 0 5e-14
cpar_gw2_e10_kd1 gw2_e10_kd1 0 5e-14
cpar_gw2_e10_knb gw2_e10_knb 0 5e-14
cpar_gw2_e10_ko1 gw2_e10_ko1 0 5e-14
cpar_gw2_e10_ktail gw2_e10_ktail 0 5e-14
cpar_gw2_e10_q gw2_e10_q 0 5e-14
cpar_gw2_e10_qb gw2_e10_qb 0 5e-14
cpar_gw2_e10_rec gw2_e10_rec 0 5e-14
cpar_gw2_e10_rt gw2_e10_rt 0 5e-14
cpar_gw2_e10_vm gw2_e10_vm 0 5e-14
cpar_gw2_e10_vmd gw2_e10_vmd 0 5e-14
cpar_gw2_e10_vms gw2_e10_vms 0 5e-14
cpar_gw2_e1_h gw2_e1_h 0 5e-14
cpar_gw2_e1_kd1 gw2_e1_kd1 0 5e-14
cpar_gw2_e1_knb gw2_e1_knb 0 5e-14
cpar_gw2_e1_ko1 gw2_e1_ko1 0 5e-14
cpar_gw2_e1_ktail gw2_e1_ktail 0 5e-14
cpar_gw2_e1_q gw2_e1_q 0 5e-14
cpar_gw2_e1_qb gw2_e1_qb 0 5e-14
cpar_gw2_e1_rec gw2_e1_rec 0 5e-14
cpar_gw2_e1_rt gw2_e1_rt 0 5e-14
cpar_gw2_e1_vm gw2_e1_vm 0 5e-14
cpar_gw2_e1_vmd gw2_e1_vmd 0 5e-14
cpar_gw2_e1_vms gw2_e1_vms 0 5e-14
cpar_gw2_e2_h gw2_e2_h 0 5e-14
cpar_gw2_e2_kd1 gw2_e2_kd1 0 5e-14
cpar_gw2_e2_knb gw2_e2_knb 0 5e-14
cpar_gw2_e2_ko1 gw2_e2_ko1 0 5e-14
cpar_gw2_e2_ktail gw2_e2_ktail 0 5e-14
cpar_gw2_e2_q gw2_e2_q 0 5e-14
cpar_gw2_e2_qb gw2_e2_qb 0 5e-14
cpar_gw2_e2_rec gw2_e2_rec 0 5e-14
cpar_gw2_e2_rt gw2_e2_rt 0 5e-14
cpar_gw2_e2_vm gw2_e2_vm 0 5e-14
cpar_gw2_e2_vmd gw2_e2_vmd 0 5e-14
cpar_gw2_e2_vms gw2_e2_vms 0 5e-14
cpar_gw2_e3_h gw2_e3_h 0 5e-14
cpar_gw2_e3_kd1 gw2_e3_kd1 0 5e-14
cpar_gw2_e3_knb gw2_e3_knb 0 5e-14
cpar_gw2_e3_ko1 gw2_e3_ko1 0 5e-14
cpar_gw2_e3_ktail gw2_e3_ktail 0 5e-14
cpar_gw2_e3_q gw2_e3_q 0 5e-14
cpar_gw2_e3_qb gw2_e3_qb 0 5e-14
cpar_gw2_e3_rec gw2_e3_rec 0 5e-14
cpar_gw2_e3_rt gw2_e3_rt 0 5e-14
cpar_gw2_e3_vm gw2_e3_vm 0 5e-14
cpar_gw2_e3_vmd gw2_e3_vmd 0 5e-14
cpar_gw2_e3_vms gw2_e3_vms 0 5e-14
cpar_gw2_e4_h gw2_e4_h 0 5e-14
cpar_gw2_e4_kd1 gw2_e4_kd1 0 5e-14
cpar_gw2_e4_knb gw2_e4_knb 0 5e-14
cpar_gw2_e4_ko1 gw2_e4_ko1 0 5e-14
cpar_gw2_e4_ktail gw2_e4_ktail 0 5e-14
cpar_gw2_e4_q gw2_e4_q 0 5e-14
cpar_gw2_e4_qb gw2_e4_qb 0 5e-14
cpar_gw2_e4_rec gw2_e4_rec 0 5e-14
cpar_gw2_e4_rt gw2_e4_rt 0 5e-14
cpar_gw2_e4_vm gw2_e4_vm 0 5e-14
cpar_gw2_e4_vmd gw2_e4_vmd 0 5e-14
cpar_gw2_e4_vms gw2_e4_vms 0 5e-14
cpar_gw2_e5_h gw2_e5_h 0 5e-14
cpar_gw2_e5_kd1 gw2_e5_kd1 0 5e-14
cpar_gw2_e5_knb gw2_e5_knb 0 5e-14
cpar_gw2_e5_ko1 gw2_e5_ko1 0 5e-14
cpar_gw2_e5_ktail gw2_e5_ktail 0 5e-14
cpar_gw2_e5_q gw2_e5_q 0 5e-14
cpar_gw2_e5_qb gw2_e5_qb 0 5e-14
cpar_gw2_e5_rec gw2_e5_rec 0 5e-14
cpar_gw2_e5_rt gw2_e5_rt 0 5e-14
cpar_gw2_e5_vm gw2_e5_vm 0 5e-14
cpar_gw2_e5_vmd gw2_e5_vmd 0 5e-14
cpar_gw2_e5_vms gw2_e5_vms 0 5e-14
cpar_gw2_e6_h gw2_e6_h 0 5e-14
cpar_gw2_e6_kd1 gw2_e6_kd1 0 5e-14
cpar_gw2_e6_knb gw2_e6_knb 0 5e-14
cpar_gw2_e6_ko1 gw2_e6_ko1 0 5e-14
cpar_gw2_e6_ktail gw2_e6_ktail 0 5e-14
cpar_gw2_e6_q gw2_e6_q 0 5e-14
cpar_gw2_e6_qb gw2_e6_qb 0 5e-14
cpar_gw2_e6_rec gw2_e6_rec 0 5e-14
cpar_gw2_e6_rt gw2_e6_rt 0 5e-14
cpar_gw2_e6_vm gw2_e6_vm 0 5e-14
cpar_gw2_e6_vmd gw2_e6_vmd 0 5e-14
cpar_gw2_e6_vms gw2_e6_vms 0 5e-14
cpar_gw2_e7_h gw2_e7_h 0 5e-14
cpar_gw2_e7_kd1 gw2_e7_kd1 0 5e-14
cpar_gw2_e7_knb gw2_e7_knb 0 5e-14
cpar_gw2_e7_ko1 gw2_e7_ko1 0 5e-14
cpar_gw2_e7_ktail gw2_e7_ktail 0 5e-14
cpar_gw2_e7_q gw2_e7_q 0 5e-14
cpar_gw2_e7_qb gw2_e7_qb 0 5e-14
cpar_gw2_e7_rec gw2_e7_rec 0 5e-14
cpar_gw2_e7_rt gw2_e7_rt 0 5e-14
cpar_gw2_e7_vm gw2_e7_vm 0 5e-14
cpar_gw2_e7_vmd gw2_e7_vmd 0 5e-14
cpar_gw2_e7_vms gw2_e7_vms 0 5e-14
cpar_gw2_e8_h gw2_e8_h 0 5e-14
cpar_gw2_e8_kd1 gw2_e8_kd1 0 5e-14
cpar_gw2_e8_knb gw2_e8_knb 0 5e-14
cpar_gw2_e8_ko1 gw2_e8_ko1 0 5e-14
cpar_gw2_e8_ktail gw2_e8_ktail 0 5e-14
cpar_gw2_e8_q gw2_e8_q 0 5e-14
cpar_gw2_e8_qb gw2_e8_qb 0 5e-14
cpar_gw2_e8_rec gw2_e8_rec 0 5e-14
cpar_gw2_e8_rt gw2_e8_rt 0 5e-14
cpar_gw2_e8_vm gw2_e8_vm 0 5e-14
cpar_gw2_e8_vmd gw2_e8_vmd 0 5e-14
cpar_gw2_e8_vms gw2_e8_vms 0 5e-14
cpar_gw2_e9_h gw2_e9_h 0 5e-14
cpar_gw2_e9_kd1 gw2_e9_kd1 0 5e-14
cpar_gw2_e9_knb gw2_e9_knb 0 5e-14
cpar_gw2_e9_ko1 gw2_e9_ko1 0 5e-14
cpar_gw2_e9_ktail gw2_e9_ktail 0 5e-14
cpar_gw2_e9_q gw2_e9_q 0 5e-14
cpar_gw2_e9_qb gw2_e9_qb 0 5e-14
cpar_gw2_e9_rec gw2_e9_rec 0 5e-14
cpar_gw2_e9_rt gw2_e9_rt 0 5e-14
cpar_gw2_e9_vm gw2_e9_vm 0 5e-14
cpar_gw2_e9_vmd gw2_e9_vmd 0 5e-14
cpar_gw2_e9_vms gw2_e9_vms 0 5e-14
cpar_gw2_gb gw2_gb 0 5e-14
cpar_gw2_op_ad gw2_op_ad 0 5e-14
cpar_gw2_op_adn gw2_op_adn 0 5e-14
cpar_gw2_op_an gw2_op_an 0 5e-14
cpar_gw2_op_aq gw2_op_aq 0 5e-14
cpar_gw2_op_aqb gw2_op_aqb 0 5e-14
cpar_gw2_op_at gw2_op_at 0 5e-14
cpar_gw2_op_gx gw2_op_gx 0 5e-14
cpar_gw2_op_p gw2_op_p 0 5e-14
cpar_gw2_op_pb gw2_op_pb 0 5e-14
cpar_gw2_op_tt gw2_op_tt 0 5e-14
cpar_gw3_and_a0_nb gw3_and_a0_nb 0 5e-14
cpar_gw3_and_a0_nx gw3_and_a0_nx 0 5e-14
cpar_gw3_and_a1_nb gw3_and_a1_nb 0 5e-14
cpar_gw3_and_a1_nx gw3_and_a1_nx 0 5e-14
cpar_gw3_and_a2_nb gw3_and_a2_nb 0 5e-14
cpar_gw3_and_a2_nx gw3_and_a2_nx 0 5e-14
cpar_gw3_and_a3_nb gw3_and_a3_nb 0 5e-14
cpar_gw3_and_a3_nx gw3_and_a3_nx 0 5e-14
cpar_gw3_and_a4_nb gw3_and_a4_nb 0 5e-14
cpar_gw3_and_a4_nx gw3_and_a4_nx 0 5e-14
cpar_gw3_and_a5_nb gw3_and_a5_nb 0 5e-14
cpar_gw3_and_a5_nx gw3_and_a5_nx 0 5e-14
cpar_gw3_and_a6_nb gw3_and_a6_nb 0 5e-14
cpar_gw3_and_a6_nx gw3_and_a6_nx 0 5e-14
cpar_gw3_and_a7_nb gw3_and_a7_nb 0 5e-14
cpar_gw3_and_a7_nx gw3_and_a7_nx 0 5e-14
cpar_gw3_and_a8_nb gw3_and_a8_nb 0 5e-14
cpar_gw3_and_a8_nx gw3_and_a8_nx 0 5e-14
cpar_gw3_and_g0 gw3_and_g0 0 5e-14
cpar_gw3_and_g1 gw3_and_g1 0 5e-14
cpar_gw3_and_g2 gw3_and_g2 0 5e-14
cpar_gw3_and_g3 gw3_and_g3 0 5e-14
cpar_gw3_and_g4 gw3_and_g4 0 5e-14
cpar_gw3_and_g5 gw3_and_g5 0 5e-14
cpar_gw3_and_g6 gw3_and_g6 0 5e-14
cpar_gw3_and_g7 gw3_and_g7 0 5e-14
cpar_gw3_and_g8 gw3_and_g8 0 5e-14
cpar_gw3_b1 gw3_b1 0 5e-14
cpar_gw3_b10 gw3_b10 0 5e-14
cpar_gw3_b10_n gw3_b10_n 0 5e-14
cpar_gw3_b10_q gw3_b10_q 0 5e-14
cpar_gw3_b10_t gw3_b10_t 0 5e-14
cpar_gw3_b1_n gw3_b1_n 0 5e-14
cpar_gw3_b1_q gw3_b1_q 0 5e-14
cpar_gw3_b1_t gw3_b1_t 0 5e-14
cpar_gw3_b2 gw3_b2 0 5e-14
cpar_gw3_b2_n gw3_b2_n 0 5e-14
cpar_gw3_b2_q gw3_b2_q 0 5e-14
cpar_gw3_b2_t gw3_b2_t 0 5e-14
cpar_gw3_b3 gw3_b3 0 5e-14
cpar_gw3_b3_n gw3_b3_n 0 5e-14
cpar_gw3_b3_q gw3_b3_q 0 5e-14
cpar_gw3_b3_t gw3_b3_t 0 5e-14
cpar_gw3_b4 gw3_b4 0 5e-14
cpar_gw3_b4_n gw3_b4_n 0 5e-14
cpar_gw3_b4_q gw3_b4_q 0 5e-14
cpar_gw3_b4_t gw3_b4_t 0 5e-14
cpar_gw3_b5 gw3_b5 0 5e-14
cpar_gw3_b5_n gw3_b5_n 0 5e-14
cpar_gw3_b5_q gw3_b5_q 0 5e-14
cpar_gw3_b5_t gw3_b5_t 0 5e-14
cpar_gw3_b6 gw3_b6 0 5e-14
cpar_gw3_b6_n gw3_b6_n 0 5e-14
cpar_gw3_b6_q gw3_b6_q 0 5e-14
cpar_gw3_b6_t gw3_b6_t 0 5e-14
cpar_gw3_b7 gw3_b7 0 5e-14
cpar_gw3_b7_n gw3_b7_n 0 5e-14
cpar_gw3_b7_q gw3_b7_q 0 5e-14
cpar_gw3_b7_t gw3_b7_t 0 5e-14
cpar_gw3_b8 gw3_b8 0 5e-14
cpar_gw3_b8_n gw3_b8_n 0 5e-14
cpar_gw3_b8_q gw3_b8_q 0 5e-14
cpar_gw3_b8_t gw3_b8_t 0 5e-14
cpar_gw3_b9 gw3_b9 0 5e-14
cpar_gw3_b9_n gw3_b9_n 0 5e-14
cpar_gw3_b9_q gw3_b9_q 0 5e-14
cpar_gw3_b9_t gw3_b9_t 0 5e-14
cpar_gw3_cin_cg gw3_cin_cg 0 5e-14
cpar_gw3_cin_ena gw3_cin_ena 0 5e-14
cpar_gw3_col_h gw3_col_h 0 5e-14
cpar_gw3_col_kd1 gw3_col_kd1 0 5e-14
cpar_gw3_col_knb gw3_col_knb 0 5e-14
cpar_gw3_col_ko1 gw3_col_ko1 0 5e-14
cpar_gw3_col_ktail gw3_col_ktail 0 5e-14
cpar_gw3_col_q gw3_col_q 0 5e-14
cpar_gw3_col_qb gw3_col_qb 0 5e-14
cpar_gw3_col_rec gw3_col_rec 0 5e-14
cpar_gw3_col_rt gw3_col_rt 0 5e-14
cpar_gw3_col_vm gw3_col_vm 0 5e-14
cpar_gw3_col_vmd gw3_col_vmd 0 5e-14
cpar_gw3_col_vms gw3_col_vms 0 5e-14
cpar_gw3_e10_h gw3_e10_h 0 5e-14
cpar_gw3_e10_kd1 gw3_e10_kd1 0 5e-14
cpar_gw3_e10_knb gw3_e10_knb 0 5e-14
cpar_gw3_e10_ko1 gw3_e10_ko1 0 5e-14
cpar_gw3_e10_ktail gw3_e10_ktail 0 5e-14
cpar_gw3_e10_q gw3_e10_q 0 5e-14
cpar_gw3_e10_qb gw3_e10_qb 0 5e-14
cpar_gw3_e10_rec gw3_e10_rec 0 5e-14
cpar_gw3_e10_rt gw3_e10_rt 0 5e-14
cpar_gw3_e10_vm gw3_e10_vm 0 5e-14
cpar_gw3_e10_vmd gw3_e10_vmd 0 5e-14
cpar_gw3_e10_vms gw3_e10_vms 0 5e-14
cpar_gw3_e1_h gw3_e1_h 0 5e-14
cpar_gw3_e1_kd1 gw3_e1_kd1 0 5e-14
cpar_gw3_e1_knb gw3_e1_knb 0 5e-14
cpar_gw3_e1_ko1 gw3_e1_ko1 0 5e-14
cpar_gw3_e1_ktail gw3_e1_ktail 0 5e-14
cpar_gw3_e1_q gw3_e1_q 0 5e-14
cpar_gw3_e1_qb gw3_e1_qb 0 5e-14
cpar_gw3_e1_rec gw3_e1_rec 0 5e-14
cpar_gw3_e1_rt gw3_e1_rt 0 5e-14
cpar_gw3_e1_vm gw3_e1_vm 0 5e-14
cpar_gw3_e1_vmd gw3_e1_vmd 0 5e-14
cpar_gw3_e1_vms gw3_e1_vms 0 5e-14
cpar_gw3_e2_h gw3_e2_h 0 5e-14
cpar_gw3_e2_kd1 gw3_e2_kd1 0 5e-14
cpar_gw3_e2_knb gw3_e2_knb 0 5e-14
cpar_gw3_e2_ko1 gw3_e2_ko1 0 5e-14
cpar_gw3_e2_ktail gw3_e2_ktail 0 5e-14
cpar_gw3_e2_q gw3_e2_q 0 5e-14
cpar_gw3_e2_qb gw3_e2_qb 0 5e-14
cpar_gw3_e2_rec gw3_e2_rec 0 5e-14
cpar_gw3_e2_rt gw3_e2_rt 0 5e-14
cpar_gw3_e2_vm gw3_e2_vm 0 5e-14
cpar_gw3_e2_vmd gw3_e2_vmd 0 5e-14
cpar_gw3_e2_vms gw3_e2_vms 0 5e-14
cpar_gw3_e3_h gw3_e3_h 0 5e-14
cpar_gw3_e3_kd1 gw3_e3_kd1 0 5e-14
cpar_gw3_e3_knb gw3_e3_knb 0 5e-14
cpar_gw3_e3_ko1 gw3_e3_ko1 0 5e-14
cpar_gw3_e3_ktail gw3_e3_ktail 0 5e-14
cpar_gw3_e3_q gw3_e3_q 0 5e-14
cpar_gw3_e3_qb gw3_e3_qb 0 5e-14
cpar_gw3_e3_rec gw3_e3_rec 0 5e-14
cpar_gw3_e3_rt gw3_e3_rt 0 5e-14
cpar_gw3_e3_vm gw3_e3_vm 0 5e-14
cpar_gw3_e3_vmd gw3_e3_vmd 0 5e-14
cpar_gw3_e3_vms gw3_e3_vms 0 5e-14
cpar_gw3_e4_h gw3_e4_h 0 5e-14
cpar_gw3_e4_kd1 gw3_e4_kd1 0 5e-14
cpar_gw3_e4_knb gw3_e4_knb 0 5e-14
cpar_gw3_e4_ko1 gw3_e4_ko1 0 5e-14
cpar_gw3_e4_ktail gw3_e4_ktail 0 5e-14
cpar_gw3_e4_q gw3_e4_q 0 5e-14
cpar_gw3_e4_qb gw3_e4_qb 0 5e-14
cpar_gw3_e4_rec gw3_e4_rec 0 5e-14
cpar_gw3_e4_rt gw3_e4_rt 0 5e-14
cpar_gw3_e4_vm gw3_e4_vm 0 5e-14
cpar_gw3_e4_vmd gw3_e4_vmd 0 5e-14
cpar_gw3_e4_vms gw3_e4_vms 0 5e-14
cpar_gw3_e5_h gw3_e5_h 0 5e-14
cpar_gw3_e5_kd1 gw3_e5_kd1 0 5e-14
cpar_gw3_e5_knb gw3_e5_knb 0 5e-14
cpar_gw3_e5_ko1 gw3_e5_ko1 0 5e-14
cpar_gw3_e5_ktail gw3_e5_ktail 0 5e-14
cpar_gw3_e5_q gw3_e5_q 0 5e-14
cpar_gw3_e5_qb gw3_e5_qb 0 5e-14
cpar_gw3_e5_rec gw3_e5_rec 0 5e-14
cpar_gw3_e5_rt gw3_e5_rt 0 5e-14
cpar_gw3_e5_vm gw3_e5_vm 0 5e-14
cpar_gw3_e5_vmd gw3_e5_vmd 0 5e-14
cpar_gw3_e5_vms gw3_e5_vms 0 5e-14
cpar_gw3_e6_h gw3_e6_h 0 5e-14
cpar_gw3_e6_kd1 gw3_e6_kd1 0 5e-14
cpar_gw3_e6_knb gw3_e6_knb 0 5e-14
cpar_gw3_e6_ko1 gw3_e6_ko1 0 5e-14
cpar_gw3_e6_ktail gw3_e6_ktail 0 5e-14
cpar_gw3_e6_q gw3_e6_q 0 5e-14
cpar_gw3_e6_qb gw3_e6_qb 0 5e-14
cpar_gw3_e6_rec gw3_e6_rec 0 5e-14
cpar_gw3_e6_rt gw3_e6_rt 0 5e-14
cpar_gw3_e6_vm gw3_e6_vm 0 5e-14
cpar_gw3_e6_vmd gw3_e6_vmd 0 5e-14
cpar_gw3_e6_vms gw3_e6_vms 0 5e-14
cpar_gw3_e7_h gw3_e7_h 0 5e-14
cpar_gw3_e7_kd1 gw3_e7_kd1 0 5e-14
cpar_gw3_e7_knb gw3_e7_knb 0 5e-14
cpar_gw3_e7_ko1 gw3_e7_ko1 0 5e-14
cpar_gw3_e7_ktail gw3_e7_ktail 0 5e-14
cpar_gw3_e7_q gw3_e7_q 0 5e-14
cpar_gw3_e7_qb gw3_e7_qb 0 5e-14
cpar_gw3_e7_rec gw3_e7_rec 0 5e-14
cpar_gw3_e7_rt gw3_e7_rt 0 5e-14
cpar_gw3_e7_vm gw3_e7_vm 0 5e-14
cpar_gw3_e7_vmd gw3_e7_vmd 0 5e-14
cpar_gw3_e7_vms gw3_e7_vms 0 5e-14
cpar_gw3_e8_h gw3_e8_h 0 5e-14
cpar_gw3_e8_kd1 gw3_e8_kd1 0 5e-14
cpar_gw3_e8_knb gw3_e8_knb 0 5e-14
cpar_gw3_e8_ko1 gw3_e8_ko1 0 5e-14
cpar_gw3_e8_ktail gw3_e8_ktail 0 5e-14
cpar_gw3_e8_q gw3_e8_q 0 5e-14
cpar_gw3_e8_qb gw3_e8_qb 0 5e-14
cpar_gw3_e8_rec gw3_e8_rec 0 5e-14
cpar_gw3_e8_rt gw3_e8_rt 0 5e-14
cpar_gw3_e8_vm gw3_e8_vm 0 5e-14
cpar_gw3_e8_vmd gw3_e8_vmd 0 5e-14
cpar_gw3_e8_vms gw3_e8_vms 0 5e-14
cpar_gw3_e9_h gw3_e9_h 0 5e-14
cpar_gw3_e9_kd1 gw3_e9_kd1 0 5e-14
cpar_gw3_e9_knb gw3_e9_knb 0 5e-14
cpar_gw3_e9_ko1 gw3_e9_ko1 0 5e-14
cpar_gw3_e9_ktail gw3_e9_ktail 0 5e-14
cpar_gw3_e9_q gw3_e9_q 0 5e-14
cpar_gw3_e9_qb gw3_e9_qb 0 5e-14
cpar_gw3_e9_rec gw3_e9_rec 0 5e-14
cpar_gw3_e9_rt gw3_e9_rt 0 5e-14
cpar_gw3_e9_vm gw3_e9_vm 0 5e-14
cpar_gw3_e9_vmd gw3_e9_vmd 0 5e-14
cpar_gw3_e9_vms gw3_e9_vms 0 5e-14
cpar_gw3_gb gw3_gb 0 5e-14
cpar_gw3_op_ad gw3_op_ad 0 5e-14
cpar_gw3_op_adn gw3_op_adn 0 5e-14
cpar_gw3_op_an gw3_op_an 0 5e-14
cpar_gw3_op_aq gw3_op_aq 0 5e-14
cpar_gw3_op_aqb gw3_op_aqb 0 5e-14
cpar_gw3_op_at gw3_op_at 0 5e-14
cpar_gw3_op_gx gw3_op_gx 0 5e-14
cpar_gw3_op_p gw3_op_p 0 5e-14
cpar_gw3_op_pb gw3_op_pb 0 5e-14
cpar_gw3_op_tt gw3_op_tt 0 5e-14
cpar_gw4_and_a0_nb gw4_and_a0_nb 0 5e-14
cpar_gw4_and_a0_nx gw4_and_a0_nx 0 5e-14
cpar_gw4_and_a1_nb gw4_and_a1_nb 0 5e-14
cpar_gw4_and_a1_nx gw4_and_a1_nx 0 5e-14
cpar_gw4_and_a2_nb gw4_and_a2_nb 0 5e-14
cpar_gw4_and_a2_nx gw4_and_a2_nx 0 5e-14
cpar_gw4_and_a3_nb gw4_and_a3_nb 0 5e-14
cpar_gw4_and_a3_nx gw4_and_a3_nx 0 5e-14
cpar_gw4_and_a4_nb gw4_and_a4_nb 0 5e-14
cpar_gw4_and_a4_nx gw4_and_a4_nx 0 5e-14
cpar_gw4_and_a5_nb gw4_and_a5_nb 0 5e-14
cpar_gw4_and_a5_nx gw4_and_a5_nx 0 5e-14
cpar_gw4_and_a6_nb gw4_and_a6_nb 0 5e-14
cpar_gw4_and_a6_nx gw4_and_a6_nx 0 5e-14
cpar_gw4_and_a7_nb gw4_and_a7_nb 0 5e-14
cpar_gw4_and_a7_nx gw4_and_a7_nx 0 5e-14
cpar_gw4_and_a8_nb gw4_and_a8_nb 0 5e-14
cpar_gw4_and_a8_nx gw4_and_a8_nx 0 5e-14
cpar_gw4_and_g0 gw4_and_g0 0 5e-14
cpar_gw4_and_g1 gw4_and_g1 0 5e-14
cpar_gw4_and_g2 gw4_and_g2 0 5e-14
cpar_gw4_and_g3 gw4_and_g3 0 5e-14
cpar_gw4_and_g4 gw4_and_g4 0 5e-14
cpar_gw4_and_g5 gw4_and_g5 0 5e-14
cpar_gw4_and_g6 gw4_and_g6 0 5e-14
cpar_gw4_and_g7 gw4_and_g7 0 5e-14
cpar_gw4_and_g8 gw4_and_g8 0 5e-14
cpar_gw4_b1 gw4_b1 0 5e-14
cpar_gw4_b10 gw4_b10 0 5e-14
cpar_gw4_b10_n gw4_b10_n 0 5e-14
cpar_gw4_b10_q gw4_b10_q 0 5e-14
cpar_gw4_b10_t gw4_b10_t 0 5e-14
cpar_gw4_b1_n gw4_b1_n 0 5e-14
cpar_gw4_b1_q gw4_b1_q 0 5e-14
cpar_gw4_b1_t gw4_b1_t 0 5e-14
cpar_gw4_b2 gw4_b2 0 5e-14
cpar_gw4_b2_n gw4_b2_n 0 5e-14
cpar_gw4_b2_q gw4_b2_q 0 5e-14
cpar_gw4_b2_t gw4_b2_t 0 5e-14
cpar_gw4_b3 gw4_b3 0 5e-14
cpar_gw4_b3_n gw4_b3_n 0 5e-14
cpar_gw4_b3_q gw4_b3_q 0 5e-14
cpar_gw4_b3_t gw4_b3_t 0 5e-14
cpar_gw4_b4 gw4_b4 0 5e-14
cpar_gw4_b4_n gw4_b4_n 0 5e-14
cpar_gw4_b4_q gw4_b4_q 0 5e-14
cpar_gw4_b4_t gw4_b4_t 0 5e-14
cpar_gw4_b5 gw4_b5 0 5e-14
cpar_gw4_b5_n gw4_b5_n 0 5e-14
cpar_gw4_b5_q gw4_b5_q 0 5e-14
cpar_gw4_b5_t gw4_b5_t 0 5e-14
cpar_gw4_b6 gw4_b6 0 5e-14
cpar_gw4_b6_n gw4_b6_n 0 5e-14
cpar_gw4_b6_q gw4_b6_q 0 5e-14
cpar_gw4_b6_t gw4_b6_t 0 5e-14
cpar_gw4_b7 gw4_b7 0 5e-14
cpar_gw4_b7_n gw4_b7_n 0 5e-14
cpar_gw4_b7_q gw4_b7_q 0 5e-14
cpar_gw4_b7_t gw4_b7_t 0 5e-14
cpar_gw4_b8 gw4_b8 0 5e-14
cpar_gw4_b8_n gw4_b8_n 0 5e-14
cpar_gw4_b8_q gw4_b8_q 0 5e-14
cpar_gw4_b8_t gw4_b8_t 0 5e-14
cpar_gw4_b9 gw4_b9 0 5e-14
cpar_gw4_b9_n gw4_b9_n 0 5e-14
cpar_gw4_b9_q gw4_b9_q 0 5e-14
cpar_gw4_b9_t gw4_b9_t 0 5e-14
cpar_gw4_cin_cg gw4_cin_cg 0 5e-14
cpar_gw4_cin_ena gw4_cin_ena 0 5e-14
cpar_gw4_col_h gw4_col_h 0 5e-14
cpar_gw4_col_kd1 gw4_col_kd1 0 5e-14
cpar_gw4_col_knb gw4_col_knb 0 5e-14
cpar_gw4_col_ko1 gw4_col_ko1 0 5e-14
cpar_gw4_col_ktail gw4_col_ktail 0 5e-14
cpar_gw4_col_q gw4_col_q 0 5e-14
cpar_gw4_col_qb gw4_col_qb 0 5e-14
cpar_gw4_col_rec gw4_col_rec 0 5e-14
cpar_gw4_col_rt gw4_col_rt 0 5e-14
cpar_gw4_col_vm gw4_col_vm 0 5e-14
cpar_gw4_col_vmd gw4_col_vmd 0 5e-14
cpar_gw4_col_vms gw4_col_vms 0 5e-14
cpar_gw4_e10_h gw4_e10_h 0 5e-14
cpar_gw4_e10_kd1 gw4_e10_kd1 0 5e-14
cpar_gw4_e10_knb gw4_e10_knb 0 5e-14
cpar_gw4_e10_ko1 gw4_e10_ko1 0 5e-14
cpar_gw4_e10_ktail gw4_e10_ktail 0 5e-14
cpar_gw4_e10_q gw4_e10_q 0 5e-14
cpar_gw4_e10_qb gw4_e10_qb 0 5e-14
cpar_gw4_e10_rec gw4_e10_rec 0 5e-14
cpar_gw4_e10_rt gw4_e10_rt 0 5e-14
cpar_gw4_e10_vm gw4_e10_vm 0 5e-14
cpar_gw4_e10_vmd gw4_e10_vmd 0 5e-14
cpar_gw4_e10_vms gw4_e10_vms 0 5e-14
cpar_gw4_e1_h gw4_e1_h 0 5e-14
cpar_gw4_e1_kd1 gw4_e1_kd1 0 5e-14
cpar_gw4_e1_knb gw4_e1_knb 0 5e-14
cpar_gw4_e1_ko1 gw4_e1_ko1 0 5e-14
cpar_gw4_e1_ktail gw4_e1_ktail 0 5e-14
cpar_gw4_e1_q gw4_e1_q 0 5e-14
cpar_gw4_e1_qb gw4_e1_qb 0 5e-14
cpar_gw4_e1_rec gw4_e1_rec 0 5e-14
cpar_gw4_e1_rt gw4_e1_rt 0 5e-14
cpar_gw4_e1_vm gw4_e1_vm 0 5e-14
cpar_gw4_e1_vmd gw4_e1_vmd 0 5e-14
cpar_gw4_e1_vms gw4_e1_vms 0 5e-14
cpar_gw4_e2_h gw4_e2_h 0 5e-14
cpar_gw4_e2_kd1 gw4_e2_kd1 0 5e-14
cpar_gw4_e2_knb gw4_e2_knb 0 5e-14
cpar_gw4_e2_ko1 gw4_e2_ko1 0 5e-14
cpar_gw4_e2_ktail gw4_e2_ktail 0 5e-14
cpar_gw4_e2_q gw4_e2_q 0 5e-14
cpar_gw4_e2_qb gw4_e2_qb 0 5e-14
cpar_gw4_e2_rec gw4_e2_rec 0 5e-14
cpar_gw4_e2_rt gw4_e2_rt 0 5e-14
cpar_gw4_e2_vm gw4_e2_vm 0 5e-14
cpar_gw4_e2_vmd gw4_e2_vmd 0 5e-14
cpar_gw4_e2_vms gw4_e2_vms 0 5e-14
cpar_gw4_e3_h gw4_e3_h 0 5e-14
cpar_gw4_e3_kd1 gw4_e3_kd1 0 5e-14
cpar_gw4_e3_knb gw4_e3_knb 0 5e-14
cpar_gw4_e3_ko1 gw4_e3_ko1 0 5e-14
cpar_gw4_e3_ktail gw4_e3_ktail 0 5e-14
cpar_gw4_e3_q gw4_e3_q 0 5e-14
cpar_gw4_e3_qb gw4_e3_qb 0 5e-14
cpar_gw4_e3_rec gw4_e3_rec 0 5e-14
cpar_gw4_e3_rt gw4_e3_rt 0 5e-14
cpar_gw4_e3_vm gw4_e3_vm 0 5e-14
cpar_gw4_e3_vmd gw4_e3_vmd 0 5e-14
cpar_gw4_e3_vms gw4_e3_vms 0 5e-14
cpar_gw4_e4_h gw4_e4_h 0 5e-14
cpar_gw4_e4_kd1 gw4_e4_kd1 0 5e-14
cpar_gw4_e4_knb gw4_e4_knb 0 5e-14
cpar_gw4_e4_ko1 gw4_e4_ko1 0 5e-14
cpar_gw4_e4_ktail gw4_e4_ktail 0 5e-14
cpar_gw4_e4_q gw4_e4_q 0 5e-14
cpar_gw4_e4_qb gw4_e4_qb 0 5e-14
cpar_gw4_e4_rec gw4_e4_rec 0 5e-14
cpar_gw4_e4_rt gw4_e4_rt 0 5e-14
cpar_gw4_e4_vm gw4_e4_vm 0 5e-14
cpar_gw4_e4_vmd gw4_e4_vmd 0 5e-14
cpar_gw4_e4_vms gw4_e4_vms 0 5e-14
cpar_gw4_e5_h gw4_e5_h 0 5e-14
cpar_gw4_e5_kd1 gw4_e5_kd1 0 5e-14
cpar_gw4_e5_knb gw4_e5_knb 0 5e-14
cpar_gw4_e5_ko1 gw4_e5_ko1 0 5e-14
cpar_gw4_e5_ktail gw4_e5_ktail 0 5e-14
cpar_gw4_e5_q gw4_e5_q 0 5e-14
cpar_gw4_e5_qb gw4_e5_qb 0 5e-14
cpar_gw4_e5_rec gw4_e5_rec 0 5e-14
cpar_gw4_e5_rt gw4_e5_rt 0 5e-14
cpar_gw4_e5_vm gw4_e5_vm 0 5e-14
cpar_gw4_e5_vmd gw4_e5_vmd 0 5e-14
cpar_gw4_e5_vms gw4_e5_vms 0 5e-14
cpar_gw4_e6_h gw4_e6_h 0 5e-14
cpar_gw4_e6_kd1 gw4_e6_kd1 0 5e-14
cpar_gw4_e6_knb gw4_e6_knb 0 5e-14
cpar_gw4_e6_ko1 gw4_e6_ko1 0 5e-14
cpar_gw4_e6_ktail gw4_e6_ktail 0 5e-14
cpar_gw4_e6_q gw4_e6_q 0 5e-14
cpar_gw4_e6_qb gw4_e6_qb 0 5e-14
cpar_gw4_e6_rec gw4_e6_rec 0 5e-14
cpar_gw4_e6_rt gw4_e6_rt 0 5e-14
cpar_gw4_e6_vm gw4_e6_vm 0 5e-14
cpar_gw4_e6_vmd gw4_e6_vmd 0 5e-14
cpar_gw4_e6_vms gw4_e6_vms 0 5e-14
cpar_gw4_e7_h gw4_e7_h 0 5e-14
cpar_gw4_e7_kd1 gw4_e7_kd1 0 5e-14
cpar_gw4_e7_knb gw4_e7_knb 0 5e-14
cpar_gw4_e7_ko1 gw4_e7_ko1 0 5e-14
cpar_gw4_e7_ktail gw4_e7_ktail 0 5e-14
cpar_gw4_e7_q gw4_e7_q 0 5e-14
cpar_gw4_e7_qb gw4_e7_qb 0 5e-14
cpar_gw4_e7_rec gw4_e7_rec 0 5e-14
cpar_gw4_e7_rt gw4_e7_rt 0 5e-14
cpar_gw4_e7_vm gw4_e7_vm 0 5e-14
cpar_gw4_e7_vmd gw4_e7_vmd 0 5e-14
cpar_gw4_e7_vms gw4_e7_vms 0 5e-14
cpar_gw4_e8_h gw4_e8_h 0 5e-14
cpar_gw4_e8_kd1 gw4_e8_kd1 0 5e-14
cpar_gw4_e8_knb gw4_e8_knb 0 5e-14
cpar_gw4_e8_ko1 gw4_e8_ko1 0 5e-14
cpar_gw4_e8_ktail gw4_e8_ktail 0 5e-14
cpar_gw4_e8_q gw4_e8_q 0 5e-14
cpar_gw4_e8_qb gw4_e8_qb 0 5e-14
cpar_gw4_e8_rec gw4_e8_rec 0 5e-14
cpar_gw4_e8_rt gw4_e8_rt 0 5e-14
cpar_gw4_e8_vm gw4_e8_vm 0 5e-14
cpar_gw4_e8_vmd gw4_e8_vmd 0 5e-14
cpar_gw4_e8_vms gw4_e8_vms 0 5e-14
cpar_gw4_e9_h gw4_e9_h 0 5e-14
cpar_gw4_e9_kd1 gw4_e9_kd1 0 5e-14
cpar_gw4_e9_knb gw4_e9_knb 0 5e-14
cpar_gw4_e9_ko1 gw4_e9_ko1 0 5e-14
cpar_gw4_e9_ktail gw4_e9_ktail 0 5e-14
cpar_gw4_e9_q gw4_e9_q 0 5e-14
cpar_gw4_e9_qb gw4_e9_qb 0 5e-14
cpar_gw4_e9_rec gw4_e9_rec 0 5e-14
cpar_gw4_e9_rt gw4_e9_rt 0 5e-14
cpar_gw4_e9_vm gw4_e9_vm 0 5e-14
cpar_gw4_e9_vmd gw4_e9_vmd 0 5e-14
cpar_gw4_e9_vms gw4_e9_vms 0 5e-14
cpar_gw4_gb gw4_gb 0 5e-14
cpar_gw4_op_ad gw4_op_ad 0 5e-14
cpar_gw4_op_adn gw4_op_adn 0 5e-14
cpar_gw4_op_an gw4_op_an 0 5e-14
cpar_gw4_op_aq gw4_op_aq 0 5e-14
cpar_gw4_op_aqb gw4_op_aqb 0 5e-14
cpar_gw4_op_at gw4_op_at 0 5e-14
cpar_gw4_op_gx gw4_op_gx 0 5e-14
cpar_gw4_op_p gw4_op_p 0 5e-14
cpar_gw4_op_pb gw4_op_pb 0 5e-14
cpar_gw4_op_tt gw4_op_tt 0 5e-14
cpar_hc1 hc1 0 5e-14
cpar_hc2 hc2 0 5e-14
cpar_hc3 hc3 0 5e-14
cpar_hc4 hc4 0 5e-14
cpar_hsc1_h1 hsc1_h1 0 5e-14
cpar_hsc1_sd hsc1_sd 0 5e-14
cpar_hsc2_h1 hsc2_h1 0 5e-14
cpar_hsc2_sd hsc2_sd 0 5e-14
cpar_hsc3_h1 hsc3_h1 0 5e-14
cpar_hsc3_sd hsc3_sd 0 5e-14
cpar_hsc4_h1 hsc4_h1 0 5e-14
cpar_hsc4_sd hsc4_sd 0 5e-14
cpar_hsw1_h1 hsw1_h1 0 5e-14
cpar_hsw1_sd hsw1_sd 0 5e-14
cpar_hsw2_h1 hsw2_h1 0 5e-14
cpar_hsw2_sd hsw2_sd 0 5e-14
cpar_hsw3_h1 hsw3_h1 0 5e-14
cpar_hsw3_sd hsw3_sd 0 5e-14
cpar_hsw4_h1 hsw4_h1 0 5e-14
cpar_hsw4_sd hsw4_sd 0 5e-14
cpar_hw1 hw1 0 5e-14
cpar_hw2 hw2 0 5e-14
cpar_hw3 hw3 0 5e-14
cpar_hw4 hw4 0 5e-14
cpar_ilim_n ilim_n 0 5e-14
cpar_ilimp_n ilimp_n 0 5e-14
cpar_iref_n iref_n 0 5e-14
cpar_irefp_n irefp_n 0 5e-14
cpar_istep_n istep_n 0 5e-14
cpar_load_neg load_neg 0 5e-14
cpar_load_pos load_pos 0 5e-14
cpar_por_hold por_hold 0 5e-14
cpar_por_ok por_ok 0 5e-14
cpar_porc porc 0 5e-14
cpar_porx porx 0 5e-14
cpar_s1_anb s1_anb 0 5e-14
cpar_s1_atl s1_atl 0 5e-14
cpar_s1_da s1_da 0 5e-14
cpar_s1_db s1_db 0 5e-14
cpar_s1_m s1_m 0 5e-14
cpar_s1_s s1_s 0 5e-14
cpar_s1_tl s1_tl 0 5e-14
cpar_s1_ya s1_ya 0 5e-14
cpar_s1_yb s1_yb 0 5e-14
cpar_s1_za s1_za 0 5e-14
cpar_s1_zb s1_zb 0 5e-14
cpar_s2_anb s2_anb 0 5e-14
cpar_s2_atl s2_atl 0 5e-14
cpar_s2_da s2_da 0 5e-14
cpar_s2_db s2_db 0 5e-14
cpar_s2_m s2_m 0 5e-14
cpar_s2_s s2_s 0 5e-14
cpar_s2_tl s2_tl 0 5e-14
cpar_s2_ya s2_ya 0 5e-14
cpar_s2_yb s2_yb 0 5e-14
cpar_s2_za s2_za 0 5e-14
cpar_s2_zb s2_zb 0 5e-14
cpar_s3_anb s3_anb 0 5e-14
cpar_s3_atl s3_atl 0 5e-14
cpar_s3_da s3_da 0 5e-14
cpar_s3_db s3_db 0 5e-14
cpar_s3_m s3_m 0 5e-14
cpar_s3_s s3_s 0 5e-14
cpar_s3_tl s3_tl 0 5e-14
cpar_s3_ya s3_ya 0 5e-14
cpar_s3_yb s3_yb 0 5e-14
cpar_s3_za s3_za 0 5e-14
cpar_s3_zb s3_zb 0 5e-14
cpar_s4_anb s4_anb 0 5e-14
cpar_s4_atl s4_atl 0 5e-14
cpar_s4_da s4_da 0 5e-14
cpar_s4_db s4_db 0 5e-14
cpar_s4_m s4_m 0 5e-14
cpar_s4_s s4_s 0 5e-14
cpar_s4_tl s4_tl 0 5e-14
cpar_s4_ya s4_ya 0 5e-14
cpar_s4_yb s4_yb 0 5e-14
cpar_s4_za s4_za 0 5e-14
cpar_s4_zb s4_zb 0 5e-14
cpar_sgc12f_h sgc12f_h 0 5e-14
cpar_sgc12f_kd1 sgc12f_kd1 0 5e-14
cpar_sgc12f_knb sgc12f_knb 0 5e-14
cpar_sgc12f_ko1 sgc12f_ko1 0 5e-14
cpar_sgc12f_ktail sgc12f_ktail 0 5e-14
cpar_sgc12f_op_ad sgc12f_op_ad 0 5e-14
cpar_sgc12f_op_adn sgc12f_op_adn 0 5e-14
cpar_sgc12f_op_an sgc12f_op_an 0 5e-14
cpar_sgc12f_op_aq sgc12f_op_aq 0 5e-14
cpar_sgc12f_op_aqb sgc12f_op_aqb 0 5e-14
cpar_sgc12f_op_at sgc12f_op_at 0 5e-14
cpar_sgc12f_op_gx sgc12f_op_gx 0 5e-14
cpar_sgc12f_op_p sgc12f_op_p 0 5e-14
cpar_sgc12f_op_pb sgc12f_op_pb 0 5e-14
cpar_sgc12f_op_tt sgc12f_op_tt 0 5e-14
cpar_sgc12f_ota_d1 sgc12f_ota_d1 0 5e-14
cpar_sgc12f_ota_nb sgc12f_ota_nb 0 5e-14
cpar_sgc12f_ota_tail sgc12f_ota_tail 0 5e-14
cpar_sgc12f_q sgc12f_q 0 5e-14
cpar_sgc12f_qb sgc12f_qb 0 5e-14
cpar_sgc12f_rec sgc12f_rec 0 5e-14
cpar_sgc12f_rt sgc12f_rt 0 5e-14
cpar_sgc12f_vm sgc12f_vm 0 5e-14
cpar_sgc12f_vmd sgc12f_vmd 0 5e-14
cpar_sgc12f_vms sgc12f_vms 0 5e-14
cpar_sgc12r_h sgc12r_h 0 5e-14
cpar_sgc12r_kd1 sgc12r_kd1 0 5e-14
cpar_sgc12r_knb sgc12r_knb 0 5e-14
cpar_sgc12r_ko1 sgc12r_ko1 0 5e-14
cpar_sgc12r_ktail sgc12r_ktail 0 5e-14
cpar_sgc12r_op_ad sgc12r_op_ad 0 5e-14
cpar_sgc12r_op_adn sgc12r_op_adn 0 5e-14
cpar_sgc12r_op_an sgc12r_op_an 0 5e-14
cpar_sgc12r_op_aq sgc12r_op_aq 0 5e-14
cpar_sgc12r_op_aqb sgc12r_op_aqb 0 5e-14
cpar_sgc12r_op_at sgc12r_op_at 0 5e-14
cpar_sgc12r_op_gx sgc12r_op_gx 0 5e-14
cpar_sgc12r_op_p sgc12r_op_p 0 5e-14
cpar_sgc12r_op_pb sgc12r_op_pb 0 5e-14
cpar_sgc12r_op_tt sgc12r_op_tt 0 5e-14
cpar_sgc12r_ota_d1 sgc12r_ota_d1 0 5e-14
cpar_sgc12r_ota_nb sgc12r_ota_nb 0 5e-14
cpar_sgc12r_ota_tail sgc12r_ota_tail 0 5e-14
cpar_sgc12r_q sgc12r_q 0 5e-14
cpar_sgc12r_qb sgc12r_qb 0 5e-14
cpar_sgc12r_rec sgc12r_rec 0 5e-14
cpar_sgc12r_rt sgc12r_rt 0 5e-14
cpar_sgc12r_vm sgc12r_vm 0 5e-14
cpar_sgc12r_vmd sgc12r_vmd 0 5e-14
cpar_sgc12r_vms sgc12r_vms 0 5e-14
cpar_sgc23f_h sgc23f_h 0 5e-14
cpar_sgc23f_kd1 sgc23f_kd1 0 5e-14
cpar_sgc23f_knb sgc23f_knb 0 5e-14
cpar_sgc23f_ko1 sgc23f_ko1 0 5e-14
cpar_sgc23f_ktail sgc23f_ktail 0 5e-14
cpar_sgc23f_op_ad sgc23f_op_ad 0 5e-14
cpar_sgc23f_op_adn sgc23f_op_adn 0 5e-14
cpar_sgc23f_op_an sgc23f_op_an 0 5e-14
cpar_sgc23f_op_aq sgc23f_op_aq 0 5e-14
cpar_sgc23f_op_aqb sgc23f_op_aqb 0 5e-14
cpar_sgc23f_op_at sgc23f_op_at 0 5e-14
cpar_sgc23f_op_gx sgc23f_op_gx 0 5e-14
cpar_sgc23f_op_p sgc23f_op_p 0 5e-14
cpar_sgc23f_op_pb sgc23f_op_pb 0 5e-14
cpar_sgc23f_op_tt sgc23f_op_tt 0 5e-14
cpar_sgc23f_ota_d1 sgc23f_ota_d1 0 5e-14
cpar_sgc23f_ota_nb sgc23f_ota_nb 0 5e-14
cpar_sgc23f_ota_tail sgc23f_ota_tail 0 5e-14
cpar_sgc23f_q sgc23f_q 0 5e-14
cpar_sgc23f_qb sgc23f_qb 0 5e-14
cpar_sgc23f_rec sgc23f_rec 0 5e-14
cpar_sgc23f_rt sgc23f_rt 0 5e-14
cpar_sgc23f_vm sgc23f_vm 0 5e-14
cpar_sgc23f_vmd sgc23f_vmd 0 5e-14
cpar_sgc23f_vms sgc23f_vms 0 5e-14
cpar_sgc23r_h sgc23r_h 0 5e-14
cpar_sgc23r_kd1 sgc23r_kd1 0 5e-14
cpar_sgc23r_knb sgc23r_knb 0 5e-14
cpar_sgc23r_ko1 sgc23r_ko1 0 5e-14
cpar_sgc23r_ktail sgc23r_ktail 0 5e-14
cpar_sgc23r_op_ad sgc23r_op_ad 0 5e-14
cpar_sgc23r_op_adn sgc23r_op_adn 0 5e-14
cpar_sgc23r_op_an sgc23r_op_an 0 5e-14
cpar_sgc23r_op_aq sgc23r_op_aq 0 5e-14
cpar_sgc23r_op_aqb sgc23r_op_aqb 0 5e-14
cpar_sgc23r_op_at sgc23r_op_at 0 5e-14
cpar_sgc23r_op_gx sgc23r_op_gx 0 5e-14
cpar_sgc23r_op_p sgc23r_op_p 0 5e-14
cpar_sgc23r_op_pb sgc23r_op_pb 0 5e-14
cpar_sgc23r_op_tt sgc23r_op_tt 0 5e-14
cpar_sgc23r_ota_d1 sgc23r_ota_d1 0 5e-14
cpar_sgc23r_ota_nb sgc23r_ota_nb 0 5e-14
cpar_sgc23r_ota_tail sgc23r_ota_tail 0 5e-14
cpar_sgc23r_q sgc23r_q 0 5e-14
cpar_sgc23r_qb sgc23r_qb 0 5e-14
cpar_sgc23r_rec sgc23r_rec 0 5e-14
cpar_sgc23r_rt sgc23r_rt 0 5e-14
cpar_sgc23r_vm sgc23r_vm 0 5e-14
cpar_sgc23r_vmd sgc23r_vmd 0 5e-14
cpar_sgc23r_vms sgc23r_vms 0 5e-14
cpar_sgc34f_h sgc34f_h 0 5e-14
cpar_sgc34f_kd1 sgc34f_kd1 0 5e-14
cpar_sgc34f_knb sgc34f_knb 0 5e-14
cpar_sgc34f_ko1 sgc34f_ko1 0 5e-14
cpar_sgc34f_ktail sgc34f_ktail 0 5e-14
cpar_sgc34f_op_ad sgc34f_op_ad 0 5e-14
cpar_sgc34f_op_adn sgc34f_op_adn 0 5e-14
cpar_sgc34f_op_an sgc34f_op_an 0 5e-14
cpar_sgc34f_op_aq sgc34f_op_aq 0 5e-14
cpar_sgc34f_op_aqb sgc34f_op_aqb 0 5e-14
cpar_sgc34f_op_at sgc34f_op_at 0 5e-14
cpar_sgc34f_op_gx sgc34f_op_gx 0 5e-14
cpar_sgc34f_op_p sgc34f_op_p 0 5e-14
cpar_sgc34f_op_pb sgc34f_op_pb 0 5e-14
cpar_sgc34f_op_tt sgc34f_op_tt 0 5e-14
cpar_sgc34f_ota_d1 sgc34f_ota_d1 0 5e-14
cpar_sgc34f_ota_nb sgc34f_ota_nb 0 5e-14
cpar_sgc34f_ota_tail sgc34f_ota_tail 0 5e-14
cpar_sgc34f_q sgc34f_q 0 5e-14
cpar_sgc34f_qb sgc34f_qb 0 5e-14
cpar_sgc34f_rec sgc34f_rec 0 5e-14
cpar_sgc34f_rt sgc34f_rt 0 5e-14
cpar_sgc34f_vm sgc34f_vm 0 5e-14
cpar_sgc34f_vmd sgc34f_vmd 0 5e-14
cpar_sgc34f_vms sgc34f_vms 0 5e-14
cpar_sgc34r_h sgc34r_h 0 5e-14
cpar_sgc34r_kd1 sgc34r_kd1 0 5e-14
cpar_sgc34r_knb sgc34r_knb 0 5e-14
cpar_sgc34r_ko1 sgc34r_ko1 0 5e-14
cpar_sgc34r_ktail sgc34r_ktail 0 5e-14
cpar_sgc34r_op_ad sgc34r_op_ad 0 5e-14
cpar_sgc34r_op_adn sgc34r_op_adn 0 5e-14
cpar_sgc34r_op_an sgc34r_op_an 0 5e-14
cpar_sgc34r_op_aq sgc34r_op_aq 0 5e-14
cpar_sgc34r_op_aqb sgc34r_op_aqb 0 5e-14
cpar_sgc34r_op_at sgc34r_op_at 0 5e-14
cpar_sgc34r_op_gx sgc34r_op_gx 0 5e-14
cpar_sgc34r_op_p sgc34r_op_p 0 5e-14
cpar_sgc34r_op_pb sgc34r_op_pb 0 5e-14
cpar_sgc34r_op_tt sgc34r_op_tt 0 5e-14
cpar_sgc34r_ota_d1 sgc34r_ota_d1 0 5e-14
cpar_sgc34r_ota_nb sgc34r_ota_nb 0 5e-14
cpar_sgc34r_ota_tail sgc34r_ota_tail 0 5e-14
cpar_sgc34r_q sgc34r_q 0 5e-14
cpar_sgc34r_qb sgc34r_qb 0 5e-14
cpar_sgc34r_rec sgc34r_rec 0 5e-14
cpar_sgc34r_rt sgc34r_rt 0 5e-14
cpar_sgc34r_vm sgc34r_vm 0 5e-14
cpar_sgc34r_vmd sgc34r_vmd 0 5e-14
cpar_sgc34r_vms sgc34r_vms 0 5e-14
cpar_sgw12f_h sgw12f_h 0 5e-14
cpar_sgw12f_kd1 sgw12f_kd1 0 5e-14
cpar_sgw12f_knb sgw12f_knb 0 5e-14
cpar_sgw12f_ko1 sgw12f_ko1 0 5e-14
cpar_sgw12f_ktail sgw12f_ktail 0 5e-14
cpar_sgw12f_op_ad sgw12f_op_ad 0 5e-14
cpar_sgw12f_op_adn sgw12f_op_adn 0 5e-14
cpar_sgw12f_op_an sgw12f_op_an 0 5e-14
cpar_sgw12f_op_aq sgw12f_op_aq 0 5e-14
cpar_sgw12f_op_aqb sgw12f_op_aqb 0 5e-14
cpar_sgw12f_op_at sgw12f_op_at 0 5e-14
cpar_sgw12f_op_gx sgw12f_op_gx 0 5e-14
cpar_sgw12f_op_p sgw12f_op_p 0 5e-14
cpar_sgw12f_op_pb sgw12f_op_pb 0 5e-14
cpar_sgw12f_op_tt sgw12f_op_tt 0 5e-14
cpar_sgw12f_ota_d1 sgw12f_ota_d1 0 5e-14
cpar_sgw12f_ota_nb sgw12f_ota_nb 0 5e-14
cpar_sgw12f_ota_tail sgw12f_ota_tail 0 5e-14
cpar_sgw12f_q sgw12f_q 0 5e-14
cpar_sgw12f_qb sgw12f_qb 0 5e-14
cpar_sgw12f_rec sgw12f_rec 0 5e-14
cpar_sgw12f_rt sgw12f_rt 0 5e-14
cpar_sgw12f_vm sgw12f_vm 0 5e-14
cpar_sgw12f_vmd sgw12f_vmd 0 5e-14
cpar_sgw12f_vms sgw12f_vms 0 5e-14
cpar_sgw12r_h sgw12r_h 0 5e-14
cpar_sgw12r_kd1 sgw12r_kd1 0 5e-14
cpar_sgw12r_knb sgw12r_knb 0 5e-14
cpar_sgw12r_ko1 sgw12r_ko1 0 5e-14
cpar_sgw12r_ktail sgw12r_ktail 0 5e-14
cpar_sgw12r_op_ad sgw12r_op_ad 0 5e-14
cpar_sgw12r_op_adn sgw12r_op_adn 0 5e-14
cpar_sgw12r_op_an sgw12r_op_an 0 5e-14
cpar_sgw12r_op_aq sgw12r_op_aq 0 5e-14
cpar_sgw12r_op_aqb sgw12r_op_aqb 0 5e-14
cpar_sgw12r_op_at sgw12r_op_at 0 5e-14
cpar_sgw12r_op_gx sgw12r_op_gx 0 5e-14
cpar_sgw12r_op_p sgw12r_op_p 0 5e-14
cpar_sgw12r_op_pb sgw12r_op_pb 0 5e-14
cpar_sgw12r_op_tt sgw12r_op_tt 0 5e-14
cpar_sgw12r_ota_d1 sgw12r_ota_d1 0 5e-14
cpar_sgw12r_ota_nb sgw12r_ota_nb 0 5e-14
cpar_sgw12r_ota_tail sgw12r_ota_tail 0 5e-14
cpar_sgw12r_q sgw12r_q 0 5e-14
cpar_sgw12r_qb sgw12r_qb 0 5e-14
cpar_sgw12r_rec sgw12r_rec 0 5e-14
cpar_sgw12r_rt sgw12r_rt 0 5e-14
cpar_sgw12r_vm sgw12r_vm 0 5e-14
cpar_sgw12r_vmd sgw12r_vmd 0 5e-14
cpar_sgw12r_vms sgw12r_vms 0 5e-14
cpar_sgw23f_h sgw23f_h 0 5e-14
cpar_sgw23f_kd1 sgw23f_kd1 0 5e-14
cpar_sgw23f_knb sgw23f_knb 0 5e-14
cpar_sgw23f_ko1 sgw23f_ko1 0 5e-14
cpar_sgw23f_ktail sgw23f_ktail 0 5e-14
cpar_sgw23f_op_ad sgw23f_op_ad 0 5e-14
cpar_sgw23f_op_adn sgw23f_op_adn 0 5e-14
cpar_sgw23f_op_an sgw23f_op_an 0 5e-14
cpar_sgw23f_op_aq sgw23f_op_aq 0 5e-14
cpar_sgw23f_op_aqb sgw23f_op_aqb 0 5e-14
cpar_sgw23f_op_at sgw23f_op_at 0 5e-14
cpar_sgw23f_op_gx sgw23f_op_gx 0 5e-14
cpar_sgw23f_op_p sgw23f_op_p 0 5e-14
cpar_sgw23f_op_pb sgw23f_op_pb 0 5e-14
cpar_sgw23f_op_tt sgw23f_op_tt 0 5e-14
cpar_sgw23f_ota_d1 sgw23f_ota_d1 0 5e-14
cpar_sgw23f_ota_nb sgw23f_ota_nb 0 5e-14
cpar_sgw23f_ota_tail sgw23f_ota_tail 0 5e-14
cpar_sgw23f_q sgw23f_q 0 5e-14
cpar_sgw23f_qb sgw23f_qb 0 5e-14
cpar_sgw23f_rec sgw23f_rec 0 5e-14
cpar_sgw23f_rt sgw23f_rt 0 5e-14
cpar_sgw23f_vm sgw23f_vm 0 5e-14
cpar_sgw23f_vmd sgw23f_vmd 0 5e-14
cpar_sgw23f_vms sgw23f_vms 0 5e-14
cpar_sgw23r_h sgw23r_h 0 5e-14
cpar_sgw23r_kd1 sgw23r_kd1 0 5e-14
cpar_sgw23r_knb sgw23r_knb 0 5e-14
cpar_sgw23r_ko1 sgw23r_ko1 0 5e-14
cpar_sgw23r_ktail sgw23r_ktail 0 5e-14
cpar_sgw23r_op_ad sgw23r_op_ad 0 5e-14
cpar_sgw23r_op_adn sgw23r_op_adn 0 5e-14
cpar_sgw23r_op_an sgw23r_op_an 0 5e-14
cpar_sgw23r_op_aq sgw23r_op_aq 0 5e-14
cpar_sgw23r_op_aqb sgw23r_op_aqb 0 5e-14
cpar_sgw23r_op_at sgw23r_op_at 0 5e-14
cpar_sgw23r_op_gx sgw23r_op_gx 0 5e-14
cpar_sgw23r_op_p sgw23r_op_p 0 5e-14
cpar_sgw23r_op_pb sgw23r_op_pb 0 5e-14
cpar_sgw23r_op_tt sgw23r_op_tt 0 5e-14
cpar_sgw23r_ota_d1 sgw23r_ota_d1 0 5e-14
cpar_sgw23r_ota_nb sgw23r_ota_nb 0 5e-14
cpar_sgw23r_ota_tail sgw23r_ota_tail 0 5e-14
cpar_sgw23r_q sgw23r_q 0 5e-14
cpar_sgw23r_qb sgw23r_qb 0 5e-14
cpar_sgw23r_rec sgw23r_rec 0 5e-14
cpar_sgw23r_rt sgw23r_rt 0 5e-14
cpar_sgw23r_vm sgw23r_vm 0 5e-14
cpar_sgw23r_vmd sgw23r_vmd 0 5e-14
cpar_sgw23r_vms sgw23r_vms 0 5e-14
cpar_sgw34f_h sgw34f_h 0 5e-14
cpar_sgw34f_kd1 sgw34f_kd1 0 5e-14
cpar_sgw34f_knb sgw34f_knb 0 5e-14
cpar_sgw34f_ko1 sgw34f_ko1 0 5e-14
cpar_sgw34f_ktail sgw34f_ktail 0 5e-14
cpar_sgw34f_op_ad sgw34f_op_ad 0 5e-14
cpar_sgw34f_op_adn sgw34f_op_adn 0 5e-14
cpar_sgw34f_op_an sgw34f_op_an 0 5e-14
cpar_sgw34f_op_aq sgw34f_op_aq 0 5e-14
cpar_sgw34f_op_aqb sgw34f_op_aqb 0 5e-14
cpar_sgw34f_op_at sgw34f_op_at 0 5e-14
cpar_sgw34f_op_gx sgw34f_op_gx 0 5e-14
cpar_sgw34f_op_p sgw34f_op_p 0 5e-14
cpar_sgw34f_op_pb sgw34f_op_pb 0 5e-14
cpar_sgw34f_op_tt sgw34f_op_tt 0 5e-14
cpar_sgw34f_ota_d1 sgw34f_ota_d1 0 5e-14
cpar_sgw34f_ota_nb sgw34f_ota_nb 0 5e-14
cpar_sgw34f_ota_tail sgw34f_ota_tail 0 5e-14
cpar_sgw34f_q sgw34f_q 0 5e-14
cpar_sgw34f_qb sgw34f_qb 0 5e-14
cpar_sgw34f_rec sgw34f_rec 0 5e-14
cpar_sgw34f_rt sgw34f_rt 0 5e-14
cpar_sgw34f_vm sgw34f_vm 0 5e-14
cpar_sgw34f_vmd sgw34f_vmd 0 5e-14
cpar_sgw34f_vms sgw34f_vms 0 5e-14
cpar_sgw34r_h sgw34r_h 0 5e-14
cpar_sgw34r_kd1 sgw34r_kd1 0 5e-14
cpar_sgw34r_knb sgw34r_knb 0 5e-14
cpar_sgw34r_ko1 sgw34r_ko1 0 5e-14
cpar_sgw34r_ktail sgw34r_ktail 0 5e-14
cpar_sgw34r_op_ad sgw34r_op_ad 0 5e-14
cpar_sgw34r_op_adn sgw34r_op_adn 0 5e-14
cpar_sgw34r_op_an sgw34r_op_an 0 5e-14
cpar_sgw34r_op_aq sgw34r_op_aq 0 5e-14
cpar_sgw34r_op_aqb sgw34r_op_aqb 0 5e-14
cpar_sgw34r_op_at sgw34r_op_at 0 5e-14
cpar_sgw34r_op_gx sgw34r_op_gx 0 5e-14
cpar_sgw34r_op_p sgw34r_op_p 0 5e-14
cpar_sgw34r_op_pb sgw34r_op_pb 0 5e-14
cpar_sgw34r_op_tt sgw34r_op_tt 0 5e-14
cpar_sgw34r_ota_d1 sgw34r_ota_d1 0 5e-14
cpar_sgw34r_ota_nb sgw34r_ota_nb 0 5e-14
cpar_sgw34r_ota_tail sgw34r_ota_tail 0 5e-14
cpar_sgw34r_q sgw34r_q 0 5e-14
cpar_sgw34r_qb sgw34r_qb 0 5e-14
cpar_sgw34r_rec sgw34r_rec 0 5e-14
cpar_sgw34r_rt sgw34r_rt 0 5e-14
cpar_sgw34r_vm sgw34r_vm 0 5e-14
cpar_sgw34r_vmd sgw34r_vmd 0 5e-14
cpar_sgw34r_vms sgw34r_vms 0 5e-14
cpar_spc1 spc1 0 5e-14
cpar_spc2 spc2 0 5e-14
cpar_spc3 spc3 0 5e-14
cpar_spc4 spc4 0 5e-14
cpar_spci1_cg spci1_cg 0 5e-14
cpar_spci1_ena spci1_ena 0 5e-14
cpar_spci2_cg spci2_cg 0 5e-14
cpar_spci2_ena spci2_ena 0 5e-14
cpar_spci3_cg spci3_cg 0 5e-14
cpar_spci3_ena spci3_ena 0 5e-14
cpar_spci4_cg spci4_cg 0 5e-14
cpar_spci4_ena spci4_ena 0 5e-14
cpar_spcs12 spcs12 0 5e-14
cpar_spcs23 spcs23 0 5e-14
cpar_spcs34 spcs34 0 5e-14
cpar_spw1 spw1 0 5e-14
cpar_spw2 spw2 0 5e-14
cpar_spw3 spw3 0 5e-14
cpar_spw4 spw4 0 5e-14
cpar_spwi1_cg spwi1_cg 0 5e-14
cpar_spwi1_ena spwi1_ena 0 5e-14
cpar_spwi2_cg spwi2_cg 0 5e-14
cpar_spwi2_ena spwi2_ena 0 5e-14
cpar_spwi3_cg spwi3_cg 0 5e-14
cpar_spwi3_ena spwi3_ena 0 5e-14
cpar_spwi4_cg spwi4_cg 0 5e-14
cpar_spwi4_ena spwi4_ena 0 5e-14
cpar_spws12 spws12 0 5e-14
cpar_spws23 spws23 0 5e-14
cpar_spws34 spws34 0 5e-14
cpar_thc12f_h thc12f_h 0 5e-14
cpar_thc12f_kd1 thc12f_kd1 0 5e-14
cpar_thc12f_knb thc12f_knb 0 5e-14
cpar_thc12f_ko1 thc12f_ko1 0 5e-14
cpar_thc12f_ktail thc12f_ktail 0 5e-14
cpar_thc12f_mi thc12f_mi 0 5e-14
cpar_thc12f_op_ad thc12f_op_ad 0 5e-14
cpar_thc12f_op_adn thc12f_op_adn 0 5e-14
cpar_thc12f_op_an thc12f_op_an 0 5e-14
cpar_thc12f_op_aq thc12f_op_aq 0 5e-14
cpar_thc12f_op_aqb thc12f_op_aqb 0 5e-14
cpar_thc12f_op_at thc12f_op_at 0 5e-14
cpar_thc12f_op_gx thc12f_op_gx 0 5e-14
cpar_thc12f_op_p thc12f_op_p 0 5e-14
cpar_thc12f_op_pb thc12f_op_pb 0 5e-14
cpar_thc12f_op_tt thc12f_op_tt 0 5e-14
cpar_thc12f_q thc12f_q 0 5e-14
cpar_thc12f_qb thc12f_qb 0 5e-14
cpar_thc12f_rec thc12f_rec 0 5e-14
cpar_thc12f_rt thc12f_rt 0 5e-14
cpar_thc12f_st_x thc12f_st_x 0 5e-14
cpar_thc12f_vm thc12f_vm 0 5e-14
cpar_thc12f_vmd thc12f_vmd 0 5e-14
cpar_thc12f_vms thc12f_vms 0 5e-14
cpar_thc12r_h thc12r_h 0 5e-14
cpar_thc12r_kd1 thc12r_kd1 0 5e-14
cpar_thc12r_knb thc12r_knb 0 5e-14
cpar_thc12r_ko1 thc12r_ko1 0 5e-14
cpar_thc12r_ktail thc12r_ktail 0 5e-14
cpar_thc12r_mi thc12r_mi 0 5e-14
cpar_thc12r_op_ad thc12r_op_ad 0 5e-14
cpar_thc12r_op_adn thc12r_op_adn 0 5e-14
cpar_thc12r_op_an thc12r_op_an 0 5e-14
cpar_thc12r_op_aq thc12r_op_aq 0 5e-14
cpar_thc12r_op_aqb thc12r_op_aqb 0 5e-14
cpar_thc12r_op_at thc12r_op_at 0 5e-14
cpar_thc12r_op_gx thc12r_op_gx 0 5e-14
cpar_thc12r_op_p thc12r_op_p 0 5e-14
cpar_thc12r_op_pb thc12r_op_pb 0 5e-14
cpar_thc12r_op_tt thc12r_op_tt 0 5e-14
cpar_thc12r_q thc12r_q 0 5e-14
cpar_thc12r_qb thc12r_qb 0 5e-14
cpar_thc12r_rec thc12r_rec 0 5e-14
cpar_thc12r_rt thc12r_rt 0 5e-14
cpar_thc12r_st_x thc12r_st_x 0 5e-14
cpar_thc12r_vm thc12r_vm 0 5e-14
cpar_thc12r_vmd thc12r_vmd 0 5e-14
cpar_thc12r_vms thc12r_vms 0 5e-14
cpar_thc23f_h thc23f_h 0 5e-14
cpar_thc23f_kd1 thc23f_kd1 0 5e-14
cpar_thc23f_knb thc23f_knb 0 5e-14
cpar_thc23f_ko1 thc23f_ko1 0 5e-14
cpar_thc23f_ktail thc23f_ktail 0 5e-14
cpar_thc23f_mi thc23f_mi 0 5e-14
cpar_thc23f_op_ad thc23f_op_ad 0 5e-14
cpar_thc23f_op_adn thc23f_op_adn 0 5e-14
cpar_thc23f_op_an thc23f_op_an 0 5e-14
cpar_thc23f_op_aq thc23f_op_aq 0 5e-14
cpar_thc23f_op_aqb thc23f_op_aqb 0 5e-14
cpar_thc23f_op_at thc23f_op_at 0 5e-14
cpar_thc23f_op_gx thc23f_op_gx 0 5e-14
cpar_thc23f_op_p thc23f_op_p 0 5e-14
cpar_thc23f_op_pb thc23f_op_pb 0 5e-14
cpar_thc23f_op_tt thc23f_op_tt 0 5e-14
cpar_thc23f_q thc23f_q 0 5e-14
cpar_thc23f_qb thc23f_qb 0 5e-14
cpar_thc23f_rec thc23f_rec 0 5e-14
cpar_thc23f_rt thc23f_rt 0 5e-14
cpar_thc23f_st_x thc23f_st_x 0 5e-14
cpar_thc23f_vm thc23f_vm 0 5e-14
cpar_thc23f_vmd thc23f_vmd 0 5e-14
cpar_thc23f_vms thc23f_vms 0 5e-14
cpar_thc23r_h thc23r_h 0 5e-14
cpar_thc23r_kd1 thc23r_kd1 0 5e-14
cpar_thc23r_knb thc23r_knb 0 5e-14
cpar_thc23r_ko1 thc23r_ko1 0 5e-14
cpar_thc23r_ktail thc23r_ktail 0 5e-14
cpar_thc23r_mi thc23r_mi 0 5e-14
cpar_thc23r_op_ad thc23r_op_ad 0 5e-14
cpar_thc23r_op_adn thc23r_op_adn 0 5e-14
cpar_thc23r_op_an thc23r_op_an 0 5e-14
cpar_thc23r_op_aq thc23r_op_aq 0 5e-14
cpar_thc23r_op_aqb thc23r_op_aqb 0 5e-14
cpar_thc23r_op_at thc23r_op_at 0 5e-14
cpar_thc23r_op_gx thc23r_op_gx 0 5e-14
cpar_thc23r_op_p thc23r_op_p 0 5e-14
cpar_thc23r_op_pb thc23r_op_pb 0 5e-14
cpar_thc23r_op_tt thc23r_op_tt 0 5e-14
cpar_thc23r_q thc23r_q 0 5e-14
cpar_thc23r_qb thc23r_qb 0 5e-14
cpar_thc23r_rec thc23r_rec 0 5e-14
cpar_thc23r_rt thc23r_rt 0 5e-14
cpar_thc23r_st_x thc23r_st_x 0 5e-14
cpar_thc23r_vm thc23r_vm 0 5e-14
cpar_thc23r_vmd thc23r_vmd 0 5e-14
cpar_thc23r_vms thc23r_vms 0 5e-14
cpar_thc34f_h thc34f_h 0 5e-14
cpar_thc34f_kd1 thc34f_kd1 0 5e-14
cpar_thc34f_knb thc34f_knb 0 5e-14
cpar_thc34f_ko1 thc34f_ko1 0 5e-14
cpar_thc34f_ktail thc34f_ktail 0 5e-14
cpar_thc34f_mi thc34f_mi 0 5e-14
cpar_thc34f_op_ad thc34f_op_ad 0 5e-14
cpar_thc34f_op_adn thc34f_op_adn 0 5e-14
cpar_thc34f_op_an thc34f_op_an 0 5e-14
cpar_thc34f_op_aq thc34f_op_aq 0 5e-14
cpar_thc34f_op_aqb thc34f_op_aqb 0 5e-14
cpar_thc34f_op_at thc34f_op_at 0 5e-14
cpar_thc34f_op_gx thc34f_op_gx 0 5e-14
cpar_thc34f_op_p thc34f_op_p 0 5e-14
cpar_thc34f_op_pb thc34f_op_pb 0 5e-14
cpar_thc34f_op_tt thc34f_op_tt 0 5e-14
cpar_thc34f_q thc34f_q 0 5e-14
cpar_thc34f_qb thc34f_qb 0 5e-14
cpar_thc34f_rec thc34f_rec 0 5e-14
cpar_thc34f_rt thc34f_rt 0 5e-14
cpar_thc34f_st_x thc34f_st_x 0 5e-14
cpar_thc34f_vm thc34f_vm 0 5e-14
cpar_thc34f_vmd thc34f_vmd 0 5e-14
cpar_thc34f_vms thc34f_vms 0 5e-14
cpar_thc34r_h thc34r_h 0 5e-14
cpar_thc34r_kd1 thc34r_kd1 0 5e-14
cpar_thc34r_knb thc34r_knb 0 5e-14
cpar_thc34r_ko1 thc34r_ko1 0 5e-14
cpar_thc34r_ktail thc34r_ktail 0 5e-14
cpar_thc34r_mi thc34r_mi 0 5e-14
cpar_thc34r_op_ad thc34r_op_ad 0 5e-14
cpar_thc34r_op_adn thc34r_op_adn 0 5e-14
cpar_thc34r_op_an thc34r_op_an 0 5e-14
cpar_thc34r_op_aq thc34r_op_aq 0 5e-14
cpar_thc34r_op_aqb thc34r_op_aqb 0 5e-14
cpar_thc34r_op_at thc34r_op_at 0 5e-14
cpar_thc34r_op_gx thc34r_op_gx 0 5e-14
cpar_thc34r_op_p thc34r_op_p 0 5e-14
cpar_thc34r_op_pb thc34r_op_pb 0 5e-14
cpar_thc34r_op_tt thc34r_op_tt 0 5e-14
cpar_thc34r_q thc34r_q 0 5e-14
cpar_thc34r_qb thc34r_qb 0 5e-14
cpar_thc34r_rec thc34r_rec 0 5e-14
cpar_thc34r_rt thc34r_rt 0 5e-14
cpar_thc34r_st_x thc34r_st_x 0 5e-14
cpar_thc34r_vm thc34r_vm 0 5e-14
cpar_thc34r_vmd thc34r_vmd 0 5e-14
cpar_thc34r_vms thc34r_vms 0 5e-14
cpar_thw12f_h thw12f_h 0 5e-14
cpar_thw12f_kd1 thw12f_kd1 0 5e-14
cpar_thw12f_knb thw12f_knb 0 5e-14
cpar_thw12f_ko1 thw12f_ko1 0 5e-14
cpar_thw12f_ktail thw12f_ktail 0 5e-14
cpar_thw12f_mi thw12f_mi 0 5e-14
cpar_thw12f_op_ad thw12f_op_ad 0 5e-14
cpar_thw12f_op_adn thw12f_op_adn 0 5e-14
cpar_thw12f_op_an thw12f_op_an 0 5e-14
cpar_thw12f_op_aq thw12f_op_aq 0 5e-14
cpar_thw12f_op_aqb thw12f_op_aqb 0 5e-14
cpar_thw12f_op_at thw12f_op_at 0 5e-14
cpar_thw12f_op_gx thw12f_op_gx 0 5e-14
cpar_thw12f_op_p thw12f_op_p 0 5e-14
cpar_thw12f_op_pb thw12f_op_pb 0 5e-14
cpar_thw12f_op_tt thw12f_op_tt 0 5e-14
cpar_thw12f_q thw12f_q 0 5e-14
cpar_thw12f_qb thw12f_qb 0 5e-14
cpar_thw12f_rec thw12f_rec 0 5e-14
cpar_thw12f_rt thw12f_rt 0 5e-14
cpar_thw12f_st_x thw12f_st_x 0 5e-14
cpar_thw12f_vm thw12f_vm 0 5e-14
cpar_thw12f_vmd thw12f_vmd 0 5e-14
cpar_thw12f_vms thw12f_vms 0 5e-14
cpar_thw12r_h thw12r_h 0 5e-14
cpar_thw12r_kd1 thw12r_kd1 0 5e-14
cpar_thw12r_knb thw12r_knb 0 5e-14
cpar_thw12r_ko1 thw12r_ko1 0 5e-14
cpar_thw12r_ktail thw12r_ktail 0 5e-14
cpar_thw12r_mi thw12r_mi 0 5e-14
cpar_thw12r_op_ad thw12r_op_ad 0 5e-14
cpar_thw12r_op_adn thw12r_op_adn 0 5e-14
cpar_thw12r_op_an thw12r_op_an 0 5e-14
cpar_thw12r_op_aq thw12r_op_aq 0 5e-14
cpar_thw12r_op_aqb thw12r_op_aqb 0 5e-14
cpar_thw12r_op_at thw12r_op_at 0 5e-14
cpar_thw12r_op_gx thw12r_op_gx 0 5e-14
cpar_thw12r_op_p thw12r_op_p 0 5e-14
cpar_thw12r_op_pb thw12r_op_pb 0 5e-14
cpar_thw12r_op_tt thw12r_op_tt 0 5e-14
cpar_thw12r_q thw12r_q 0 5e-14
cpar_thw12r_qb thw12r_qb 0 5e-14
cpar_thw12r_rec thw12r_rec 0 5e-14
cpar_thw12r_rt thw12r_rt 0 5e-14
cpar_thw12r_st_x thw12r_st_x 0 5e-14
cpar_thw12r_vm thw12r_vm 0 5e-14
cpar_thw12r_vmd thw12r_vmd 0 5e-14
cpar_thw12r_vms thw12r_vms 0 5e-14
cpar_thw23f_h thw23f_h 0 5e-14
cpar_thw23f_kd1 thw23f_kd1 0 5e-14
cpar_thw23f_knb thw23f_knb 0 5e-14
cpar_thw23f_ko1 thw23f_ko1 0 5e-14
cpar_thw23f_ktail thw23f_ktail 0 5e-14
cpar_thw23f_mi thw23f_mi 0 5e-14
cpar_thw23f_op_ad thw23f_op_ad 0 5e-14
cpar_thw23f_op_adn thw23f_op_adn 0 5e-14
cpar_thw23f_op_an thw23f_op_an 0 5e-14
cpar_thw23f_op_aq thw23f_op_aq 0 5e-14
cpar_thw23f_op_aqb thw23f_op_aqb 0 5e-14
cpar_thw23f_op_at thw23f_op_at 0 5e-14
cpar_thw23f_op_gx thw23f_op_gx 0 5e-14
cpar_thw23f_op_p thw23f_op_p 0 5e-14
cpar_thw23f_op_pb thw23f_op_pb 0 5e-14
cpar_thw23f_op_tt thw23f_op_tt 0 5e-14
cpar_thw23f_q thw23f_q 0 5e-14
cpar_thw23f_qb thw23f_qb 0 5e-14
cpar_thw23f_rec thw23f_rec 0 5e-14
cpar_thw23f_rt thw23f_rt 0 5e-14
cpar_thw23f_st_x thw23f_st_x 0 5e-14
cpar_thw23f_vm thw23f_vm 0 5e-14
cpar_thw23f_vmd thw23f_vmd 0 5e-14
cpar_thw23f_vms thw23f_vms 0 5e-14
cpar_thw23r_h thw23r_h 0 5e-14
cpar_thw23r_kd1 thw23r_kd1 0 5e-14
cpar_thw23r_knb thw23r_knb 0 5e-14
cpar_thw23r_ko1 thw23r_ko1 0 5e-14
cpar_thw23r_ktail thw23r_ktail 0 5e-14
cpar_thw23r_mi thw23r_mi 0 5e-14
cpar_thw23r_op_ad thw23r_op_ad 0 5e-14
cpar_thw23r_op_adn thw23r_op_adn 0 5e-14
cpar_thw23r_op_an thw23r_op_an 0 5e-14
cpar_thw23r_op_aq thw23r_op_aq 0 5e-14
cpar_thw23r_op_aqb thw23r_op_aqb 0 5e-14
cpar_thw23r_op_at thw23r_op_at 0 5e-14
cpar_thw23r_op_gx thw23r_op_gx 0 5e-14
cpar_thw23r_op_p thw23r_op_p 0 5e-14
cpar_thw23r_op_pb thw23r_op_pb 0 5e-14
cpar_thw23r_op_tt thw23r_op_tt 0 5e-14
cpar_thw23r_q thw23r_q 0 5e-14
cpar_thw23r_qb thw23r_qb 0 5e-14
cpar_thw23r_rec thw23r_rec 0 5e-14
cpar_thw23r_rt thw23r_rt 0 5e-14
cpar_thw23r_st_x thw23r_st_x 0 5e-14
cpar_thw23r_vm thw23r_vm 0 5e-14
cpar_thw23r_vmd thw23r_vmd 0 5e-14
cpar_thw23r_vms thw23r_vms 0 5e-14
cpar_thw34f_h thw34f_h 0 5e-14
cpar_thw34f_kd1 thw34f_kd1 0 5e-14
cpar_thw34f_knb thw34f_knb 0 5e-14
cpar_thw34f_ko1 thw34f_ko1 0 5e-14
cpar_thw34f_ktail thw34f_ktail 0 5e-14
cpar_thw34f_mi thw34f_mi 0 5e-14
cpar_thw34f_op_ad thw34f_op_ad 0 5e-14
cpar_thw34f_op_adn thw34f_op_adn 0 5e-14
cpar_thw34f_op_an thw34f_op_an 0 5e-14
cpar_thw34f_op_aq thw34f_op_aq 0 5e-14
cpar_thw34f_op_aqb thw34f_op_aqb 0 5e-14
cpar_thw34f_op_at thw34f_op_at 0 5e-14
cpar_thw34f_op_gx thw34f_op_gx 0 5e-14
cpar_thw34f_op_p thw34f_op_p 0 5e-14
cpar_thw34f_op_pb thw34f_op_pb 0 5e-14
cpar_thw34f_op_tt thw34f_op_tt 0 5e-14
cpar_thw34f_q thw34f_q 0 5e-14
cpar_thw34f_qb thw34f_qb 0 5e-14
cpar_thw34f_rec thw34f_rec 0 5e-14
cpar_thw34f_rt thw34f_rt 0 5e-14
cpar_thw34f_st_x thw34f_st_x 0 5e-14
cpar_thw34f_vm thw34f_vm 0 5e-14
cpar_thw34f_vmd thw34f_vmd 0 5e-14
cpar_thw34f_vms thw34f_vms 0 5e-14
cpar_thw34r_h thw34r_h 0 5e-14
cpar_thw34r_kd1 thw34r_kd1 0 5e-14
cpar_thw34r_knb thw34r_knb 0 5e-14
cpar_thw34r_ko1 thw34r_ko1 0 5e-14
cpar_thw34r_ktail thw34r_ktail 0 5e-14
cpar_thw34r_mi thw34r_mi 0 5e-14
cpar_thw34r_op_ad thw34r_op_ad 0 5e-14
cpar_thw34r_op_adn thw34r_op_adn 0 5e-14
cpar_thw34r_op_an thw34r_op_an 0 5e-14
cpar_thw34r_op_aq thw34r_op_aq 0 5e-14
cpar_thw34r_op_aqb thw34r_op_aqb 0 5e-14
cpar_thw34r_op_at thw34r_op_at 0 5e-14
cpar_thw34r_op_gx thw34r_op_gx 0 5e-14
cpar_thw34r_op_p thw34r_op_p 0 5e-14
cpar_thw34r_op_pb thw34r_op_pb 0 5e-14
cpar_thw34r_op_tt thw34r_op_tt 0 5e-14
cpar_thw34r_q thw34r_q 0 5e-14
cpar_thw34r_qb thw34r_qb 0 5e-14
cpar_thw34r_rec thw34r_rec 0 5e-14
cpar_thw34r_rt thw34r_rt 0 5e-14
cpar_thw34r_st_x thw34r_st_x 0 5e-14
cpar_thw34r_vm thw34r_vm 0 5e-14
cpar_thw34r_vmd thw34r_vmd 0 5e-14
cpar_thw34r_vms thw34r_vms 0 5e-14
cpar_vdd vdd 0 5e-14
cpar_vmid vmid 0 5e-14
va_cpar_vrest_p vrest cpar_vrest_p 0
cpar_vrest cpar_vrest_p 0 5e-14
cpar_vthe vthe 0 5e-14
cpar_vthr vthr 0 5e-14
.options sparse method=gear reltol=1e-5 abstol=1e-16
.save v(vsrc) v(vdd) v(vrest) v(vthe) v(vthr) v(vmid) v(iref_n) v(irefp_n) v(ilim_n) v(ilimp_n) v(istep_n) i(vsrc) v(agc12f_cg) v(agc12f_ena) v(agc12r_cg) v(agc12r_ena) v(agc23f_cg) v(agc23f_ena) v(agc23r_cg) v(agc23r_ena) v(agc34f_cg) v(agc34f_ena) v(agc34r_cg) v(agc34r_ena) v(agw12f_cg) v(agw12f_ena) v(agw12r_cg) v(agw12r_ena) v(agw23f_cg) v(agw23f_ena) v(agw23r_cg) v(agw23r_ena) v(agw34f_cg) v(agw34f_ena) v(agw34r_cg) v(agw34r_ena) v(cdc12f_h) v(cdc12f_hc) v(cdc12f_hcf_h1) v(cdc12f_hcf_sd) v(cdc12f_hs) v(cdc12f_hsf_h1) v(cdc12f_hsf_sd) v(cdc12f_kd1) v(cdc12f_knb) v(cdc12f_ko1) v(cdc12f_ktail) v(cdc12f_kx) v(cdc12f_mi) v(cdc12f_op_ad) v(cdc12f_op_adn) v(cdc12f_op_an) v(cdc12f_op_aq) v(cdc12f_op_aqb) v(cdc12f_op_at) v(cdc12f_op_gx) v(cdc12f_op_p) v(cdc12f_op_pb) v(cdc12f_op_tt) v(cdc12f_q) v(cdc12f_qb) v(cdc12f_rec) v(cdc12f_rt) v(cdc12f_st_x) v(cdc12f_vm) v(cdc12f_vmd) v(cdc12f_vms) v(cdc12r_h) v(cdc12r_hc) v(cdc12r_hcf_h1) v(cdc12r_hcf_sd) v(cdc12r_hs) v(cdc12r_hsf_h1) v(cdc12r_hsf_sd) v(cdc12r_kd1) v(cdc12r_knb) v(cdc12r_ko1) v(cdc12r_ktail) v(cdc12r_kx) v(cdc12r_mi) v(cdc12r_op_ad) v(cdc12r_op_adn) v(cdc12r_op_an) v(cdc12r_op_aq) v(cdc12r_op_aqb) v(cdc12r_op_at) v(cdc12r_op_gx) v(cdc12r_op_p) v(cdc12r_op_pb) v(cdc12r_op_tt) v(cdc12r_q) v(cdc12r_qb) v(cdc12r_rec) v(cdc12r_rt) v(cdc12r_st_x) v(cdc12r_vm) v(cdc12r_vmd) v(cdc12r_vms) v(cdc23f_h) v(cdc23f_hc) v(cdc23f_hcf_h1) v(cdc23f_hcf_sd) v(cdc23f_hs) v(cdc23f_hsf_h1) v(cdc23f_hsf_sd) v(cdc23f_kd1) v(cdc23f_knb) v(cdc23f_ko1) v(cdc23f_ktail) v(cdc23f_kx) v(cdc23f_mi) v(cdc23f_op_ad) v(cdc23f_op_adn) v(cdc23f_op_an) v(cdc23f_op_aq) v(cdc23f_op_aqb) v(cdc23f_op_at) v(cdc23f_op_gx) v(cdc23f_op_p) v(cdc23f_op_pb) v(cdc23f_op_tt) v(cdc23f_q) v(cdc23f_qb) v(cdc23f_rec) v(cdc23f_rt) v(cdc23f_st_x) v(cdc23f_vm) v(cdc23f_vmd) v(cdc23f_vms) v(cdc23r_h) v(cdc23r_hc) v(cdc23r_hcf_h1) v(cdc23r_hcf_sd) v(cdc23r_hs) v(cdc23r_hsf_h1) v(cdc23r_hsf_sd) v(cdc23r_kd1) v(cdc23r_knb) v(cdc23r_ko1) v(cdc23r_ktail) v(cdc23r_kx) v(cdc23r_mi) v(cdc23r_op_ad) v(cdc23r_op_adn) v(cdc23r_op_an) v(cdc23r_op_aq) v(cdc23r_op_aqb) v(cdc23r_op_at) v(cdc23r_op_gx) v(cdc23r_op_p) v(cdc23r_op_pb) v(cdc23r_op_tt) v(cdc23r_q) v(cdc23r_qb) v(cdc23r_rec) v(cdc23r_rt) v(cdc23r_st_x) v(cdc23r_vm) v(cdc23r_vmd) v(cdc23r_vms) v(cdc34f_h) v(cdc34f_hc) v(cdc34f_hcf_h1) v(cdc34f_hcf_sd) v(cdc34f_hs) v(cdc34f_hsf_h1) v(cdc34f_hsf_sd) v(cdc34f_kd1) v(cdc34f_knb) v(cdc34f_ko1) v(cdc34f_ktail) v(cdc34f_kx) v(cdc34f_mi) v(cdc34f_op_ad) v(cdc34f_op_adn) v(cdc34f_op_an) v(cdc34f_op_aq) v(cdc34f_op_aqb) v(cdc34f_op_at) v(cdc34f_op_gx) v(cdc34f_op_p) v(cdc34f_op_pb) v(cdc34f_op_tt) v(cdc34f_q) v(cdc34f_qb) v(cdc34f_rec) v(cdc34f_rt) v(cdc34f_st_x) v(cdc34f_vm) v(cdc34f_vmd) v(cdc34f_vms) v(cdc34r_h) v(cdc34r_hc) v(cdc34r_hcf_h1) v(cdc34r_hcf_sd) v(cdc34r_hs) v(cdc34r_hsf_h1) v(cdc34r_hsf_sd) v(cdc34r_kd1) v(cdc34r_knb) v(cdc34r_ko1) v(cdc34r_ktail) v(cdc34r_kx) v(cdc34r_mi) v(cdc34r_op_ad) v(cdc34r_op_adn) v(cdc34r_op_an) v(cdc34r_op_aq) v(cdc34r_op_aqb) v(cdc34r_op_at) v(cdc34r_op_gx) v(cdc34r_op_p) v(cdc34r_op_pb) v(cdc34r_op_tt) v(cdc34r_q) v(cdc34r_qb) v(cdc34r_rec) v(cdc34r_rt) v(cdc34r_st_x) v(cdc34r_vm) v(cdc34r_vmd) v(cdc34r_vms) v(cdw12f_h) v(cdw12f_hc) v(cdw12f_hcf_h1) v(cdw12f_hcf_sd) v(cdw12f_hs) v(cdw12f_hsf_h1) v(cdw12f_hsf_sd) v(cdw12f_kd1) v(cdw12f_knb) v(cdw12f_ko1) v(cdw12f_ktail) v(cdw12f_kx) v(cdw12f_mi) v(cdw12f_op_ad) v(cdw12f_op_adn) v(cdw12f_op_an) v(cdw12f_op_aq) v(cdw12f_op_aqb) v(cdw12f_op_at) v(cdw12f_op_gx) v(cdw12f_op_p) v(cdw12f_op_pb) v(cdw12f_op_tt) v(cdw12f_q) v(cdw12f_qb) v(cdw12f_rec) v(cdw12f_rt) v(cdw12f_st_x) v(cdw12f_vm) v(cdw12f_vmd) v(cdw12f_vms) v(cdw12r_h) v(cdw12r_hc) v(cdw12r_hcf_h1) v(cdw12r_hcf_sd) v(cdw12r_hs) v(cdw12r_hsf_h1) v(cdw12r_hsf_sd) v(cdw12r_kd1) v(cdw12r_knb) v(cdw12r_ko1) v(cdw12r_ktail) v(cdw12r_kx) v(cdw12r_mi) v(cdw12r_op_ad) v(cdw12r_op_adn) v(cdw12r_op_an) v(cdw12r_op_aq) v(cdw12r_op_aqb) v(cdw12r_op_at) v(cdw12r_op_gx) v(cdw12r_op_p) v(cdw12r_op_pb) v(cdw12r_op_tt) v(cdw12r_q) v(cdw12r_qb) v(cdw12r_rec) v(cdw12r_rt) v(cdw12r_st_x) v(cdw12r_vm) v(cdw12r_vmd) v(cdw12r_vms) v(cdw23f_h) v(cdw23f_hc) v(cdw23f_hcf_h1) v(cdw23f_hcf_sd) v(cdw23f_hs) v(cdw23f_hsf_h1) v(cdw23f_hsf_sd) v(cdw23f_kd1) v(cdw23f_knb) v(cdw23f_ko1) v(cdw23f_ktail) v(cdw23f_kx) v(cdw23f_mi) v(cdw23f_op_ad) v(cdw23f_op_adn) v(cdw23f_op_an) v(cdw23f_op_aq) v(cdw23f_op_aqb) v(cdw23f_op_at) v(cdw23f_op_gx) v(cdw23f_op_p) v(cdw23f_op_pb) v(cdw23f_op_tt) v(cdw23f_q) v(cdw23f_qb) v(cdw23f_rec) v(cdw23f_rt) v(cdw23f_st_x) v(cdw23f_vm) v(cdw23f_vmd) v(cdw23f_vms) v(cdw23r_h) v(cdw23r_hc) v(cdw23r_hcf_h1) v(cdw23r_hcf_sd) v(cdw23r_hs) v(cdw23r_hsf_h1) v(cdw23r_hsf_sd) v(cdw23r_kd1) v(cdw23r_knb) v(cdw23r_ko1) v(cdw23r_ktail) v(cdw23r_kx) v(cdw23r_mi) v(cdw23r_op_ad) v(cdw23r_op_adn) v(cdw23r_op_an) v(cdw23r_op_aq) v(cdw23r_op_aqb) v(cdw23r_op_at) v(cdw23r_op_gx) v(cdw23r_op_p) v(cdw23r_op_pb) v(cdw23r_op_tt) v(cdw23r_q) v(cdw23r_qb) v(cdw23r_rec) v(cdw23r_rt) v(cdw23r_st_x) v(cdw23r_vm) v(cdw23r_vmd) v(cdw23r_vms) v(cdw34f_h) v(cdw34f_hc) v(cdw34f_hcf_h1) v(cdw34f_hcf_sd) v(cdw34f_hs) v(cdw34f_hsf_h1) v(cdw34f_hsf_sd) v(cdw34f_kd1) v(cdw34f_knb) v(cdw34f_ko1) v(cdw34f_ktail) v(cdw34f_kx) v(cdw34f_mi) v(cdw34f_op_ad) v(cdw34f_op_adn) v(cdw34f_op_an) v(cdw34f_op_aq) v(cdw34f_op_aqb) v(cdw34f_op_at) v(cdw34f_op_gx) v(cdw34f_op_p) v(cdw34f_op_pb) v(cdw34f_op_tt) v(cdw34f_q) v(cdw34f_qb) v(cdw34f_rec) v(cdw34f_rt) v(cdw34f_st_x) v(cdw34f_vm) v(cdw34f_vmd) v(cdw34f_vms) v(cdw34r_h) v(cdw34r_hc) v(cdw34r_hcf_h1) v(cdw34r_hcf_sd) v(cdw34r_hs) v(cdw34r_hsf_h1) v(cdw34r_hsf_sd) v(cdw34r_kd1) v(cdw34r_knb) v(cdw34r_ko1) v(cdw34r_ktail) v(cdw34r_kx) v(cdw34r_mi) v(cdw34r_op_ad) v(cdw34r_op_adn) v(cdw34r_op_an) v(cdw34r_op_aq) v(cdw34r_op_aqb) v(cdw34r_op_at) v(cdw34r_op_gx) v(cdw34r_op_p) v(cdw34r_op_pb) v(cdw34r_op_tt) v(cdw34r_q) v(cdw34r_qb) v(cdw34r_rec) v(cdw34r_rt) v(cdw34r_st_x) v(cdw34r_vm) v(cdw34r_vmd) v(cdw34r_vms) v(gc1_and_a0_nb) v(gc1_and_a0_nx) v(gc1_and_a1_nb) v(gc1_and_a1_nx) v(gc1_and_a2_nb) v(gc1_and_a2_nx) v(gc1_and_a3_nb) v(gc1_and_a3_nx) v(gc1_and_a4_nb) v(gc1_and_a4_nx) v(gc1_and_a5_nb) v(gc1_and_a5_nx) v(gc1_and_a6_nb) v(gc1_and_a6_nx) v(gc1_and_a7_nb) v(gc1_and_a7_nx) v(gc1_and_a8_nb) v(gc1_and_a8_nx) v(gc1_and_g0) v(gc1_and_g1) v(gc1_and_g2) v(gc1_and_g3) v(gc1_and_g4) v(gc1_and_g5) v(gc1_and_g6) v(gc1_and_g7) v(gc1_and_g8) v(gc1_b1) v(gc1_b10) v(gc1_b10_n) v(gc1_b10_q) v(gc1_b10_t) v(gc1_b1_n) v(gc1_b1_q) v(gc1_b1_t) v(gc1_b2) v(gc1_b2_n) v(gc1_b2_q) v(gc1_b2_t) v(gc1_b3) v(gc1_b3_n) v(gc1_b3_q) v(gc1_b3_t) v(gc1_b4) v(gc1_b4_n) v(gc1_b4_q) v(gc1_b4_t) v(gc1_b5) v(gc1_b5_n) v(gc1_b5_q) v(gc1_b5_t) v(gc1_b6) v(gc1_b6_n) v(gc1_b6_q) v(gc1_b6_t) v(gc1_b7) v(gc1_b7_n) v(gc1_b7_q) v(gc1_b7_t) v(gc1_b8) v(gc1_b8_n) v(gc1_b8_q) v(gc1_b8_t) v(gc1_b9) v(gc1_b9_n) v(gc1_b9_q) v(gc1_b9_t) v(gc1_cin_cg) v(gc1_cin_ena) v(gc1_col_h) v(gc1_col_kd1) v(gc1_col_knb) v(gc1_col_ko1) v(gc1_col_ktail) v(gc1_col_q) v(gc1_col_qb) v(gc1_col_rec) v(gc1_col_rt) v(gc1_col_vm) v(gc1_col_vmd) v(gc1_col_vms) v(gc1_e10_h) v(gc1_e10_kd1) v(gc1_e10_knb) v(gc1_e10_ko1) v(gc1_e10_ktail) v(gc1_e10_q) v(gc1_e10_qb) v(gc1_e10_rec) v(gc1_e10_rt) v(gc1_e10_vm) v(gc1_e10_vmd) v(gc1_e10_vms) v(gc1_e1_h) v(gc1_e1_kd1) v(gc1_e1_knb) v(gc1_e1_ko1) v(gc1_e1_ktail) v(gc1_e1_q) v(gc1_e1_qb) v(gc1_e1_rec) v(gc1_e1_rt) v(gc1_e1_vm) v(gc1_e1_vmd) v(gc1_e1_vms) v(gc1_e2_h) v(gc1_e2_kd1) v(gc1_e2_knb) v(gc1_e2_ko1) v(gc1_e2_ktail) v(gc1_e2_q) v(gc1_e2_qb) v(gc1_e2_rec) v(gc1_e2_rt) v(gc1_e2_vm) v(gc1_e2_vmd) v(gc1_e2_vms) v(gc1_e3_h) v(gc1_e3_kd1) v(gc1_e3_knb) v(gc1_e3_ko1) v(gc1_e3_ktail) v(gc1_e3_q) v(gc1_e3_qb) v(gc1_e3_rec) v(gc1_e3_rt) v(gc1_e3_vm) v(gc1_e3_vmd) v(gc1_e3_vms) v(gc1_e4_h) v(gc1_e4_kd1) v(gc1_e4_knb) v(gc1_e4_ko1) v(gc1_e4_ktail) v(gc1_e4_q) v(gc1_e4_qb) v(gc1_e4_rec) v(gc1_e4_rt) v(gc1_e4_vm) v(gc1_e4_vmd) v(gc1_e4_vms) v(gc1_e5_h) v(gc1_e5_kd1) v(gc1_e5_knb) v(gc1_e5_ko1) v(gc1_e5_ktail) v(gc1_e5_q) v(gc1_e5_qb) v(gc1_e5_rec) v(gc1_e5_rt) v(gc1_e5_vm) v(gc1_e5_vmd) v(gc1_e5_vms) v(gc1_e6_h) v(gc1_e6_kd1) v(gc1_e6_knb) v(gc1_e6_ko1) v(gc1_e6_ktail) v(gc1_e6_q) v(gc1_e6_qb) v(gc1_e6_rec) v(gc1_e6_rt) v(gc1_e6_vm) v(gc1_e6_vmd) v(gc1_e6_vms) v(gc1_e7_h) v(gc1_e7_kd1) v(gc1_e7_knb) v(gc1_e7_ko1) v(gc1_e7_ktail) v(gc1_e7_q) v(gc1_e7_qb) v(gc1_e7_rec) v(gc1_e7_rt) v(gc1_e7_vm) v(gc1_e7_vmd) v(gc1_e7_vms) v(gc1_e8_h) v(gc1_e8_kd1) v(gc1_e8_knb) v(gc1_e8_ko1) v(gc1_e8_ktail) v(gc1_e8_q) v(gc1_e8_qb) v(gc1_e8_rec) v(gc1_e8_rt) v(gc1_e8_vm) v(gc1_e8_vmd) v(gc1_e8_vms) v(gc1_e9_h) v(gc1_e9_kd1) v(gc1_e9_knb) v(gc1_e9_ko1) v(gc1_e9_ktail) v(gc1_e9_q) v(gc1_e9_qb) v(gc1_e9_rec) v(gc1_e9_rt) v(gc1_e9_vm) v(gc1_e9_vmd) v(gc1_e9_vms) v(gc1_gb) v(gc1_op_ad) v(gc1_op_adn) v(gc1_op_an) v(gc1_op_aq) v(gc1_op_aqb) v(gc1_op_at) v(gc1_op_gx) v(gc1_op_p) v(gc1_op_pb) v(gc1_op_tt) v(gc2_and_a0_nb) v(gc2_and_a0_nx) v(gc2_and_a1_nb) v(gc2_and_a1_nx) v(gc2_and_a2_nb) v(gc2_and_a2_nx) v(gc2_and_a3_nb) v(gc2_and_a3_nx) v(gc2_and_a4_nb) v(gc2_and_a4_nx) v(gc2_and_a5_nb) v(gc2_and_a5_nx) v(gc2_and_a6_nb) v(gc2_and_a6_nx) v(gc2_and_a7_nb) v(gc2_and_a7_nx) v(gc2_and_a8_nb) v(gc2_and_a8_nx) v(gc2_and_g0) v(gc2_and_g1) v(gc2_and_g2) v(gc2_and_g3) v(gc2_and_g4) v(gc2_and_g5) v(gc2_and_g6) v(gc2_and_g7) v(gc2_and_g8) v(gc2_b1) v(gc2_b10) v(gc2_b10_n) v(gc2_b10_q) v(gc2_b10_t) v(gc2_b1_n) v(gc2_b1_q) v(gc2_b1_t) v(gc2_b2) v(gc2_b2_n) v(gc2_b2_q) v(gc2_b2_t) v(gc2_b3) v(gc2_b3_n) v(gc2_b3_q) v(gc2_b3_t) v(gc2_b4) v(gc2_b4_n) v(gc2_b4_q) v(gc2_b4_t) v(gc2_b5) v(gc2_b5_n) v(gc2_b5_q) v(gc2_b5_t) v(gc2_b6) v(gc2_b6_n) v(gc2_b6_q) v(gc2_b6_t) v(gc2_b7) v(gc2_b7_n) v(gc2_b7_q) v(gc2_b7_t) v(gc2_b8) v(gc2_b8_n) v(gc2_b8_q) v(gc2_b8_t) v(gc2_b9) v(gc2_b9_n) v(gc2_b9_q) v(gc2_b9_t) v(gc2_cin_cg) v(gc2_cin_ena) v(gc2_col_h) v(gc2_col_kd1) v(gc2_col_knb) v(gc2_col_ko1) v(gc2_col_ktail) v(gc2_col_q) v(gc2_col_qb) v(gc2_col_rec) v(gc2_col_rt) v(gc2_col_vm) v(gc2_col_vmd) v(gc2_col_vms) v(gc2_e10_h) v(gc2_e10_kd1) v(gc2_e10_knb) v(gc2_e10_ko1) v(gc2_e10_ktail) v(gc2_e10_q) v(gc2_e10_qb) v(gc2_e10_rec) v(gc2_e10_rt) v(gc2_e10_vm) v(gc2_e10_vmd) v(gc2_e10_vms) v(gc2_e1_h) v(gc2_e1_kd1) v(gc2_e1_knb) v(gc2_e1_ko1) v(gc2_e1_ktail) v(gc2_e1_q) v(gc2_e1_qb) v(gc2_e1_rec) v(gc2_e1_rt) v(gc2_e1_vm) v(gc2_e1_vmd) v(gc2_e1_vms) v(gc2_e2_h) v(gc2_e2_kd1) v(gc2_e2_knb) v(gc2_e2_ko1) v(gc2_e2_ktail) v(gc2_e2_q) v(gc2_e2_qb) v(gc2_e2_rec) v(gc2_e2_rt) v(gc2_e2_vm) v(gc2_e2_vmd) v(gc2_e2_vms) v(gc2_e3_h) v(gc2_e3_kd1) v(gc2_e3_knb) v(gc2_e3_ko1) v(gc2_e3_ktail) v(gc2_e3_q) v(gc2_e3_qb) v(gc2_e3_rec) v(gc2_e3_rt) v(gc2_e3_vm) v(gc2_e3_vmd) v(gc2_e3_vms) v(gc2_e4_h) v(gc2_e4_kd1) v(gc2_e4_knb) v(gc2_e4_ko1) v(gc2_e4_ktail) v(gc2_e4_q) v(gc2_e4_qb) v(gc2_e4_rec) v(gc2_e4_rt) v(gc2_e4_vm) v(gc2_e4_vmd) v(gc2_e4_vms) v(gc2_e5_h) v(gc2_e5_kd1) v(gc2_e5_knb) v(gc2_e5_ko1) v(gc2_e5_ktail) v(gc2_e5_q) v(gc2_e5_qb) v(gc2_e5_rec) v(gc2_e5_rt) v(gc2_e5_vm) v(gc2_e5_vmd) v(gc2_e5_vms) v(gc2_e6_h) v(gc2_e6_kd1) v(gc2_e6_knb) v(gc2_e6_ko1) v(gc2_e6_ktail) v(gc2_e6_q) v(gc2_e6_qb) v(gc2_e6_rec) v(gc2_e6_rt) v(gc2_e6_vm) v(gc2_e6_vmd) v(gc2_e6_vms) v(gc2_e7_h) v(gc2_e7_kd1) v(gc2_e7_knb) v(gc2_e7_ko1) v(gc2_e7_ktail) v(gc2_e7_q) v(gc2_e7_qb) v(gc2_e7_rec) v(gc2_e7_rt) v(gc2_e7_vm) v(gc2_e7_vmd) v(gc2_e7_vms) v(gc2_e8_h) v(gc2_e8_kd1) v(gc2_e8_knb) v(gc2_e8_ko1) v(gc2_e8_ktail) v(gc2_e8_q) v(gc2_e8_qb) v(gc2_e8_rec) v(gc2_e8_rt) v(gc2_e8_vm) v(gc2_e8_vmd) v(gc2_e8_vms) v(gc2_e9_h) v(gc2_e9_kd1) v(gc2_e9_knb) v(gc2_e9_ko1) v(gc2_e9_ktail) v(gc2_e9_q) v(gc2_e9_qb) v(gc2_e9_rec) v(gc2_e9_rt) v(gc2_e9_vm) v(gc2_e9_vmd) v(gc2_e9_vms) v(gc2_gb) v(gc2_op_ad) v(gc2_op_adn) v(gc2_op_an) v(gc2_op_aq) v(gc2_op_aqb) v(gc2_op_at) v(gc2_op_gx) v(gc2_op_p) v(gc2_op_pb) v(gc2_op_tt) v(gc3_and_a0_nb) v(gc3_and_a0_nx) v(gc3_and_a1_nb) v(gc3_and_a1_nx) v(gc3_and_a2_nb) v(gc3_and_a2_nx) v(gc3_and_a3_nb) v(gc3_and_a3_nx) v(gc3_and_a4_nb) v(gc3_and_a4_nx) v(gc3_and_a5_nb) v(gc3_and_a5_nx) v(gc3_and_a6_nb) v(gc3_and_a6_nx) v(gc3_and_a7_nb) v(gc3_and_a7_nx) v(gc3_and_a8_nb) v(gc3_and_a8_nx) v(gc3_and_g0) v(gc3_and_g1) v(gc3_and_g2) v(gc3_and_g3) v(gc3_and_g4) v(gc3_and_g5) v(gc3_and_g6) v(gc3_and_g7) v(gc3_and_g8) v(gc3_b1) v(gc3_b10) v(gc3_b10_n) v(gc3_b10_q) v(gc3_b10_t) v(gc3_b1_n) v(gc3_b1_q) v(gc3_b1_t) v(gc3_b2) v(gc3_b2_n) v(gc3_b2_q) v(gc3_b2_t) v(gc3_b3) v(gc3_b3_n) v(gc3_b3_q) v(gc3_b3_t) v(gc3_b4) v(gc3_b4_n) v(gc3_b4_q) v(gc3_b4_t) v(gc3_b5) v(gc3_b5_n) v(gc3_b5_q) v(gc3_b5_t) v(gc3_b6) v(gc3_b6_n) v(gc3_b6_q) v(gc3_b6_t) v(gc3_b7) v(gc3_b7_n) v(gc3_b7_q) v(gc3_b7_t) v(gc3_b8) v(gc3_b8_n) v(gc3_b8_q) v(gc3_b8_t) v(gc3_b9) v(gc3_b9_n) v(gc3_b9_q) v(gc3_b9_t) v(gc3_cin_cg) v(gc3_cin_ena) v(gc3_col_h) v(gc3_col_kd1) v(gc3_col_knb) v(gc3_col_ko1) v(gc3_col_ktail) v(gc3_col_q) v(gc3_col_qb) v(gc3_col_rec) v(gc3_col_rt) v(gc3_col_vm) v(gc3_col_vmd) v(gc3_col_vms) v(gc3_e10_h) v(gc3_e10_kd1) v(gc3_e10_knb) v(gc3_e10_ko1) v(gc3_e10_ktail) v(gc3_e10_q) v(gc3_e10_qb) v(gc3_e10_rec) v(gc3_e10_rt) v(gc3_e10_vm) v(gc3_e10_vmd) v(gc3_e10_vms) v(gc3_e1_h) v(gc3_e1_kd1) v(gc3_e1_knb) v(gc3_e1_ko1) v(gc3_e1_ktail) v(gc3_e1_q) v(gc3_e1_qb) v(gc3_e1_rec) v(gc3_e1_rt) v(gc3_e1_vm) v(gc3_e1_vmd) v(gc3_e1_vms) v(gc3_e2_h) v(gc3_e2_kd1) v(gc3_e2_knb) v(gc3_e2_ko1) v(gc3_e2_ktail) v(gc3_e2_q) v(gc3_e2_qb) v(gc3_e2_rec) v(gc3_e2_rt) v(gc3_e2_vm) v(gc3_e2_vmd) v(gc3_e2_vms) v(gc3_e3_h) v(gc3_e3_kd1) v(gc3_e3_knb) v(gc3_e3_ko1) v(gc3_e3_ktail) v(gc3_e3_q) v(gc3_e3_qb) v(gc3_e3_rec) v(gc3_e3_rt) v(gc3_e3_vm) v(gc3_e3_vmd) v(gc3_e3_vms) v(gc3_e4_h) v(gc3_e4_kd1) v(gc3_e4_knb) v(gc3_e4_ko1) v(gc3_e4_ktail) v(gc3_e4_q) v(gc3_e4_qb) v(gc3_e4_rec) v(gc3_e4_rt) v(gc3_e4_vm) v(gc3_e4_vmd) v(gc3_e4_vms) v(gc3_e5_h) v(gc3_e5_kd1) v(gc3_e5_knb) v(gc3_e5_ko1) v(gc3_e5_ktail) v(gc3_e5_q) v(gc3_e5_qb) v(gc3_e5_rec) v(gc3_e5_rt) v(gc3_e5_vm) v(gc3_e5_vmd) v(gc3_e5_vms) v(gc3_e6_h) v(gc3_e6_kd1) v(gc3_e6_knb) v(gc3_e6_ko1) v(gc3_e6_ktail) v(gc3_e6_q) v(gc3_e6_qb) v(gc3_e6_rec) v(gc3_e6_rt) v(gc3_e6_vm) v(gc3_e6_vmd) v(gc3_e6_vms) v(gc3_e7_h) v(gc3_e7_kd1) v(gc3_e7_knb) v(gc3_e7_ko1) v(gc3_e7_ktail) v(gc3_e7_q) v(gc3_e7_qb) v(gc3_e7_rec) v(gc3_e7_rt) v(gc3_e7_vm) v(gc3_e7_vmd) v(gc3_e7_vms) v(gc3_e8_h) v(gc3_e8_kd1) v(gc3_e8_knb) v(gc3_e8_ko1) v(gc3_e8_ktail) v(gc3_e8_q) v(gc3_e8_qb) v(gc3_e8_rec) v(gc3_e8_rt) v(gc3_e8_vm) v(gc3_e8_vmd) v(gc3_e8_vms) v(gc3_e9_h) v(gc3_e9_kd1) v(gc3_e9_knb) v(gc3_e9_ko1) v(gc3_e9_ktail) v(gc3_e9_q) v(gc3_e9_qb) v(gc3_e9_rec) v(gc3_e9_rt) v(gc3_e9_vm) v(gc3_e9_vmd) v(gc3_e9_vms) v(gc3_gb) v(gc3_op_ad) v(gc3_op_adn) v(gc3_op_an) v(gc3_op_aq) v(gc3_op_aqb) v(gc3_op_at) v(gc3_op_gx) v(gc3_op_p) v(gc3_op_pb) v(gc3_op_tt) v(gc4_and_a0_nb) v(gc4_and_a0_nx) v(gc4_and_a1_nb) v(gc4_and_a1_nx) v(gc4_and_a2_nb) v(gc4_and_a2_nx) v(gc4_and_a3_nb) v(gc4_and_a3_nx) v(gc4_and_a4_nb) v(gc4_and_a4_nx) v(gc4_and_a5_nb) v(gc4_and_a5_nx) v(gc4_and_a6_nb) v(gc4_and_a6_nx) v(gc4_and_a7_nb) v(gc4_and_a7_nx) v(gc4_and_a8_nb) v(gc4_and_a8_nx) v(gc4_and_g0) v(gc4_and_g1) v(gc4_and_g2) v(gc4_and_g3) v(gc4_and_g4) v(gc4_and_g5) v(gc4_and_g6) v(gc4_and_g7) v(gc4_and_g8) v(gc4_b1) v(gc4_b10) v(gc4_b10_n) v(gc4_b10_q) v(gc4_b10_t) v(gc4_b1_n) v(gc4_b1_q) v(gc4_b1_t) v(gc4_b2) v(gc4_b2_n) v(gc4_b2_q) v(gc4_b2_t) v(gc4_b3) v(gc4_b3_n) v(gc4_b3_q) v(gc4_b3_t) v(gc4_b4) v(gc4_b4_n) v(gc4_b4_q) v(gc4_b4_t) v(gc4_b5) v(gc4_b5_n) v(gc4_b5_q) v(gc4_b5_t) v(gc4_b6) v(gc4_b6_n) v(gc4_b6_q) v(gc4_b6_t) v(gc4_b7) v(gc4_b7_n) v(gc4_b7_q) v(gc4_b7_t) v(gc4_b8) v(gc4_b8_n) v(gc4_b8_q) v(gc4_b8_t) v(gc4_b9) v(gc4_b9_n) v(gc4_b9_q) v(gc4_b9_t) v(gc4_cin_cg) v(gc4_cin_ena) v(gc4_col_h) v(gc4_col_kd1) v(gc4_col_knb) v(gc4_col_ko1) v(gc4_col_ktail) v(gc4_col_q) v(gc4_col_qb) v(gc4_col_rec) v(gc4_col_rt) v(gc4_col_vm) v(gc4_col_vmd) v(gc4_col_vms) v(gc4_e10_h) v(gc4_e10_kd1) v(gc4_e10_knb) v(gc4_e10_ko1) v(gc4_e10_ktail) v(gc4_e10_q) v(gc4_e10_qb) v(gc4_e10_rec) v(gc4_e10_rt) v(gc4_e10_vm) v(gc4_e10_vmd) v(gc4_e10_vms) v(gc4_e1_h) v(gc4_e1_kd1) v(gc4_e1_knb) v(gc4_e1_ko1) v(gc4_e1_ktail) v(gc4_e1_q) v(gc4_e1_qb) v(gc4_e1_rec) v(gc4_e1_rt) v(gc4_e1_vm) v(gc4_e1_vmd) v(gc4_e1_vms) v(gc4_e2_h) v(gc4_e2_kd1) v(gc4_e2_knb) v(gc4_e2_ko1) v(gc4_e2_ktail) v(gc4_e2_q) v(gc4_e2_qb) v(gc4_e2_rec) v(gc4_e2_rt) v(gc4_e2_vm) v(gc4_e2_vmd) v(gc4_e2_vms) v(gc4_e3_h) v(gc4_e3_kd1) v(gc4_e3_knb) v(gc4_e3_ko1) v(gc4_e3_ktail) v(gc4_e3_q) v(gc4_e3_qb) v(gc4_e3_rec) v(gc4_e3_rt) v(gc4_e3_vm) v(gc4_e3_vmd) v(gc4_e3_vms) v(gc4_e4_h) v(gc4_e4_kd1) v(gc4_e4_knb) v(gc4_e4_ko1) v(gc4_e4_ktail) v(gc4_e4_q) v(gc4_e4_qb) v(gc4_e4_rec) v(gc4_e4_rt) v(gc4_e4_vm) v(gc4_e4_vmd) v(gc4_e4_vms) v(gc4_e5_h) v(gc4_e5_kd1) v(gc4_e5_knb) v(gc4_e5_ko1) v(gc4_e5_ktail) v(gc4_e5_q) v(gc4_e5_qb) v(gc4_e5_rec) v(gc4_e5_rt) v(gc4_e5_vm) v(gc4_e5_vmd) v(gc4_e5_vms) v(gc4_e6_h) v(gc4_e6_kd1) v(gc4_e6_knb) v(gc4_e6_ko1) v(gc4_e6_ktail) v(gc4_e6_q) v(gc4_e6_qb) v(gc4_e6_rec) v(gc4_e6_rt) v(gc4_e6_vm) v(gc4_e6_vmd) v(gc4_e6_vms) v(gc4_e7_h) v(gc4_e7_kd1) v(gc4_e7_knb) v(gc4_e7_ko1) v(gc4_e7_ktail) v(gc4_e7_q) v(gc4_e7_qb) v(gc4_e7_rec) v(gc4_e7_rt) v(gc4_e7_vm) v(gc4_e7_vmd) v(gc4_e7_vms) v(gc4_e8_h) v(gc4_e8_kd1) v(gc4_e8_knb) v(gc4_e8_ko1) v(gc4_e8_ktail) v(gc4_e8_q) v(gc4_e8_qb) v(gc4_e8_rec) v(gc4_e8_rt) v(gc4_e8_vm) v(gc4_e8_vmd) v(gc4_e8_vms) v(gc4_e9_h) v(gc4_e9_kd1) v(gc4_e9_knb) v(gc4_e9_ko1) v(gc4_e9_ktail) v(gc4_e9_q) v(gc4_e9_qb) v(gc4_e9_rec) v(gc4_e9_rt) v(gc4_e9_vm) v(gc4_e9_vmd) v(gc4_e9_vms) v(gc4_gb) v(gc4_op_ad) v(gc4_op_adn) v(gc4_op_an) v(gc4_op_aq) v(gc4_op_aqb) v(gc4_op_at) v(gc4_op_gx) v(gc4_op_p) v(gc4_op_pb) v(gc4_op_tt) v(gw1_and_a0_nb) v(gw1_and_a0_nx) v(gw1_and_a1_nb) v(gw1_and_a1_nx) v(gw1_and_a2_nb) v(gw1_and_a2_nx) v(gw1_and_a3_nb) v(gw1_and_a3_nx) v(gw1_and_a4_nb) v(gw1_and_a4_nx) v(gw1_and_a5_nb) v(gw1_and_a5_nx) v(gw1_and_a6_nb) v(gw1_and_a6_nx) v(gw1_and_a7_nb) v(gw1_and_a7_nx) v(gw1_and_a8_nb) v(gw1_and_a8_nx) v(gw1_and_g0) v(gw1_and_g1) v(gw1_and_g2) v(gw1_and_g3) v(gw1_and_g4) v(gw1_and_g5) v(gw1_and_g6) v(gw1_and_g7) v(gw1_and_g8) v(gw1_b1) v(gw1_b10) v(gw1_b10_n) v(gw1_b10_q) v(gw1_b10_t) v(gw1_b1_n) v(gw1_b1_q) v(gw1_b1_t) v(gw1_b2) v(gw1_b2_n) v(gw1_b2_q) v(gw1_b2_t) v(gw1_b3) v(gw1_b3_n) v(gw1_b3_q) v(gw1_b3_t) v(gw1_b4) v(gw1_b4_n) v(gw1_b4_q) v(gw1_b4_t) v(gw1_b5) v(gw1_b5_n) v(gw1_b5_q) v(gw1_b5_t) v(gw1_b6) v(gw1_b6_n) v(gw1_b6_q) v(gw1_b6_t) v(gw1_b7) v(gw1_b7_n) v(gw1_b7_q) v(gw1_b7_t) v(gw1_b8) v(gw1_b8_n) v(gw1_b8_q) v(gw1_b8_t) v(gw1_b9) v(gw1_b9_n) v(gw1_b9_q) v(gw1_b9_t) v(gw1_cin_cg) v(gw1_cin_ena) v(gw1_col_h) v(gw1_col_kd1) v(gw1_col_knb) v(gw1_col_ko1) v(gw1_col_ktail) v(gw1_col_q) v(gw1_col_qb) v(gw1_col_rec) v(gw1_col_rt) v(gw1_col_vm) v(gw1_col_vmd) v(gw1_col_vms) v(gw1_e10_h) v(gw1_e10_kd1) v(gw1_e10_knb) v(gw1_e10_ko1) v(gw1_e10_ktail) v(gw1_e10_q) v(gw1_e10_qb) v(gw1_e10_rec) v(gw1_e10_rt) v(gw1_e10_vm) v(gw1_e10_vmd) v(gw1_e10_vms) v(gw1_e1_h) v(gw1_e1_kd1) v(gw1_e1_knb) v(gw1_e1_ko1) v(gw1_e1_ktail) v(gw1_e1_q) v(gw1_e1_qb) v(gw1_e1_rec) v(gw1_e1_rt) v(gw1_e1_vm) v(gw1_e1_vmd) v(gw1_e1_vms) v(gw1_e2_h) v(gw1_e2_kd1) v(gw1_e2_knb) v(gw1_e2_ko1) v(gw1_e2_ktail) v(gw1_e2_q) v(gw1_e2_qb) v(gw1_e2_rec) v(gw1_e2_rt) v(gw1_e2_vm) v(gw1_e2_vmd) v(gw1_e2_vms) v(gw1_e3_h) v(gw1_e3_kd1) v(gw1_e3_knb) v(gw1_e3_ko1) v(gw1_e3_ktail) v(gw1_e3_q) v(gw1_e3_qb) v(gw1_e3_rec) v(gw1_e3_rt) v(gw1_e3_vm) v(gw1_e3_vmd) v(gw1_e3_vms) v(gw1_e4_h) v(gw1_e4_kd1) v(gw1_e4_knb) v(gw1_e4_ko1) v(gw1_e4_ktail) v(gw1_e4_q) v(gw1_e4_qb) v(gw1_e4_rec) v(gw1_e4_rt) v(gw1_e4_vm) v(gw1_e4_vmd) v(gw1_e4_vms) v(gw1_e5_h) v(gw1_e5_kd1) v(gw1_e5_knb) v(gw1_e5_ko1) v(gw1_e5_ktail) v(gw1_e5_q) v(gw1_e5_qb) v(gw1_e5_rec) v(gw1_e5_rt) v(gw1_e5_vm) v(gw1_e5_vmd) v(gw1_e5_vms) v(gw1_e6_h) v(gw1_e6_kd1) v(gw1_e6_knb) v(gw1_e6_ko1) v(gw1_e6_ktail) v(gw1_e6_q) v(gw1_e6_qb) v(gw1_e6_rec) v(gw1_e6_rt) v(gw1_e6_vm) v(gw1_e6_vmd) v(gw1_e6_vms) v(gw1_e7_h) v(gw1_e7_kd1) v(gw1_e7_knb) v(gw1_e7_ko1) v(gw1_e7_ktail) v(gw1_e7_q) v(gw1_e7_qb) v(gw1_e7_rec) v(gw1_e7_rt) v(gw1_e7_vm) v(gw1_e7_vmd) v(gw1_e7_vms) v(gw1_e8_h) v(gw1_e8_kd1) v(gw1_e8_knb) v(gw1_e8_ko1) v(gw1_e8_ktail) v(gw1_e8_q) v(gw1_e8_qb) v(gw1_e8_rec) v(gw1_e8_rt) v(gw1_e8_vm) v(gw1_e8_vmd) v(gw1_e8_vms) v(gw1_e9_h) v(gw1_e9_kd1) v(gw1_e9_knb) v(gw1_e9_ko1) v(gw1_e9_ktail) v(gw1_e9_q) v(gw1_e9_qb) v(gw1_e9_rec) v(gw1_e9_rt) v(gw1_e9_vm) v(gw1_e9_vmd) v(gw1_e9_vms) v(gw1_gb) v(gw1_op_ad) v(gw1_op_adn) v(gw1_op_an) v(gw1_op_aq) v(gw1_op_aqb) v(gw1_op_at) v(gw1_op_gx) v(gw1_op_p) v(gw1_op_pb) v(gw1_op_tt) v(gw2_and_a0_nb) v(gw2_and_a0_nx) v(gw2_and_a1_nb) v(gw2_and_a1_nx) v(gw2_and_a2_nb) v(gw2_and_a2_nx) v(gw2_and_a3_nb) v(gw2_and_a3_nx) v(gw2_and_a4_nb) v(gw2_and_a4_nx) v(gw2_and_a5_nb) v(gw2_and_a5_nx) v(gw2_and_a6_nb) v(gw2_and_a6_nx) v(gw2_and_a7_nb) v(gw2_and_a7_nx) v(gw2_and_a8_nb) v(gw2_and_a8_nx) v(gw2_and_g0) v(gw2_and_g1) v(gw2_and_g2) v(gw2_and_g3) v(gw2_and_g4) v(gw2_and_g5) v(gw2_and_g6) v(gw2_and_g7) v(gw2_and_g8) v(gw2_b1) v(gw2_b10) v(gw2_b10_n) v(gw2_b10_q) v(gw2_b10_t) v(gw2_b1_n) v(gw2_b1_q) v(gw2_b1_t) v(gw2_b2) v(gw2_b2_n) v(gw2_b2_q) v(gw2_b2_t) v(gw2_b3) v(gw2_b3_n) v(gw2_b3_q) v(gw2_b3_t) v(gw2_b4) v(gw2_b4_n) v(gw2_b4_q) v(gw2_b4_t) v(gw2_b5) v(gw2_b5_n) v(gw2_b5_q) v(gw2_b5_t) v(gw2_b6) v(gw2_b6_n) v(gw2_b6_q) v(gw2_b6_t) v(gw2_b7) v(gw2_b7_n) v(gw2_b7_q) v(gw2_b7_t) v(gw2_b8) v(gw2_b8_n) v(gw2_b8_q) v(gw2_b8_t) v(gw2_b9) v(gw2_b9_n) v(gw2_b9_q) v(gw2_b9_t) v(gw2_cin_cg) v(gw2_cin_ena) v(gw2_col_h) v(gw2_col_kd1) v(gw2_col_knb) v(gw2_col_ko1) v(gw2_col_ktail) v(gw2_col_q) v(gw2_col_qb) v(gw2_col_rec) v(gw2_col_rt) v(gw2_col_vm) v(gw2_col_vmd) v(gw2_col_vms) v(gw2_e10_h) v(gw2_e10_kd1) v(gw2_e10_knb) v(gw2_e10_ko1) v(gw2_e10_ktail) v(gw2_e10_q) v(gw2_e10_qb) v(gw2_e10_rec) v(gw2_e10_rt) v(gw2_e10_vm) v(gw2_e10_vmd) v(gw2_e10_vms) v(gw2_e1_h) v(gw2_e1_kd1) v(gw2_e1_knb) v(gw2_e1_ko1) v(gw2_e1_ktail) v(gw2_e1_q) v(gw2_e1_qb) v(gw2_e1_rec) v(gw2_e1_rt) v(gw2_e1_vm) v(gw2_e1_vmd) v(gw2_e1_vms) v(gw2_e2_h) v(gw2_e2_kd1) v(gw2_e2_knb) v(gw2_e2_ko1) v(gw2_e2_ktail) v(gw2_e2_q) v(gw2_e2_qb) v(gw2_e2_rec) v(gw2_e2_rt) v(gw2_e2_vm) v(gw2_e2_vmd) v(gw2_e2_vms) v(gw2_e3_h) v(gw2_e3_kd1) v(gw2_e3_knb) v(gw2_e3_ko1) v(gw2_e3_ktail) v(gw2_e3_q) v(gw2_e3_qb) v(gw2_e3_rec) v(gw2_e3_rt) v(gw2_e3_vm) v(gw2_e3_vmd) v(gw2_e3_vms) v(gw2_e4_h) v(gw2_e4_kd1) v(gw2_e4_knb) v(gw2_e4_ko1) v(gw2_e4_ktail) v(gw2_e4_q) v(gw2_e4_qb) v(gw2_e4_rec) v(gw2_e4_rt) v(gw2_e4_vm) v(gw2_e4_vmd) v(gw2_e4_vms) v(gw2_e5_h) v(gw2_e5_kd1) v(gw2_e5_knb) v(gw2_e5_ko1) v(gw2_e5_ktail) v(gw2_e5_q) v(gw2_e5_qb) v(gw2_e5_rec) v(gw2_e5_rt) v(gw2_e5_vm) v(gw2_e5_vmd) v(gw2_e5_vms) v(gw2_e6_h) v(gw2_e6_kd1) v(gw2_e6_knb) v(gw2_e6_ko1) v(gw2_e6_ktail) v(gw2_e6_q) v(gw2_e6_qb) v(gw2_e6_rec) v(gw2_e6_rt) v(gw2_e6_vm) v(gw2_e6_vmd) v(gw2_e6_vms) v(gw2_e7_h) v(gw2_e7_kd1) v(gw2_e7_knb) v(gw2_e7_ko1) v(gw2_e7_ktail) v(gw2_e7_q) v(gw2_e7_qb) v(gw2_e7_rec) v(gw2_e7_rt) v(gw2_e7_vm) v(gw2_e7_vmd) v(gw2_e7_vms) v(gw2_e8_h) v(gw2_e8_kd1) v(gw2_e8_knb) v(gw2_e8_ko1) v(gw2_e8_ktail) v(gw2_e8_q) v(gw2_e8_qb) v(gw2_e8_rec) v(gw2_e8_rt) v(gw2_e8_vm) v(gw2_e8_vmd) v(gw2_e8_vms) v(gw2_e9_h) v(gw2_e9_kd1) v(gw2_e9_knb) v(gw2_e9_ko1) v(gw2_e9_ktail) v(gw2_e9_q) v(gw2_e9_qb) v(gw2_e9_rec) v(gw2_e9_rt) v(gw2_e9_vm) v(gw2_e9_vmd) v(gw2_e9_vms) v(gw2_gb) v(gw2_op_ad) v(gw2_op_adn) v(gw2_op_an) v(gw2_op_aq) v(gw2_op_aqb) v(gw2_op_at) v(gw2_op_gx) v(gw2_op_p) v(gw2_op_pb) v(gw2_op_tt) v(gw3_and_a0_nb) v(gw3_and_a0_nx) v(gw3_and_a1_nb) v(gw3_and_a1_nx) v(gw3_and_a2_nb) v(gw3_and_a2_nx) v(gw3_and_a3_nb) v(gw3_and_a3_nx) v(gw3_and_a4_nb) v(gw3_and_a4_nx) v(gw3_and_a5_nb) v(gw3_and_a5_nx) v(gw3_and_a6_nb) v(gw3_and_a6_nx) v(gw3_and_a7_nb) v(gw3_and_a7_nx) v(gw3_and_a8_nb) v(gw3_and_a8_nx) v(gw3_and_g0) v(gw3_and_g1) v(gw3_and_g2) v(gw3_and_g3) v(gw3_and_g4) v(gw3_and_g5) v(gw3_and_g6) v(gw3_and_g7) v(gw3_and_g8) v(gw3_b1) v(gw3_b10) v(gw3_b10_n) v(gw3_b10_q) v(gw3_b10_t) v(gw3_b1_n) v(gw3_b1_q) v(gw3_b1_t) v(gw3_b2) v(gw3_b2_n) v(gw3_b2_q) v(gw3_b2_t) v(gw3_b3) v(gw3_b3_n) v(gw3_b3_q) v(gw3_b3_t) v(gw3_b4) v(gw3_b4_n) v(gw3_b4_q) v(gw3_b4_t) v(gw3_b5) v(gw3_b5_n) v(gw3_b5_q) v(gw3_b5_t) v(gw3_b6) v(gw3_b6_n) v(gw3_b6_q) v(gw3_b6_t) v(gw3_b7) v(gw3_b7_n) v(gw3_b7_q) v(gw3_b7_t) v(gw3_b8) v(gw3_b8_n) v(gw3_b8_q) v(gw3_b8_t) v(gw3_b9) v(gw3_b9_n) v(gw3_b9_q) v(gw3_b9_t) v(gw3_cin_cg) v(gw3_cin_ena) v(gw3_col_h) v(gw3_col_kd1) v(gw3_col_knb) v(gw3_col_ko1) v(gw3_col_ktail) v(gw3_col_q) v(gw3_col_qb) v(gw3_col_rec) v(gw3_col_rt) v(gw3_col_vm) v(gw3_col_vmd) v(gw3_col_vms) v(gw3_e10_h) v(gw3_e10_kd1) v(gw3_e10_knb) v(gw3_e10_ko1) v(gw3_e10_ktail) v(gw3_e10_q) v(gw3_e10_qb) v(gw3_e10_rec) v(gw3_e10_rt) v(gw3_e10_vm) v(gw3_e10_vmd) v(gw3_e10_vms) v(gw3_e1_h) v(gw3_e1_kd1) v(gw3_e1_knb) v(gw3_e1_ko1) v(gw3_e1_ktail) v(gw3_e1_q) v(gw3_e1_qb) v(gw3_e1_rec) v(gw3_e1_rt) v(gw3_e1_vm) v(gw3_e1_vmd) v(gw3_e1_vms) v(gw3_e2_h) v(gw3_e2_kd1) v(gw3_e2_knb) v(gw3_e2_ko1) v(gw3_e2_ktail) v(gw3_e2_q) v(gw3_e2_qb) v(gw3_e2_rec) v(gw3_e2_rt) v(gw3_e2_vm) v(gw3_e2_vmd) v(gw3_e2_vms) v(gw3_e3_h) v(gw3_e3_kd1) v(gw3_e3_knb) v(gw3_e3_ko1) v(gw3_e3_ktail) v(gw3_e3_q) v(gw3_e3_qb) v(gw3_e3_rec) v(gw3_e3_rt) v(gw3_e3_vm) v(gw3_e3_vmd) v(gw3_e3_vms) v(gw3_e4_h) v(gw3_e4_kd1) v(gw3_e4_knb) v(gw3_e4_ko1) v(gw3_e4_ktail) v(gw3_e4_q) v(gw3_e4_qb) v(gw3_e4_rec) v(gw3_e4_rt) v(gw3_e4_vm) v(gw3_e4_vmd) v(gw3_e4_vms) v(gw3_e5_h) v(gw3_e5_kd1) v(gw3_e5_knb) v(gw3_e5_ko1) v(gw3_e5_ktail) v(gw3_e5_q) v(gw3_e5_qb) v(gw3_e5_rec) v(gw3_e5_rt) v(gw3_e5_vm) v(gw3_e5_vmd) v(gw3_e5_vms) v(gw3_e6_h) v(gw3_e6_kd1) v(gw3_e6_knb) v(gw3_e6_ko1) v(gw3_e6_ktail) v(gw3_e6_q) v(gw3_e6_qb) v(gw3_e6_rec) v(gw3_e6_rt) v(gw3_e6_vm) v(gw3_e6_vmd) v(gw3_e6_vms) v(gw3_e7_h) v(gw3_e7_kd1) v(gw3_e7_knb) v(gw3_e7_ko1) v(gw3_e7_ktail) v(gw3_e7_q) v(gw3_e7_qb) v(gw3_e7_rec) v(gw3_e7_rt) v(gw3_e7_vm) v(gw3_e7_vmd) v(gw3_e7_vms) v(gw3_e8_h) v(gw3_e8_kd1) v(gw3_e8_knb) v(gw3_e8_ko1) v(gw3_e8_ktail) v(gw3_e8_q) v(gw3_e8_qb) v(gw3_e8_rec) v(gw3_e8_rt) v(gw3_e8_vm) v(gw3_e8_vmd) v(gw3_e8_vms) v(gw3_e9_h) v(gw3_e9_kd1) v(gw3_e9_knb) v(gw3_e9_ko1) v(gw3_e9_ktail) v(gw3_e9_q) v(gw3_e9_qb) v(gw3_e9_rec) v(gw3_e9_rt) v(gw3_e9_vm) v(gw3_e9_vmd) v(gw3_e9_vms) v(gw3_gb) v(gw3_op_ad) v(gw3_op_adn) v(gw3_op_an) v(gw3_op_aq) v(gw3_op_aqb) v(gw3_op_at) v(gw3_op_gx) v(gw3_op_p) v(gw3_op_pb) v(gw3_op_tt) v(gw4_and_a0_nb) v(gw4_and_a0_nx) v(gw4_and_a1_nb) v(gw4_and_a1_nx) v(gw4_and_a2_nb) v(gw4_and_a2_nx) v(gw4_and_a3_nb) v(gw4_and_a3_nx) v(gw4_and_a4_nb) v(gw4_and_a4_nx) v(gw4_and_a5_nb) v(gw4_and_a5_nx) v(gw4_and_a6_nb) v(gw4_and_a6_nx) v(gw4_and_a7_nb) v(gw4_and_a7_nx) v(gw4_and_a8_nb) v(gw4_and_a8_nx) v(gw4_and_g0) v(gw4_and_g1) v(gw4_and_g2) v(gw4_and_g3) v(gw4_and_g4) v(gw4_and_g5) v(gw4_and_g6) v(gw4_and_g7) v(gw4_and_g8) v(gw4_b1) v(gw4_b10) v(gw4_b10_n) v(gw4_b10_q) v(gw4_b10_t) v(gw4_b1_n) v(gw4_b1_q) v(gw4_b1_t) v(gw4_b2) v(gw4_b2_n) v(gw4_b2_q) v(gw4_b2_t) v(gw4_b3) v(gw4_b3_n) v(gw4_b3_q) v(gw4_b3_t) v(gw4_b4) v(gw4_b4_n) v(gw4_b4_q) v(gw4_b4_t) v(gw4_b5) v(gw4_b5_n) v(gw4_b5_q) v(gw4_b5_t) v(gw4_b6) v(gw4_b6_n) v(gw4_b6_q) v(gw4_b6_t) v(gw4_b7) v(gw4_b7_n) v(gw4_b7_q) v(gw4_b7_t) v(gw4_b8) v(gw4_b8_n) v(gw4_b8_q) v(gw4_b8_t) v(gw4_b9) v(gw4_b9_n) v(gw4_b9_q) v(gw4_b9_t) v(gw4_cin_cg) v(gw4_cin_ena) v(gw4_col_h) v(gw4_col_kd1) v(gw4_col_knb) v(gw4_col_ko1) v(gw4_col_ktail) v(gw4_col_q) v(gw4_col_qb) v(gw4_col_rec) v(gw4_col_rt) v(gw4_col_vm) v(gw4_col_vmd) v(gw4_col_vms) v(gw4_e10_h) v(gw4_e10_kd1) v(gw4_e10_knb) v(gw4_e10_ko1) v(gw4_e10_ktail) v(gw4_e10_q) v(gw4_e10_qb) v(gw4_e10_rec) v(gw4_e10_rt) v(gw4_e10_vm) v(gw4_e10_vmd) v(gw4_e10_vms) v(gw4_e1_h) v(gw4_e1_kd1) v(gw4_e1_knb) v(gw4_e1_ko1) v(gw4_e1_ktail) v(gw4_e1_q) v(gw4_e1_qb) v(gw4_e1_rec) v(gw4_e1_rt) v(gw4_e1_vm) v(gw4_e1_vmd) v(gw4_e1_vms) v(gw4_e2_h) v(gw4_e2_kd1) v(gw4_e2_knb) v(gw4_e2_ko1) v(gw4_e2_ktail) v(gw4_e2_q) v(gw4_e2_qb) v(gw4_e2_rec) v(gw4_e2_rt) v(gw4_e2_vm) v(gw4_e2_vmd) v(gw4_e2_vms) v(gw4_e3_h) v(gw4_e3_kd1) v(gw4_e3_knb) v(gw4_e3_ko1) v(gw4_e3_ktail) v(gw4_e3_q) v(gw4_e3_qb) v(gw4_e3_rec) v(gw4_e3_rt) v(gw4_e3_vm) v(gw4_e3_vmd) v(gw4_e3_vms) v(gw4_e4_h) v(gw4_e4_kd1) v(gw4_e4_knb) v(gw4_e4_ko1) v(gw4_e4_ktail) v(gw4_e4_q) v(gw4_e4_qb) v(gw4_e4_rec) v(gw4_e4_rt) v(gw4_e4_vm) v(gw4_e4_vmd) v(gw4_e4_vms) v(gw4_e5_h) v(gw4_e5_kd1) v(gw4_e5_knb) v(gw4_e5_ko1) v(gw4_e5_ktail) v(gw4_e5_q) v(gw4_e5_qb) v(gw4_e5_rec) v(gw4_e5_rt) v(gw4_e5_vm) v(gw4_e5_vmd) v(gw4_e5_vms) v(gw4_e6_h) v(gw4_e6_kd1) v(gw4_e6_knb) v(gw4_e6_ko1) v(gw4_e6_ktail) v(gw4_e6_q) v(gw4_e6_qb) v(gw4_e6_rec) v(gw4_e6_rt) v(gw4_e6_vm) v(gw4_e6_vmd) v(gw4_e6_vms) v(gw4_e7_h) v(gw4_e7_kd1) v(gw4_e7_knb) v(gw4_e7_ko1) v(gw4_e7_ktail) v(gw4_e7_q) v(gw4_e7_qb) v(gw4_e7_rec) v(gw4_e7_rt) v(gw4_e7_vm) v(gw4_e7_vmd) v(gw4_e7_vms) v(gw4_e8_h) v(gw4_e8_kd1) v(gw4_e8_knb) v(gw4_e8_ko1) v(gw4_e8_ktail) v(gw4_e8_q) v(gw4_e8_qb) v(gw4_e8_rec) v(gw4_e8_rt) v(gw4_e8_vm) v(gw4_e8_vmd) v(gw4_e8_vms) v(gw4_e9_h) v(gw4_e9_kd1) v(gw4_e9_knb) v(gw4_e9_ko1) v(gw4_e9_ktail) v(gw4_e9_q) v(gw4_e9_qb) v(gw4_e9_rec) v(gw4_e9_rt) v(gw4_e9_vm) v(gw4_e9_vmd) v(gw4_e9_vms) v(gw4_gb) v(gw4_op_ad) v(gw4_op_adn) v(gw4_op_an) v(gw4_op_aq) v(gw4_op_aqb) v(gw4_op_at) v(gw4_op_gx) v(gw4_op_p) v(gw4_op_pb) v(gw4_op_tt) v(hc1) v(hc2) v(hc3) v(hc4) v(hsc1_h1) v(hsc1_sd) v(hsc2_h1) v(hsc2_sd) v(hsc3_h1) v(hsc3_sd) v(hsc4_h1) v(hsc4_sd) v(hsw1_h1) v(hsw1_sd) v(hsw2_h1) v(hsw2_sd) v(hsw3_h1) v(hsw3_sd) v(hsw4_h1) v(hsw4_sd) v(hw1) v(hw2) v(hw3) v(hw4) v(load_neg) v(load_pos) v(por_hold) v(por_ok) v(porc) v(porx) v(s1_anb) v(s1_atl) v(s1_da) v(s1_db) v(s1_m) v(s1_s) v(s1_tl) v(s1_ya) v(s1_yb) v(s1_za) v(s1_zb) v(s2_anb) v(s2_atl) v(s2_da) v(s2_db) v(s2_m) v(s2_s) v(s2_tl) v(s2_ya) v(s2_yb) v(s2_za) v(s2_zb) v(s3_anb) v(s3_atl) v(s3_da) v(s3_db) v(s3_m) v(s3_s) v(s3_tl) v(s3_ya) v(s3_yb) v(s3_za) v(s3_zb) v(s4_anb) v(s4_atl) v(s4_da) v(s4_db) v(s4_m) v(s4_s) v(s4_tl) v(s4_ya) v(s4_yb) v(s4_za) v(s4_zb) v(sgc12f_h) v(sgc12f_kd1) v(sgc12f_knb) v(sgc12f_ko1) v(sgc12f_ktail) v(sgc12f_op_ad) v(sgc12f_op_adn) v(sgc12f_op_an) v(sgc12f_op_aq) v(sgc12f_op_aqb) v(sgc12f_op_at) v(sgc12f_op_gx) v(sgc12f_op_p) v(sgc12f_op_pb) v(sgc12f_op_tt) v(sgc12f_ota_d1) v(sgc12f_ota_nb) v(sgc12f_ota_tail) v(sgc12f_q) v(sgc12f_qb) v(sgc12f_rec) v(sgc12f_rt) v(sgc12f_vm) v(sgc12f_vmd) v(sgc12f_vms) v(sgc12r_h) v(sgc12r_kd1) v(sgc12r_knb) v(sgc12r_ko1) v(sgc12r_ktail) v(sgc12r_op_ad) v(sgc12r_op_adn) v(sgc12r_op_an) v(sgc12r_op_aq) v(sgc12r_op_aqb) v(sgc12r_op_at) v(sgc12r_op_gx) v(sgc12r_op_p) v(sgc12r_op_pb) v(sgc12r_op_tt) v(sgc12r_ota_d1) v(sgc12r_ota_nb) v(sgc12r_ota_tail) v(sgc12r_q) v(sgc12r_qb) v(sgc12r_rec) v(sgc12r_rt) v(sgc12r_vm) v(sgc12r_vmd) v(sgc12r_vms) v(sgc23f_h) v(sgc23f_kd1) v(sgc23f_knb) v(sgc23f_ko1) v(sgc23f_ktail) v(sgc23f_op_ad) v(sgc23f_op_adn) v(sgc23f_op_an) v(sgc23f_op_aq) v(sgc23f_op_aqb) v(sgc23f_op_at) v(sgc23f_op_gx) v(sgc23f_op_p) v(sgc23f_op_pb) v(sgc23f_op_tt) v(sgc23f_ota_d1) v(sgc23f_ota_nb) v(sgc23f_ota_tail) v(sgc23f_q) v(sgc23f_qb) v(sgc23f_rec) v(sgc23f_rt) v(sgc23f_vm) v(sgc23f_vmd) v(sgc23f_vms) v(sgc23r_h) v(sgc23r_kd1) v(sgc23r_knb) v(sgc23r_ko1) v(sgc23r_ktail) v(sgc23r_op_ad) v(sgc23r_op_adn) v(sgc23r_op_an) v(sgc23r_op_aq) v(sgc23r_op_aqb) v(sgc23r_op_at) v(sgc23r_op_gx) v(sgc23r_op_p) v(sgc23r_op_pb) v(sgc23r_op_tt) v(sgc23r_ota_d1) v(sgc23r_ota_nb) v(sgc23r_ota_tail) v(sgc23r_q) v(sgc23r_qb) v(sgc23r_rec) v(sgc23r_rt) v(sgc23r_vm) v(sgc23r_vmd) v(sgc23r_vms) v(sgc34f_h) v(sgc34f_kd1) v(sgc34f_knb) v(sgc34f_ko1) v(sgc34f_ktail) v(sgc34f_op_ad) v(sgc34f_op_adn) v(sgc34f_op_an) v(sgc34f_op_aq) v(sgc34f_op_aqb) v(sgc34f_op_at) v(sgc34f_op_gx) v(sgc34f_op_p) v(sgc34f_op_pb) v(sgc34f_op_tt) v(sgc34f_ota_d1) v(sgc34f_ota_nb) v(sgc34f_ota_tail) v(sgc34f_q) v(sgc34f_qb) v(sgc34f_rec) v(sgc34f_rt) v(sgc34f_vm) v(sgc34f_vmd) v(sgc34f_vms) v(sgc34r_h) v(sgc34r_kd1) v(sgc34r_knb) v(sgc34r_ko1) v(sgc34r_ktail) v(sgc34r_op_ad) v(sgc34r_op_adn) v(sgc34r_op_an) v(sgc34r_op_aq) v(sgc34r_op_aqb) v(sgc34r_op_at) v(sgc34r_op_gx) v(sgc34r_op_p) v(sgc34r_op_pb) v(sgc34r_op_tt) v(sgc34r_ota_d1) v(sgc34r_ota_nb) v(sgc34r_ota_tail) v(sgc34r_q) v(sgc34r_qb) v(sgc34r_rec) v(sgc34r_rt) v(sgc34r_vm) v(sgc34r_vmd) v(sgc34r_vms) v(sgw12f_h) v(sgw12f_kd1) v(sgw12f_knb) v(sgw12f_ko1) v(sgw12f_ktail) v(sgw12f_op_ad) v(sgw12f_op_adn) v(sgw12f_op_an) v(sgw12f_op_aq) v(sgw12f_op_aqb) v(sgw12f_op_at) v(sgw12f_op_gx) v(sgw12f_op_p) v(sgw12f_op_pb) v(sgw12f_op_tt) v(sgw12f_ota_d1) v(sgw12f_ota_nb) v(sgw12f_ota_tail) v(sgw12f_q) v(sgw12f_qb) v(sgw12f_rec) v(sgw12f_rt) v(sgw12f_vm) v(sgw12f_vmd) v(sgw12f_vms) v(sgw12r_h) v(sgw12r_kd1) v(sgw12r_knb) v(sgw12r_ko1) v(sgw12r_ktail) v(sgw12r_op_ad) v(sgw12r_op_adn) v(sgw12r_op_an) v(sgw12r_op_aq) v(sgw12r_op_aqb) v(sgw12r_op_at) v(sgw12r_op_gx) v(sgw12r_op_p) v(sgw12r_op_pb) v(sgw12r_op_tt) v(sgw12r_ota_d1) v(sgw12r_ota_nb) v(sgw12r_ota_tail) v(sgw12r_q) v(sgw12r_qb) v(sgw12r_rec) v(sgw12r_rt) v(sgw12r_vm) v(sgw12r_vmd) v(sgw12r_vms) v(sgw23f_h) v(sgw23f_kd1) v(sgw23f_knb) v(sgw23f_ko1) v(sgw23f_ktail) v(sgw23f_op_ad) v(sgw23f_op_adn) v(sgw23f_op_an) v(sgw23f_op_aq) v(sgw23f_op_aqb) v(sgw23f_op_at) v(sgw23f_op_gx) v(sgw23f_op_p) v(sgw23f_op_pb) v(sgw23f_op_tt) v(sgw23f_ota_d1) v(sgw23f_ota_nb) v(sgw23f_ota_tail) v(sgw23f_q) v(sgw23f_qb) v(sgw23f_rec) v(sgw23f_rt) v(sgw23f_vm) v(sgw23f_vmd) v(sgw23f_vms) v(sgw23r_h) v(sgw23r_kd1) v(sgw23r_knb) v(sgw23r_ko1) v(sgw23r_ktail) v(sgw23r_op_ad) v(sgw23r_op_adn) v(sgw23r_op_an) v(sgw23r_op_aq) v(sgw23r_op_aqb) v(sgw23r_op_at) v(sgw23r_op_gx) v(sgw23r_op_p) v(sgw23r_op_pb) v(sgw23r_op_tt) v(sgw23r_ota_d1) v(sgw23r_ota_nb) v(sgw23r_ota_tail) v(sgw23r_q) v(sgw23r_qb) v(sgw23r_rec) v(sgw23r_rt) v(sgw23r_vm) v(sgw23r_vmd) v(sgw23r_vms) v(sgw34f_h) v(sgw34f_kd1) v(sgw34f_knb) v(sgw34f_ko1) v(sgw34f_ktail) v(sgw34f_op_ad) v(sgw34f_op_adn) v(sgw34f_op_an) v(sgw34f_op_aq) v(sgw34f_op_aqb) v(sgw34f_op_at) v(sgw34f_op_gx) v(sgw34f_op_p) v(sgw34f_op_pb) v(sgw34f_op_tt) v(sgw34f_ota_d1) v(sgw34f_ota_nb) v(sgw34f_ota_tail) v(sgw34f_q) v(sgw34f_qb) v(sgw34f_rec) v(sgw34f_rt) v(sgw34f_vm) v(sgw34f_vmd) v(sgw34f_vms) v(sgw34r_h) v(sgw34r_kd1) v(sgw34r_knb) v(sgw34r_ko1) v(sgw34r_ktail) v(sgw34r_op_ad) v(sgw34r_op_adn) v(sgw34r_op_an) v(sgw34r_op_aq) v(sgw34r_op_aqb) v(sgw34r_op_at) v(sgw34r_op_gx) v(sgw34r_op_p) v(sgw34r_op_pb) v(sgw34r_op_tt) v(sgw34r_ota_d1) v(sgw34r_ota_nb) v(sgw34r_ota_tail) v(sgw34r_q) v(sgw34r_qb) v(sgw34r_rec) v(sgw34r_rt) v(sgw34r_vm) v(sgw34r_vmd) v(sgw34r_vms) v(spc1) v(spc2) v(spc3) v(spc4) v(spci1_cg) v(spci1_ena) v(spci2_cg) v(spci2_ena) v(spci3_cg) v(spci3_ena) v(spci4_cg) v(spci4_ena) v(spcs12) v(spcs23) v(spcs34) v(spw1) v(spw2) v(spw3) v(spw4) v(spwi1_cg) v(spwi1_ena) v(spwi2_cg) v(spwi2_ena) v(spwi3_cg) v(spwi3_ena) v(spwi4_cg) v(spwi4_ena) v(spws12) v(spws23) v(spws34) v(thc12f_h) v(thc12f_kd1) v(thc12f_knb) v(thc12f_ko1) v(thc12f_ktail) v(thc12f_mi) v(thc12f_op_ad) v(thc12f_op_adn) v(thc12f_op_an) v(thc12f_op_aq) v(thc12f_op_aqb) v(thc12f_op_at) v(thc12f_op_gx) v(thc12f_op_p) v(thc12f_op_pb) v(thc12f_op_tt) v(thc12f_q) v(thc12f_qb) v(thc12f_rec) v(thc12f_rt) v(thc12f_st_x) v(thc12f_vm) v(thc12f_vmd) v(thc12f_vms) v(thc12r_h) v(thc12r_kd1) v(thc12r_knb) v(thc12r_ko1) v(thc12r_ktail) v(thc12r_mi) v(thc12r_op_ad) v(thc12r_op_adn) v(thc12r_op_an) v(thc12r_op_aq) v(thc12r_op_aqb) v(thc12r_op_at) v(thc12r_op_gx) v(thc12r_op_p) v(thc12r_op_pb) v(thc12r_op_tt) v(thc12r_q) v(thc12r_qb) v(thc12r_rec) v(thc12r_rt) v(thc12r_st_x) v(thc12r_vm) v(thc12r_vmd) v(thc12r_vms) v(thc23f_h) v(thc23f_kd1) v(thc23f_knb) v(thc23f_ko1) v(thc23f_ktail) v(thc23f_mi) v(thc23f_op_ad) v(thc23f_op_adn) v(thc23f_op_an) v(thc23f_op_aq) v(thc23f_op_aqb) v(thc23f_op_at) v(thc23f_op_gx) v(thc23f_op_p) v(thc23f_op_pb) v(thc23f_op_tt) v(thc23f_q) v(thc23f_qb) v(thc23f_rec) v(thc23f_rt) v(thc23f_st_x) v(thc23f_vm) v(thc23f_vmd) v(thc23f_vms) v(thc23r_h) v(thc23r_kd1) v(thc23r_knb) v(thc23r_ko1) v(thc23r_ktail) v(thc23r_mi) v(thc23r_op_ad) v(thc23r_op_adn) v(thc23r_op_an) v(thc23r_op_aq) v(thc23r_op_aqb) v(thc23r_op_at) v(thc23r_op_gx) v(thc23r_op_p) v(thc23r_op_pb) v(thc23r_op_tt) v(thc23r_q) v(thc23r_qb) v(thc23r_rec) v(thc23r_rt) v(thc23r_st_x) v(thc23r_vm) v(thc23r_vmd) v(thc23r_vms) v(thc34f_h) v(thc34f_kd1) v(thc34f_knb) v(thc34f_ko1) v(thc34f_ktail) v(thc34f_mi) v(thc34f_op_ad) v(thc34f_op_adn) v(thc34f_op_an) v(thc34f_op_aq) v(thc34f_op_aqb) v(thc34f_op_at) v(thc34f_op_gx) v(thc34f_op_p) v(thc34f_op_pb) v(thc34f_op_tt) v(thc34f_q) v(thc34f_qb) v(thc34f_rec) v(thc34f_rt) v(thc34f_st_x) v(thc34f_vm) v(thc34f_vmd) v(thc34f_vms) v(thc34r_h) v(thc34r_kd1) v(thc34r_knb) v(thc34r_ko1) v(thc34r_ktail) v(thc34r_mi) v(thc34r_op_ad) v(thc34r_op_adn) v(thc34r_op_an) v(thc34r_op_aq) v(thc34r_op_aqb) v(thc34r_op_at) v(thc34r_op_gx) v(thc34r_op_p) v(thc34r_op_pb) v(thc34r_op_tt) v(thc34r_q) v(thc34r_qb) v(thc34r_rec) v(thc34r_rt) v(thc34r_st_x) v(thc34r_vm) v(thc34r_vmd) v(thc34r_vms) v(thw12f_h) v(thw12f_kd1) v(thw12f_knb) v(thw12f_ko1) v(thw12f_ktail) v(thw12f_mi) v(thw12f_op_ad) v(thw12f_op_adn) v(thw12f_op_an) v(thw12f_op_aq) v(thw12f_op_aqb) v(thw12f_op_at) v(thw12f_op_gx) v(thw12f_op_p) v(thw12f_op_pb) v(thw12f_op_tt) v(thw12f_q) v(thw12f_qb) v(thw12f_rec) v(thw12f_rt) v(thw12f_st_x) v(thw12f_vm) v(thw12f_vmd) v(thw12f_vms) v(thw12r_h) v(thw12r_kd1) v(thw12r_knb) v(thw12r_ko1) v(thw12r_ktail) v(thw12r_mi) v(thw12r_op_ad) v(thw12r_op_adn) v(thw12r_op_an) v(thw12r_op_aq) v(thw12r_op_aqb) v(thw12r_op_at) v(thw12r_op_gx) v(thw12r_op_p) v(thw12r_op_pb) v(thw12r_op_tt) v(thw12r_q) v(thw12r_qb) v(thw12r_rec) v(thw12r_rt) v(thw12r_st_x) v(thw12r_vm) v(thw12r_vmd) v(thw12r_vms) v(thw23f_h) v(thw23f_kd1) v(thw23f_knb) v(thw23f_ko1) v(thw23f_ktail) v(thw23f_mi) v(thw23f_op_ad) v(thw23f_op_adn) v(thw23f_op_an) v(thw23f_op_aq) v(thw23f_op_aqb) v(thw23f_op_at) v(thw23f_op_gx) v(thw23f_op_p) v(thw23f_op_pb) v(thw23f_op_tt) v(thw23f_q) v(thw23f_qb) v(thw23f_rec) v(thw23f_rt) v(thw23f_st_x) v(thw23f_vm) v(thw23f_vmd) v(thw23f_vms) v(thw23r_h) v(thw23r_kd1) v(thw23r_knb) v(thw23r_ko1) v(thw23r_ktail) v(thw23r_mi) v(thw23r_op_ad) v(thw23r_op_adn) v(thw23r_op_an) v(thw23r_op_aq) v(thw23r_op_aqb) v(thw23r_op_at) v(thw23r_op_gx) v(thw23r_op_p) v(thw23r_op_pb) v(thw23r_op_tt) v(thw23r_q) v(thw23r_qb) v(thw23r_rec) v(thw23r_rt) v(thw23r_st_x) v(thw23r_vm) v(thw23r_vmd) v(thw23r_vms) v(thw34f_h) v(thw34f_kd1) v(thw34f_knb) v(thw34f_ko1) v(thw34f_ktail) v(thw34f_mi) v(thw34f_op_ad) v(thw34f_op_adn) v(thw34f_op_an) v(thw34f_op_aq) v(thw34f_op_aqb) v(thw34f_op_at) v(thw34f_op_gx) v(thw34f_op_p) v(thw34f_op_pb) v(thw34f_op_tt) v(thw34f_q) v(thw34f_qb) v(thw34f_rec) v(thw34f_rt) v(thw34f_st_x) v(thw34f_vm) v(thw34f_vmd) v(thw34f_vms) v(thw34r_h) v(thw34r_kd1) v(thw34r_knb) v(thw34r_ko1) v(thw34r_ktail) v(thw34r_mi) v(thw34r_op_ad) v(thw34r_op_adn) v(thw34r_op_an) v(thw34r_op_aq) v(thw34r_op_aqb) v(thw34r_op_at) v(thw34r_op_gx) v(thw34r_op_p) v(thw34r_op_pb) v(thw34r_op_tt) v(thw34r_q) v(thw34r_qb) v(thw34r_rec) v(thw34r_rt) v(thw34r_st_x) v(thw34r_vm) v(thw34r_vmd) v(thw34r_vms) i(va_rvrestt_n) i(va_rvrestb_p) i(va_cvrestc_p) i(va_rgw1_e1_rm_n) i(va_rgw1_e1_rdis_n) i(va_ngw1_e1_sh2_s) i(va_ngw1_e1_porm_s) i(va_rgw1_e2_rm_n) i(va_rgw1_e2_rdis_n) i(va_ngw1_e2_sh2_s) i(va_ngw1_e2_porm_s) i(va_rgw1_e3_rm_n) i(va_rgw1_e3_rdis_n) i(va_ngw1_e3_sh2_s) i(va_ngw1_e3_porm_s) i(va_rgw1_e4_rm_n) i(va_rgw1_e4_rdis_n) i(va_ngw1_e4_sh2_s) i(va_ngw1_e4_porm_s) i(va_rgw1_e5_rm_n) i(va_rgw1_e5_rdis_n) i(va_ngw1_e5_sh2_s) i(va_ngw1_e5_porm_s) i(va_rgw1_e6_rm_n) i(va_rgw1_e6_rdis_n) i(va_ngw1_e6_sh2_s) i(va_ngw1_e6_porm_s) i(va_rgw1_e7_rm_n) i(va_rgw1_e7_rdis_n) i(va_ngw1_e7_sh2_s) i(va_ngw1_e7_porm_s) i(va_rgw1_e8_rm_n) i(va_rgw1_e8_rdis_n) i(va_ngw1_e8_sh2_s) i(va_ngw1_e8_porm_s) i(va_rgw1_e9_rm_n) i(va_rgw1_e9_rdis_n) i(va_ngw1_e9_sh2_s) i(va_ngw1_e9_porm_s) i(va_rgw1_e10_rm_n) i(va_rgw1_e10_rdis_n) i(va_ngw1_e10_sh2_s) i(va_ngw1_e10_porm_s) i(va_rgw1_col_rm_n) i(va_rgw1_col_rdis_n) i(va_ngw1_col_sh2_s) i(va_ngw1_col_porm_s) i(va_rgc1_e1_rm_n) i(va_rgc1_e1_rdis_n) i(va_ngc1_e1_sh2_s) i(va_ngc1_e1_porm_s) i(va_rgc1_e2_rm_n) i(va_rgc1_e2_rdis_n) i(va_ngc1_e2_sh2_s) i(va_ngc1_e2_porm_s) i(va_rgc1_e3_rm_n) i(va_rgc1_e3_rdis_n) i(va_ngc1_e3_sh2_s) i(va_ngc1_e3_porm_s) i(va_rgc1_e4_rm_n) i(va_rgc1_e4_rdis_n) i(va_ngc1_e4_sh2_s) i(va_ngc1_e4_porm_s) i(va_rgc1_e5_rm_n) i(va_rgc1_e5_rdis_n) i(va_ngc1_e5_sh2_s) i(va_ngc1_e5_porm_s) i(va_rgc1_e6_rm_n) i(va_rgc1_e6_rdis_n) i(va_ngc1_e6_sh2_s) i(va_ngc1_e6_porm_s) i(va_rgc1_e7_rm_n) i(va_rgc1_e7_rdis_n) i(va_ngc1_e7_sh2_s) i(va_ngc1_e7_porm_s) i(va_rgc1_e8_rm_n) i(va_rgc1_e8_rdis_n) i(va_ngc1_e8_sh2_s) i(va_ngc1_e8_porm_s) i(va_rgc1_e9_rm_n) i(va_rgc1_e9_rdis_n) i(va_ngc1_e9_sh2_s) i(va_ngc1_e9_porm_s) i(va_rgc1_e10_rm_n) i(va_rgc1_e10_rdis_n) i(va_ngc1_e10_sh2_s) i(va_ngc1_e10_porm_s) i(va_rgc1_col_rm_n) i(va_rgc1_col_rdis_n) i(va_ngc1_col_sh2_s) i(va_ngc1_col_porm_s) i(va_rgw2_e1_rm_n) i(va_rgw2_e1_rdis_n) i(va_ngw2_e1_sh2_s) i(va_ngw2_e1_porm_s) i(va_rgw2_e2_rm_n) i(va_rgw2_e2_rdis_n) i(va_ngw2_e2_sh2_s) i(va_ngw2_e2_porm_s) i(va_rgw2_e3_rm_n) i(va_rgw2_e3_rdis_n) i(va_ngw2_e3_sh2_s) i(va_ngw2_e3_porm_s) i(va_rgw2_e4_rm_n) i(va_rgw2_e4_rdis_n) i(va_ngw2_e4_sh2_s) i(va_ngw2_e4_porm_s) i(va_rgw2_e5_rm_n) i(va_rgw2_e5_rdis_n) i(va_ngw2_e5_sh2_s) i(va_ngw2_e5_porm_s) i(va_rgw2_e6_rm_n) i(va_rgw2_e6_rdis_n) i(va_ngw2_e6_sh2_s) i(va_ngw2_e6_porm_s) i(va_rgw2_e7_rm_n) i(va_rgw2_e7_rdis_n) i(va_ngw2_e7_sh2_s) i(va_ngw2_e7_porm_s) i(va_rgw2_e8_rm_n) i(va_rgw2_e8_rdis_n) i(va_ngw2_e8_sh2_s) i(va_ngw2_e8_porm_s) i(va_rgw2_e9_rm_n) i(va_rgw2_e9_rdis_n) i(va_ngw2_e9_sh2_s) i(va_ngw2_e9_porm_s) i(va_rgw2_e10_rm_n) i(va_rgw2_e10_rdis_n) i(va_ngw2_e10_sh2_s) i(va_ngw2_e10_porm_s) i(va_rgw2_col_rm_n) i(va_rgw2_col_rdis_n) i(va_ngw2_col_sh2_s) i(va_ngw2_col_porm_s) i(va_rgc2_e1_rm_n) i(va_rgc2_e1_rdis_n) i(va_ngc2_e1_sh2_s) i(va_ngc2_e1_porm_s) i(va_rgc2_e2_rm_n) i(va_rgc2_e2_rdis_n) i(va_ngc2_e2_sh2_s) i(va_ngc2_e2_porm_s) i(va_rgc2_e3_rm_n) i(va_rgc2_e3_rdis_n) i(va_ngc2_e3_sh2_s) i(va_ngc2_e3_porm_s) i(va_rgc2_e4_rm_n) i(va_rgc2_e4_rdis_n) i(va_ngc2_e4_sh2_s) i(va_ngc2_e4_porm_s) i(va_rgc2_e5_rm_n) i(va_rgc2_e5_rdis_n) i(va_ngc2_e5_sh2_s) i(va_ngc2_e5_porm_s) i(va_rgc2_e6_rm_n) i(va_rgc2_e6_rdis_n) i(va_ngc2_e6_sh2_s) i(va_ngc2_e6_porm_s) i(va_rgc2_e7_rm_n) i(va_rgc2_e7_rdis_n) i(va_ngc2_e7_sh2_s) i(va_ngc2_e7_porm_s) i(va_rgc2_e8_rm_n) i(va_rgc2_e8_rdis_n) i(va_ngc2_e8_sh2_s) i(va_ngc2_e8_porm_s) i(va_rgc2_e9_rm_n) i(va_rgc2_e9_rdis_n) i(va_ngc2_e9_sh2_s) i(va_ngc2_e9_porm_s) i(va_rgc2_e10_rm_n) i(va_rgc2_e10_rdis_n) i(va_ngc2_e10_sh2_s) i(va_ngc2_e10_porm_s) i(va_rgc2_col_rm_n) i(va_rgc2_col_rdis_n) i(va_ngc2_col_sh2_s) i(va_ngc2_col_porm_s) i(va_rgw3_e1_rm_n) i(va_rgw3_e1_rdis_n) i(va_ngw3_e1_sh2_s) i(va_ngw3_e1_porm_s) i(va_rgw3_e2_rm_n) i(va_rgw3_e2_rdis_n) i(va_ngw3_e2_sh2_s) i(va_ngw3_e2_porm_s) i(va_rgw3_e3_rm_n) i(va_rgw3_e3_rdis_n) i(va_ngw3_e3_sh2_s) i(va_ngw3_e3_porm_s) i(va_rgw3_e4_rm_n) i(va_rgw3_e4_rdis_n) i(va_ngw3_e4_sh2_s) i(va_ngw3_e4_porm_s) i(va_rgw3_e5_rm_n) i(va_rgw3_e5_rdis_n) i(va_ngw3_e5_sh2_s) i(va_ngw3_e5_porm_s) i(va_rgw3_e6_rm_n) i(va_rgw3_e6_rdis_n) i(va_ngw3_e6_sh2_s) i(va_ngw3_e6_porm_s) i(va_rgw3_e7_rm_n) i(va_rgw3_e7_rdis_n) i(va_ngw3_e7_sh2_s) i(va_ngw3_e7_porm_s) i(va_rgw3_e8_rm_n) i(va_rgw3_e8_rdis_n) i(va_ngw3_e8_sh2_s) i(va_ngw3_e8_porm_s) i(va_rgw3_e9_rm_n) i(va_rgw3_e9_rdis_n) i(va_ngw3_e9_sh2_s) i(va_ngw3_e9_porm_s) i(va_rgw3_e10_rm_n) i(va_rgw3_e10_rdis_n) i(va_ngw3_e10_sh2_s) i(va_ngw3_e10_porm_s) i(va_rgw3_col_rm_n) i(va_rgw3_col_rdis_n) i(va_ngw3_col_sh2_s) i(va_ngw3_col_porm_s) i(va_rgc3_e1_rm_n) i(va_rgc3_e1_rdis_n) i(va_ngc3_e1_sh2_s) i(va_ngc3_e1_porm_s) i(va_rgc3_e2_rm_n) i(va_rgc3_e2_rdis_n) i(va_ngc3_e2_sh2_s) i(va_ngc3_e2_porm_s) i(va_rgc3_e3_rm_n) i(va_rgc3_e3_rdis_n) i(va_ngc3_e3_sh2_s) i(va_ngc3_e3_porm_s) i(va_rgc3_e4_rm_n) i(va_rgc3_e4_rdis_n) i(va_ngc3_e4_sh2_s) i(va_ngc3_e4_porm_s) i(va_rgc3_e5_rm_n) i(va_rgc3_e5_rdis_n) i(va_ngc3_e5_sh2_s) i(va_ngc3_e5_porm_s) i(va_rgc3_e6_rm_n) i(va_rgc3_e6_rdis_n) i(va_ngc3_e6_sh2_s) i(va_ngc3_e6_porm_s) i(va_rgc3_e7_rm_n) i(va_rgc3_e7_rdis_n) i(va_ngc3_e7_sh2_s) i(va_ngc3_e7_porm_s) i(va_rgc3_e8_rm_n) i(va_rgc3_e8_rdis_n) i(va_ngc3_e8_sh2_s) i(va_ngc3_e8_porm_s) i(va_rgc3_e9_rm_n) i(va_rgc3_e9_rdis_n) i(va_ngc3_e9_sh2_s) i(va_ngc3_e9_porm_s) i(va_rgc3_e10_rm_n) i(va_rgc3_e10_rdis_n) i(va_ngc3_e10_sh2_s) i(va_ngc3_e10_porm_s) i(va_rgc3_col_rm_n) i(va_rgc3_col_rdis_n) i(va_ngc3_col_sh2_s) i(va_ngc3_col_porm_s) i(va_rgw4_e1_rm_n) i(va_rgw4_e1_rdis_n) i(va_ngw4_e1_sh2_s) i(va_ngw4_e1_porm_s) i(va_rgw4_e2_rm_n) i(va_rgw4_e2_rdis_n) i(va_ngw4_e2_sh2_s) i(va_ngw4_e2_porm_s) i(va_rgw4_e3_rm_n) i(va_rgw4_e3_rdis_n) i(va_ngw4_e3_sh2_s) i(va_ngw4_e3_porm_s) i(va_rgw4_e4_rm_n) i(va_rgw4_e4_rdis_n) i(va_ngw4_e4_sh2_s) i(va_ngw4_e4_porm_s) i(va_rgw4_e5_rm_n) i(va_rgw4_e5_rdis_n) i(va_ngw4_e5_sh2_s) i(va_ngw4_e5_porm_s) i(va_rgw4_e6_rm_n) i(va_rgw4_e6_rdis_n) i(va_ngw4_e6_sh2_s) i(va_ngw4_e6_porm_s) i(va_rgw4_e7_rm_n) i(va_rgw4_e7_rdis_n) i(va_ngw4_e7_sh2_s) i(va_ngw4_e7_porm_s) i(va_rgw4_e8_rm_n) i(va_rgw4_e8_rdis_n) i(va_ngw4_e8_sh2_s) i(va_ngw4_e8_porm_s) i(va_rgw4_e9_rm_n) i(va_rgw4_e9_rdis_n) i(va_ngw4_e9_sh2_s) i(va_ngw4_e9_porm_s) i(va_rgw4_e10_rm_n) i(va_rgw4_e10_rdis_n) i(va_ngw4_e10_sh2_s) i(va_ngw4_e10_porm_s) i(va_rgw4_col_rm_n) i(va_rgw4_col_rdis_n) i(va_ngw4_col_sh2_s) i(va_ngw4_col_porm_s) i(va_rgc4_e1_rm_n) i(va_rgc4_e1_rdis_n) i(va_ngc4_e1_sh2_s) i(va_ngc4_e1_porm_s) i(va_rgc4_e2_rm_n) i(va_rgc4_e2_rdis_n) i(va_ngc4_e2_sh2_s) i(va_ngc4_e2_porm_s) i(va_rgc4_e3_rm_n) i(va_rgc4_e3_rdis_n) i(va_ngc4_e3_sh2_s) i(va_ngc4_e3_porm_s) i(va_rgc4_e4_rm_n) i(va_rgc4_e4_rdis_n) i(va_ngc4_e4_sh2_s) i(va_ngc4_e4_porm_s) i(va_rgc4_e5_rm_n) i(va_rgc4_e5_rdis_n) i(va_ngc4_e5_sh2_s) i(va_ngc4_e5_porm_s) i(va_rgc4_e6_rm_n) i(va_rgc4_e6_rdis_n) i(va_ngc4_e6_sh2_s) i(va_ngc4_e6_porm_s) i(va_rgc4_e7_rm_n) i(va_rgc4_e7_rdis_n) i(va_ngc4_e7_sh2_s) i(va_ngc4_e7_porm_s) i(va_rgc4_e8_rm_n) i(va_rgc4_e8_rdis_n) i(va_ngc4_e8_sh2_s) i(va_ngc4_e8_porm_s) i(va_rgc4_e9_rm_n) i(va_rgc4_e9_rdis_n) i(va_ngc4_e9_sh2_s) i(va_ngc4_e9_porm_s) i(va_rgc4_e10_rm_n) i(va_rgc4_e10_rdis_n) i(va_ngc4_e10_sh2_s) i(va_ngc4_e10_porm_s) i(va_rgc4_col_rm_n) i(va_rgc4_col_rdis_n) i(va_ngc4_col_sh2_s) i(va_ngc4_col_porm_s) i(va_rthw12f_rm_n) i(va_rthw12f_rdis_n) i(va_nthw12f_sh2_s) i(va_nthw12f_porm_s) i(va_rthw12r_rm_n) i(va_rthw12r_rdis_n) i(va_nthw12r_sh2_s) i(va_nthw12r_porm_s) i(va_rthw23f_rm_n) i(va_rthw23f_rdis_n) i(va_nthw23f_sh2_s) i(va_nthw23f_porm_s) i(va_rthw23r_rm_n) i(va_rthw23r_rdis_n) i(va_nthw23r_sh2_s) i(va_nthw23r_porm_s) i(va_rthw34f_rm_n) i(va_rthw34f_rdis_n) i(va_nthw34f_sh2_s) i(va_nthw34f_porm_s) i(va_rthw34r_rm_n) i(va_rthw34r_rdis_n) i(va_nthw34r_sh2_s) i(va_nthw34r_porm_s) i(va_rsgw12f_rm_n) i(va_rsgw12f_rdis_n) i(va_nsgw12f_sh2_s) i(va_nsgw12f_porm_s) i(va_rsgw12r_rm_n) i(va_rsgw12r_rdis_n) i(va_nsgw12r_sh2_s) i(va_nsgw12r_porm_s) i(va_rsgw23f_rm_n) i(va_rsgw23f_rdis_n) i(va_nsgw23f_sh2_s) i(va_nsgw23f_porm_s) i(va_rsgw23r_rm_n) i(va_rsgw23r_rdis_n) i(va_nsgw23r_sh2_s) i(va_nsgw23r_porm_s) i(va_rsgw34f_rm_n) i(va_rsgw34f_rdis_n) i(va_nsgw34f_sh2_s) i(va_nsgw34f_porm_s) i(va_rsgw34r_rm_n) i(va_rsgw34r_rdis_n) i(va_nsgw34r_sh2_s) i(va_nsgw34r_porm_s) i(va_rcdw12f_rm_n) i(va_rcdw12f_rdis_n) i(va_ncdw12f_sh2_s) i(va_ncdw12f_porm_s) i(va_ncdw12f_kp_s) i(va_rcdw12r_rm_n) i(va_rcdw12r_rdis_n) i(va_ncdw12r_sh2_s) i(va_ncdw12r_porm_s) i(va_ncdw12r_kp_s) i(va_rcdw23f_rm_n) i(va_rcdw23f_rdis_n) i(va_ncdw23f_sh2_s) i(va_ncdw23f_porm_s) i(va_ncdw23f_kp_s) i(va_rcdw23r_rm_n) i(va_rcdw23r_rdis_n) i(va_ncdw23r_sh2_s) i(va_ncdw23r_porm_s) i(va_ncdw23r_kp_s) i(va_rcdw34f_rm_n) i(va_rcdw34f_rdis_n) i(va_ncdw34f_sh2_s) i(va_ncdw34f_porm_s) i(va_ncdw34f_kp_s) i(va_rcdw34r_rm_n) i(va_rcdw34r_rdis_n) i(va_ncdw34r_sh2_s) i(va_ncdw34r_porm_s) i(va_ncdw34r_kp_s) i(va_rthc12f_rm_n) i(va_rthc12f_rdis_n) i(va_nthc12f_sh2_s) i(va_nthc12f_porm_s) i(va_rthc12r_rm_n) i(va_rthc12r_rdis_n) i(va_nthc12r_sh2_s) i(va_nthc12r_porm_s) i(va_rthc23f_rm_n) i(va_rthc23f_rdis_n) i(va_nthc23f_sh2_s) i(va_nthc23f_porm_s) i(va_rthc23r_rm_n) i(va_rthc23r_rdis_n) i(va_nthc23r_sh2_s) i(va_nthc23r_porm_s) i(va_rthc34f_rm_n) i(va_rthc34f_rdis_n) i(va_nthc34f_sh2_s) i(va_nthc34f_porm_s) i(va_rthc34r_rm_n) i(va_rthc34r_rdis_n) i(va_nthc34r_sh2_s) i(va_nthc34r_porm_s) i(va_rsgc12f_rm_n) i(va_rsgc12f_rdis_n) i(va_nsgc12f_sh2_s) i(va_nsgc12f_porm_s) i(va_rsgc12r_rm_n) i(va_rsgc12r_rdis_n) i(va_nsgc12r_sh2_s) i(va_nsgc12r_porm_s) i(va_rsgc23f_rm_n) i(va_rsgc23f_rdis_n) i(va_nsgc23f_sh2_s) i(va_nsgc23f_porm_s) i(va_rsgc23r_rm_n) i(va_rsgc23r_rdis_n) i(va_nsgc23r_sh2_s) i(va_nsgc23r_porm_s) i(va_rsgc34f_rm_n) i(va_rsgc34f_rdis_n) i(va_nsgc34f_sh2_s) i(va_nsgc34f_porm_s) i(va_rsgc34r_rm_n) i(va_rsgc34r_rdis_n) i(va_nsgc34r_sh2_s) i(va_nsgc34r_porm_s) i(va_rcdc12f_rm_n) i(va_rcdc12f_rdis_n) i(va_ncdc12f_sh2_s) i(va_ncdc12f_porm_s) i(va_ncdc12f_kp_s) i(va_rcdc12r_rm_n) i(va_rcdc12r_rdis_n) i(va_ncdc12r_sh2_s) i(va_ncdc12r_porm_s) i(va_ncdc12r_kp_s) i(va_rcdc23f_rm_n) i(va_rcdc23f_rdis_n) i(va_ncdc23f_sh2_s) i(va_ncdc23f_porm_s) i(va_ncdc23f_kp_s) i(va_rcdc23r_rm_n) i(va_rcdc23r_rdis_n) i(va_ncdc23r_sh2_s) i(va_ncdc23r_porm_s) i(va_ncdc23r_kp_s) i(va_rcdc34f_rm_n) i(va_rcdc34f_rdis_n) i(va_ncdc34f_sh2_s) i(va_ncdc34f_porm_s) i(va_ncdc34f_kp_s) i(va_rcdc34r_rm_n) i(va_rcdc34r_rdis_n) i(va_ncdc34r_sh2_s) i(va_ncdc34r_porm_s) i(va_ncdc34r_kp_s) i(va_cpar_vrest_p)
.control
pre_osdi /workspace/thermal-g3-env/host/native/models/ekv26_linux.osdi
set filetype=binary
op
write /workspace/thermal-g3-repair/gated-source-v3-2026-10-23-fc4ec434/runs/DC_3/DC_3.raw
quit
.endc
.end

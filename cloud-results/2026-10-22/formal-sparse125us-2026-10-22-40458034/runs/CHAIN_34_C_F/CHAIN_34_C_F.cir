* THERMAL-G3-Q1-R CHAIN_34_C_F
.include /workspace/thermal-g3-formal/formal-sparse125us-2026-10-22-40458034/inputs/c05_ekv26_typ.lib
vsrc vsrc 0 PWL(0 0 0.02 3.0)
rint vsrc vdd 10
cdec vdd 0 1e-05
rvrestt vdd vrest 2000
rvrestb vrest 0 1000
cvrestc vrest 0 1e-05
rvthet vdd vthe 2000
rvtheb vthe 0 1800
cvthec vthe 0 1e-05
rvthrt vdd vthr 2400
rvthrb vthr 0 1500
cvthrc vthr 0 1e-05
rvmidt vdd vmid 2000
rvmidb vmid 0 2000
cvmidc vmid 0 1e-05
rporr vdd porc 2.2e+06
cporc porc 0 1e-06
rporra porc porx 1e+06
rporrf por_ok porx 4e+06
npori1p por_hold porx vdd vsrc pch W=2.4e-06 L=5e-07
npori1n por_hold porx 0 0 nch W=1.2e-06 L=5e-07
npori2p por_ok por_hold vdd vsrc pch W=2.4e-06 L=5e-07
npori2n por_ok por_hold 0 0 nch W=1.2e-06 L=5e-07
riref vdd iref_n 2.2e+06
nirefd iref_n iref_n 0 0 nch W=4e-06 L=4e-06
ristep vdd istep_n 5.6e+07
nistepd istep_n istep_n 0 0 nch W=4e-06 L=4e-06
nirefm irefp_n iref_n 0 0 nch W=4e-06 L=4e-06
nirefpd irefp_n irefp_n vdd vsrc pch W=4e-06 L=4e-06
rilim vdd ilim_n 1.85e+06
nilimd ilim_n ilim_n 0 0 nch W=4e-06 L=4e-06
nilimm ilimp_n ilim_n 0 0 nch W=4e-06 L=4e-06
nilimpd ilimp_n ilimp_n vdd vsrc pch W=4e-06 L=4e-06
bs1_te s1_te 0 V=18.5
vqes1 s1_te s1_tea DC 0
rs1_ge s1_tea s1_tp 500
cs1_cp s1_tp 0 0.01
rs1_gm s1_tp s1_tn 1000
cs1_cn s1_tn 0 0.0001
bs1_ntc vdd s1_s I=V(vdd,s1_s)/(100000*exp(4250*(1/(298.15+V(s1_tn))-1/298.15)))
bs1_heat 0 s1_th I=V(vdd,s1_s)*V(vdd,s1_s)/(100000*exp(4250*(1/(298.15+V(s1_tn))-1/298.15)))
vqhs1 s1_th s1_tn DC 0
rs1_rs s1_s 0 100000
rs1_ravg s1_s s1_m 2e+06
cs1_cavg s1_m 0 1e-06
ns1_mpor s1_m por_ok s1_s vsrc pch W=4e-06 L=1e-06
rs1_ab vdd s1_anb 750000
ns1_amb s1_anb s1_anb 0 0 nch W=4e-06 L=4e-06
ns1_amt s1_atl s1_anb 0 0 nch W=4e-06 L=4e-06
ns1_am1 s1_da s1_s s1_atl 0 nch W=1e-06 L=4e-06
ns1_am2 s1_db s1_m s1_atl 0 nch W=1e-06 L=4e-06
rs1_ara vdd s1_da 680000
rs1_arb vdd s1_db 680000
ns1_tt s1_tl ilim_n 0 0 nch W=4e-06 L=4e-06
ns1_ta s1_ya s1_db s1_tl 0 nch W=1e-05 L=2e-06
ns1_tb s1_yb s1_da s1_tl 0 nch W=1e-05 L=2e-06
ns1_la s1_ya s1_ya vdd vsrc pch W=4e-06 L=4e-06
ns1_lb s1_yb s1_yb vdd vsrc pch W=4e-06 L=4e-06
ns1_ca s1_za s1_ya vdd vsrc pch W=4e-06 L=4e-06
ns1_na s1_za s1_za 0 0 nch W=4e-06 L=4e-06
ns1_cb s1_zb s1_yb vdd vsrc pch W=4e-06 L=4e-06
ns1_nb s1_zb s1_zb 0 0 nch W=4e-06 L=4e-06
bs2_te s2_te 0 V=18.5
vqes2 s2_te s2_tea DC 0
rs2_ge s2_tea s2_tp 500
cs2_cp s2_tp 0 0.01
rs2_gm s2_tp s2_tn 1000
cs2_cn s2_tn 0 0.0001
bs2_ntc vdd s2_s I=V(vdd,s2_s)/(100000*exp(4250*(1/(298.15+V(s2_tn))-1/298.15)))
bs2_heat 0 s2_th I=V(vdd,s2_s)*V(vdd,s2_s)/(100000*exp(4250*(1/(298.15+V(s2_tn))-1/298.15)))
vqhs2 s2_th s2_tn DC 0
rs2_rs s2_s 0 100000
rs2_ravg s2_s s2_m 2e+06
cs2_cavg s2_m 0 1e-06
ns2_mpor s2_m por_ok s2_s vsrc pch W=4e-06 L=1e-06
rs2_ab vdd s2_anb 750000
ns2_amb s2_anb s2_anb 0 0 nch W=4e-06 L=4e-06
ns2_amt s2_atl s2_anb 0 0 nch W=4e-06 L=4e-06
ns2_am1 s2_da s2_s s2_atl 0 nch W=1e-06 L=4e-06
ns2_am2 s2_db s2_m s2_atl 0 nch W=1e-06 L=4e-06
rs2_ara vdd s2_da 680000
rs2_arb vdd s2_db 680000
ns2_tt s2_tl ilim_n 0 0 nch W=4e-06 L=4e-06
ns2_ta s2_ya s2_db s2_tl 0 nch W=1e-05 L=2e-06
ns2_tb s2_yb s2_da s2_tl 0 nch W=1e-05 L=2e-06
ns2_la s2_ya s2_ya vdd vsrc pch W=4e-06 L=4e-06
ns2_lb s2_yb s2_yb vdd vsrc pch W=4e-06 L=4e-06
ns2_ca s2_za s2_ya vdd vsrc pch W=4e-06 L=4e-06
ns2_na s2_za s2_za 0 0 nch W=4e-06 L=4e-06
ns2_cb s2_zb s2_yb vdd vsrc pch W=4e-06 L=4e-06
ns2_nb s2_zb s2_zb 0 0 nch W=4e-06 L=4e-06
bs3_te s3_te 0 V=(18.5+-3*(1/(1+exp(-(time-10.6)/0.05))-1/(1+exp(-(time-17.6)/0.05))))
vqes3 s3_te s3_tea DC 0
rs3_ge s3_tea s3_tp 500
cs3_cp s3_tp 0 0.01
rs3_gm s3_tp s3_tn 1000
cs3_cn s3_tn 0 0.0001
bs3_ntc vdd s3_s I=V(vdd,s3_s)/(100000*exp(4250*(1/(298.15+V(s3_tn))-1/298.15)))
bs3_heat 0 s3_th I=V(vdd,s3_s)*V(vdd,s3_s)/(100000*exp(4250*(1/(298.15+V(s3_tn))-1/298.15)))
vqhs3 s3_th s3_tn DC 0
rs3_rs s3_s 0 100000
rs3_ravg s3_s s3_m 2e+06
cs3_cavg s3_m 0 1e-06
ns3_mpor s3_m por_ok s3_s vsrc pch W=4e-06 L=1e-06
rs3_ab vdd s3_anb 750000
ns3_amb s3_anb s3_anb 0 0 nch W=4e-06 L=4e-06
ns3_amt s3_atl s3_anb 0 0 nch W=4e-06 L=4e-06
ns3_am1 s3_da s3_s s3_atl 0 nch W=1e-06 L=4e-06
ns3_am2 s3_db s3_m s3_atl 0 nch W=1e-06 L=4e-06
rs3_ara vdd s3_da 680000
rs3_arb vdd s3_db 680000
ns3_tt s3_tl ilim_n 0 0 nch W=4e-06 L=4e-06
ns3_ta s3_ya s3_db s3_tl 0 nch W=1e-05 L=2e-06
ns3_tb s3_yb s3_da s3_tl 0 nch W=1e-05 L=2e-06
ns3_la s3_ya s3_ya vdd vsrc pch W=4e-06 L=4e-06
ns3_lb s3_yb s3_yb vdd vsrc pch W=4e-06 L=4e-06
ns3_ca s3_za s3_ya vdd vsrc pch W=4e-06 L=4e-06
ns3_na s3_za s3_za 0 0 nch W=4e-06 L=4e-06
ns3_cb s3_zb s3_yb vdd vsrc pch W=4e-06 L=4e-06
ns3_nb s3_zb s3_zb 0 0 nch W=4e-06 L=4e-06
bs4_te s4_te 0 V=(18.5+-3*(1/(1+exp(-(time-12.1)/0.05))-1/(1+exp(-(time-19.1)/0.05))))
vqes4 s4_te s4_tea DC 0
rs4_ge s4_tea s4_tp 500
cs4_cp s4_tp 0 0.01
rs4_gm s4_tp s4_tn 1000
cs4_cn s4_tn 0 0.0001
bs4_ntc vdd s4_s I=V(vdd,s4_s)/(100000*exp(4250*(1/(298.15+V(s4_tn))-1/298.15)))
bs4_heat 0 s4_th I=V(vdd,s4_s)*V(vdd,s4_s)/(100000*exp(4250*(1/(298.15+V(s4_tn))-1/298.15)))
vqhs4 s4_th s4_tn DC 0
rs4_rs s4_s 0 100000
rs4_ravg s4_s s4_m 2e+06
cs4_cavg s4_m 0 1e-06
ns4_mpor s4_m por_ok s4_s vsrc pch W=4e-06 L=1e-06
rs4_ab vdd s4_anb 750000
ns4_amb s4_anb s4_anb 0 0 nch W=4e-06 L=4e-06
ns4_amt s4_atl s4_anb 0 0 nch W=4e-06 L=4e-06
ns4_am1 s4_da s4_s s4_atl 0 nch W=1e-06 L=4e-06
ns4_am2 s4_db s4_m s4_atl 0 nch W=1e-06 L=4e-06
rs4_ara vdd s4_da 680000
rs4_arb vdd s4_db 680000
ns4_tt s4_tl ilim_n 0 0 nch W=4e-06 L=4e-06
ns4_ta s4_ya s4_db s4_tl 0 nch W=1e-05 L=2e-06
ns4_tb s4_yb s4_da s4_tl 0 nch W=1e-05 L=2e-06
ns4_la s4_ya s4_ya vdd vsrc pch W=4e-06 L=4e-06
ns4_lb s4_yb s4_yb vdd vsrc pch W=4e-06 L=4e-06
ns4_ca s4_za s4_ya vdd vsrc pch W=4e-06 L=4e-06
ns4_na s4_za s4_za 0 0 nch W=4e-06 L=4e-06
ns4_cb s4_zb s4_yb vdd vsrc pch W=4e-06 L=4e-06
ns4_nb s4_zb s4_zb 0 0 nch W=4e-06 L=4e-06
cgc3_e1_cm gc3_e1_vm 0 1e-07
rgc3_e1_rm gc3_e1_vm vrest 1e+06
ngc3_e1_bias0 gc3_e1_vm istep_n 0 0 nch W=4e-06 L=4e-06
rgc3_e1_kb vdd gc3_e1_knb 1e+06
ngc3_e1_kmb gc3_e1_knb gc3_e1_knb 0 0 nch W=4e-06 L=4e-06
ngc3_e1_kmt gc3_e1_ktail gc3_e1_knb 0 0 nch W=4e-06 L=4e-06
ngc3_e1_km1 gc3_e1_kd1 gc3_e1_vm gc3_e1_ktail 0 nch W=4e-06 L=4e-06
ngc3_e1_km2 gc3_e1_ko1 gc3_e1_h gc3_e1_ktail 0 nch W=4e-06 L=4e-06
ngc3_e1_km3 gc3_e1_kd1 gc3_e1_kd1 vdd vsrc pch W=4e-06 L=4e-06
ngc3_e1_km4 gc3_e1_ko1 gc3_e1_kd1 vdd vsrc pch W=4e-06 L=4e-06
ngc3_e1_ki1p gc3_e1_qb gc3_e1_ko1 vdd vsrc pch W=2.4e-06 L=5e-07
ngc3_e1_ki1n gc3_e1_qb gc3_e1_ko1 0 0 nch W=1.2e-06 L=5e-07
ngc3_e1_ki2p gc3_e1_q gc3_e1_qb vdd vsrc pch W=2.4e-06 L=5e-07
ngc3_e1_ki2n gc3_e1_q gc3_e1_qb 0 0 nch W=1.2e-06 L=5e-07
rgc3_e1_hra gc3_e1_h vthe 1e+06
rgc3_e1_hrf gc3_e1_h gc3_e1_qb 1.9e+07
cgc3_e1_hc gc3_e1_h 0 2.1e-09
ngc3_e1_dis gc3_e1_vm gc3_e1_q gc3_e1_vmd 0 nch W=4e-06 L=1e-06
rgc3_e1_rdis gc3_e1_vmd vrest 220000
ngc3_e1_rp gc3_e1_rt gc3_e1_qb vdd vsrc pch W=2e-06 L=1e-06
rgc3_e1_rrc gc3_e1_rt gc3_e1_rec 10000
cgc3_e1_rc gc3_e1_rec 0 1e-07
rgc3_e1_rr gc3_e1_rec 0 8.2e+06
ngc3_e1_sh1 gc3_e1_vm gc3_e1_rec gc3_e1_vms 0 nch W=2e-06 L=1e-06
ngc3_e1_sh2 gc3_e1_vms gc3_e1_qb vrest 0 nch W=2e-06 L=1e-06
ngc3_e1_porh gc3_e1_h por_hold vthe 0 nch W=2e-06 L=1e-06
ngc3_e1_porm gc3_e1_vm por_hold vrest 0 nch W=2e-06 L=1e-06
ngc3_e1_ip gc3_e1_vm s3_yb vdd vsrc pch W=4e-06 L=4e-06
ngc3_e1_in gc3_e1_vm s3_za 0 0 nch W=4e-06 L=4e-06
ngc3_b1_sw gc3_b1_t gc3_e1_qb vdd vsrc pch W=2e-06 L=1e-06
rgc3_b1_rc gc3_b1_t gc3_b1 10000
cgc3_b1_c gc3_b1 0 1e-07
rgc3_b1_rl gc3_b1 0 2.2e+07
ngc3_b1_sh1p gc3_b1_n gc3_b1 vdd vsrc pch W=2.4e-06 L=5e-07
ngc3_b1_sh1n gc3_b1_n gc3_b1 0 0 nch W=1.2e-06 L=5e-07
ngc3_b1_sh2p gc3_b1_q gc3_b1_n vdd vsrc pch W=2.4e-06 L=5e-07
ngc3_b1_sh2n gc3_b1_q gc3_b1_n 0 0 nch W=1.2e-06 L=5e-07
cgc3_e2_cm gc3_e2_vm 0 1e-07
rgc3_e2_rm gc3_e2_vm vrest 1e+06
ngc3_e2_bias0 gc3_e2_vm istep_n 0 0 nch W=4e-06 L=4e-06
ngc3_e2_bias1 gc3_e2_vm istep_n 0 0 nch W=4e-06 L=4e-06
rgc3_e2_kb vdd gc3_e2_knb 1e+06
ngc3_e2_kmb gc3_e2_knb gc3_e2_knb 0 0 nch W=4e-06 L=4e-06
ngc3_e2_kmt gc3_e2_ktail gc3_e2_knb 0 0 nch W=4e-06 L=4e-06
ngc3_e2_km1 gc3_e2_kd1 gc3_e2_vm gc3_e2_ktail 0 nch W=4e-06 L=4e-06
ngc3_e2_km2 gc3_e2_ko1 gc3_e2_h gc3_e2_ktail 0 nch W=4e-06 L=4e-06
ngc3_e2_km3 gc3_e2_kd1 gc3_e2_kd1 vdd vsrc pch W=4e-06 L=4e-06
ngc3_e2_km4 gc3_e2_ko1 gc3_e2_kd1 vdd vsrc pch W=4e-06 L=4e-06
ngc3_e2_ki1p gc3_e2_qb gc3_e2_ko1 vdd vsrc pch W=2.4e-06 L=5e-07
ngc3_e2_ki1n gc3_e2_qb gc3_e2_ko1 0 0 nch W=1.2e-06 L=5e-07
ngc3_e2_ki2p gc3_e2_q gc3_e2_qb vdd vsrc pch W=2.4e-06 L=5e-07
ngc3_e2_ki2n gc3_e2_q gc3_e2_qb 0 0 nch W=1.2e-06 L=5e-07
rgc3_e2_hra gc3_e2_h vthe 1e+06
rgc3_e2_hrf gc3_e2_h gc3_e2_qb 1.9e+07
cgc3_e2_hc gc3_e2_h 0 2.1e-09
ngc3_e2_dis gc3_e2_vm gc3_e2_q gc3_e2_vmd 0 nch W=4e-06 L=1e-06
rgc3_e2_rdis gc3_e2_vmd vrest 220000
ngc3_e2_rp gc3_e2_rt gc3_e2_qb vdd vsrc pch W=2e-06 L=1e-06
rgc3_e2_rrc gc3_e2_rt gc3_e2_rec 10000
cgc3_e2_rc gc3_e2_rec 0 1e-07
rgc3_e2_rr gc3_e2_rec 0 8.2e+06
ngc3_e2_sh1 gc3_e2_vm gc3_e2_rec gc3_e2_vms 0 nch W=2e-06 L=1e-06
ngc3_e2_sh2 gc3_e2_vms gc3_e2_qb vrest 0 nch W=2e-06 L=1e-06
ngc3_e2_porh gc3_e2_h por_hold vthe 0 nch W=2e-06 L=1e-06
ngc3_e2_porm gc3_e2_vm por_hold vrest 0 nch W=2e-06 L=1e-06
ngc3_e2_ip gc3_e2_vm s3_yb vdd vsrc pch W=4e-06 L=4e-06
ngc3_e2_in gc3_e2_vm s3_za 0 0 nch W=4e-06 L=4e-06
ngc3_b2_sw gc3_b2_t gc3_e2_qb vdd vsrc pch W=2e-06 L=1e-06
rgc3_b2_rc gc3_b2_t gc3_b2 10000
cgc3_b2_c gc3_b2 0 1e-07
rgc3_b2_rl gc3_b2 0 2.2e+07
ngc3_b2_sh1p gc3_b2_n gc3_b2 vdd vsrc pch W=2.4e-06 L=5e-07
ngc3_b2_sh1n gc3_b2_n gc3_b2 0 0 nch W=1.2e-06 L=5e-07
ngc3_b2_sh2p gc3_b2_q gc3_b2_n vdd vsrc pch W=2.4e-06 L=5e-07
ngc3_b2_sh2n gc3_b2_q gc3_b2_n 0 0 nch W=1.2e-06 L=5e-07
cgc3_e3_cm gc3_e3_vm 0 1e-07
rgc3_e3_rm gc3_e3_vm vrest 1e+06
ngc3_e3_bias0 gc3_e3_vm istep_n 0 0 nch W=4e-06 L=4e-06
ngc3_e3_bias1 gc3_e3_vm istep_n 0 0 nch W=4e-06 L=4e-06
ngc3_e3_bias2 gc3_e3_vm istep_n 0 0 nch W=4e-06 L=4e-06
rgc3_e3_kb vdd gc3_e3_knb 1e+06
ngc3_e3_kmb gc3_e3_knb gc3_e3_knb 0 0 nch W=4e-06 L=4e-06
ngc3_e3_kmt gc3_e3_ktail gc3_e3_knb 0 0 nch W=4e-06 L=4e-06
ngc3_e3_km1 gc3_e3_kd1 gc3_e3_vm gc3_e3_ktail 0 nch W=4e-06 L=4e-06
ngc3_e3_km2 gc3_e3_ko1 gc3_e3_h gc3_e3_ktail 0 nch W=4e-06 L=4e-06
ngc3_e3_km3 gc3_e3_kd1 gc3_e3_kd1 vdd vsrc pch W=4e-06 L=4e-06
ngc3_e3_km4 gc3_e3_ko1 gc3_e3_kd1 vdd vsrc pch W=4e-06 L=4e-06
ngc3_e3_ki1p gc3_e3_qb gc3_e3_ko1 vdd vsrc pch W=2.4e-06 L=5e-07
ngc3_e3_ki1n gc3_e3_qb gc3_e3_ko1 0 0 nch W=1.2e-06 L=5e-07
ngc3_e3_ki2p gc3_e3_q gc3_e3_qb vdd vsrc pch W=2.4e-06 L=5e-07
ngc3_e3_ki2n gc3_e3_q gc3_e3_qb 0 0 nch W=1.2e-06 L=5e-07
rgc3_e3_hra gc3_e3_h vthe 1e+06
rgc3_e3_hrf gc3_e3_h gc3_e3_qb 1.9e+07
cgc3_e3_hc gc3_e3_h 0 2.1e-09
ngc3_e3_dis gc3_e3_vm gc3_e3_q gc3_e3_vmd 0 nch W=4e-06 L=1e-06
rgc3_e3_rdis gc3_e3_vmd vrest 220000
ngc3_e3_rp gc3_e3_rt gc3_e3_qb vdd vsrc pch W=2e-06 L=1e-06
rgc3_e3_rrc gc3_e3_rt gc3_e3_rec 10000
cgc3_e3_rc gc3_e3_rec 0 1e-07
rgc3_e3_rr gc3_e3_rec 0 8.2e+06
ngc3_e3_sh1 gc3_e3_vm gc3_e3_rec gc3_e3_vms 0 nch W=2e-06 L=1e-06
ngc3_e3_sh2 gc3_e3_vms gc3_e3_qb vrest 0 nch W=2e-06 L=1e-06
ngc3_e3_porh gc3_e3_h por_hold vthe 0 nch W=2e-06 L=1e-06
ngc3_e3_porm gc3_e3_vm por_hold vrest 0 nch W=2e-06 L=1e-06
ngc3_e3_ip gc3_e3_vm s3_yb vdd vsrc pch W=4e-06 L=4e-06
ngc3_e3_in gc3_e3_vm s3_za 0 0 nch W=4e-06 L=4e-06
ngc3_b3_sw gc3_b3_t gc3_e3_qb vdd vsrc pch W=2e-06 L=1e-06
rgc3_b3_rc gc3_b3_t gc3_b3 10000
cgc3_b3_c gc3_b3 0 1e-07
rgc3_b3_rl gc3_b3 0 2.2e+07
ngc3_b3_sh1p gc3_b3_n gc3_b3 vdd vsrc pch W=2.4e-06 L=5e-07
ngc3_b3_sh1n gc3_b3_n gc3_b3 0 0 nch W=1.2e-06 L=5e-07
ngc3_b3_sh2p gc3_b3_q gc3_b3_n vdd vsrc pch W=2.4e-06 L=5e-07
ngc3_b3_sh2n gc3_b3_q gc3_b3_n 0 0 nch W=1.2e-06 L=5e-07
cgc3_e4_cm gc3_e4_vm 0 1e-07
rgc3_e4_rm gc3_e4_vm vrest 1e+06
ngc3_e4_bias0 gc3_e4_vm istep_n 0 0 nch W=4e-06 L=4e-06
ngc3_e4_bias1 gc3_e4_vm istep_n 0 0 nch W=4e-06 L=4e-06
ngc3_e4_bias2 gc3_e4_vm istep_n 0 0 nch W=4e-06 L=4e-06
ngc3_e4_bias3 gc3_e4_vm istep_n 0 0 nch W=4e-06 L=4e-06
rgc3_e4_kb vdd gc3_e4_knb 1e+06
ngc3_e4_kmb gc3_e4_knb gc3_e4_knb 0 0 nch W=4e-06 L=4e-06
ngc3_e4_kmt gc3_e4_ktail gc3_e4_knb 0 0 nch W=4e-06 L=4e-06
ngc3_e4_km1 gc3_e4_kd1 gc3_e4_vm gc3_e4_ktail 0 nch W=4e-06 L=4e-06
ngc3_e4_km2 gc3_e4_ko1 gc3_e4_h gc3_e4_ktail 0 nch W=4e-06 L=4e-06
ngc3_e4_km3 gc3_e4_kd1 gc3_e4_kd1 vdd vsrc pch W=4e-06 L=4e-06
ngc3_e4_km4 gc3_e4_ko1 gc3_e4_kd1 vdd vsrc pch W=4e-06 L=4e-06
ngc3_e4_ki1p gc3_e4_qb gc3_e4_ko1 vdd vsrc pch W=2.4e-06 L=5e-07
ngc3_e4_ki1n gc3_e4_qb gc3_e4_ko1 0 0 nch W=1.2e-06 L=5e-07
ngc3_e4_ki2p gc3_e4_q gc3_e4_qb vdd vsrc pch W=2.4e-06 L=5e-07
ngc3_e4_ki2n gc3_e4_q gc3_e4_qb 0 0 nch W=1.2e-06 L=5e-07
rgc3_e4_hra gc3_e4_h vthe 1e+06
rgc3_e4_hrf gc3_e4_h gc3_e4_qb 1.9e+07
cgc3_e4_hc gc3_e4_h 0 2.1e-09
ngc3_e4_dis gc3_e4_vm gc3_e4_q gc3_e4_vmd 0 nch W=4e-06 L=1e-06
rgc3_e4_rdis gc3_e4_vmd vrest 220000
ngc3_e4_rp gc3_e4_rt gc3_e4_qb vdd vsrc pch W=2e-06 L=1e-06
rgc3_e4_rrc gc3_e4_rt gc3_e4_rec 10000
cgc3_e4_rc gc3_e4_rec 0 1e-07
rgc3_e4_rr gc3_e4_rec 0 8.2e+06
ngc3_e4_sh1 gc3_e4_vm gc3_e4_rec gc3_e4_vms 0 nch W=2e-06 L=1e-06
ngc3_e4_sh2 gc3_e4_vms gc3_e4_qb vrest 0 nch W=2e-06 L=1e-06
ngc3_e4_porh gc3_e4_h por_hold vthe 0 nch W=2e-06 L=1e-06
ngc3_e4_porm gc3_e4_vm por_hold vrest 0 nch W=2e-06 L=1e-06
ngc3_e4_ip gc3_e4_vm s3_yb vdd vsrc pch W=4e-06 L=4e-06
ngc3_e4_in gc3_e4_vm s3_za 0 0 nch W=4e-06 L=4e-06
ngc3_b4_sw gc3_b4_t gc3_e4_qb vdd vsrc pch W=2e-06 L=1e-06
rgc3_b4_rc gc3_b4_t gc3_b4 10000
cgc3_b4_c gc3_b4 0 1e-07
rgc3_b4_rl gc3_b4 0 2.2e+07
ngc3_b4_sh1p gc3_b4_n gc3_b4 vdd vsrc pch W=2.4e-06 L=5e-07
ngc3_b4_sh1n gc3_b4_n gc3_b4 0 0 nch W=1.2e-06 L=5e-07
ngc3_b4_sh2p gc3_b4_q gc3_b4_n vdd vsrc pch W=2.4e-06 L=5e-07
ngc3_b4_sh2n gc3_b4_q gc3_b4_n 0 0 nch W=1.2e-06 L=5e-07
cgc3_e5_cm gc3_e5_vm 0 1e-07
rgc3_e5_rm gc3_e5_vm vrest 1e+06
ngc3_e5_bias0 gc3_e5_vm istep_n 0 0 nch W=4e-06 L=4e-06
ngc3_e5_bias1 gc3_e5_vm istep_n 0 0 nch W=4e-06 L=4e-06
ngc3_e5_bias2 gc3_e5_vm istep_n 0 0 nch W=4e-06 L=4e-06
ngc3_e5_bias3 gc3_e5_vm istep_n 0 0 nch W=4e-06 L=4e-06
ngc3_e5_bias4 gc3_e5_vm istep_n 0 0 nch W=4e-06 L=4e-06
rgc3_e5_kb vdd gc3_e5_knb 1e+06
ngc3_e5_kmb gc3_e5_knb gc3_e5_knb 0 0 nch W=4e-06 L=4e-06
ngc3_e5_kmt gc3_e5_ktail gc3_e5_knb 0 0 nch W=4e-06 L=4e-06
ngc3_e5_km1 gc3_e5_kd1 gc3_e5_vm gc3_e5_ktail 0 nch W=4e-06 L=4e-06
ngc3_e5_km2 gc3_e5_ko1 gc3_e5_h gc3_e5_ktail 0 nch W=4e-06 L=4e-06
ngc3_e5_km3 gc3_e5_kd1 gc3_e5_kd1 vdd vsrc pch W=4e-06 L=4e-06
ngc3_e5_km4 gc3_e5_ko1 gc3_e5_kd1 vdd vsrc pch W=4e-06 L=4e-06
ngc3_e5_ki1p gc3_e5_qb gc3_e5_ko1 vdd vsrc pch W=2.4e-06 L=5e-07
ngc3_e5_ki1n gc3_e5_qb gc3_e5_ko1 0 0 nch W=1.2e-06 L=5e-07
ngc3_e5_ki2p gc3_e5_q gc3_e5_qb vdd vsrc pch W=2.4e-06 L=5e-07
ngc3_e5_ki2n gc3_e5_q gc3_e5_qb 0 0 nch W=1.2e-06 L=5e-07
rgc3_e5_hra gc3_e5_h vthe 1e+06
rgc3_e5_hrf gc3_e5_h gc3_e5_qb 1.9e+07
cgc3_e5_hc gc3_e5_h 0 2.1e-09
ngc3_e5_dis gc3_e5_vm gc3_e5_q gc3_e5_vmd 0 nch W=4e-06 L=1e-06
rgc3_e5_rdis gc3_e5_vmd vrest 220000
ngc3_e5_rp gc3_e5_rt gc3_e5_qb vdd vsrc pch W=2e-06 L=1e-06
rgc3_e5_rrc gc3_e5_rt gc3_e5_rec 10000
cgc3_e5_rc gc3_e5_rec 0 1e-07
rgc3_e5_rr gc3_e5_rec 0 8.2e+06
ngc3_e5_sh1 gc3_e5_vm gc3_e5_rec gc3_e5_vms 0 nch W=2e-06 L=1e-06
ngc3_e5_sh2 gc3_e5_vms gc3_e5_qb vrest 0 nch W=2e-06 L=1e-06
ngc3_e5_porh gc3_e5_h por_hold vthe 0 nch W=2e-06 L=1e-06
ngc3_e5_porm gc3_e5_vm por_hold vrest 0 nch W=2e-06 L=1e-06
ngc3_e5_ip gc3_e5_vm s3_yb vdd vsrc pch W=4e-06 L=4e-06
ngc3_e5_in gc3_e5_vm s3_za 0 0 nch W=4e-06 L=4e-06
ngc3_b5_sw gc3_b5_t gc3_e5_qb vdd vsrc pch W=2e-06 L=1e-06
rgc3_b5_rc gc3_b5_t gc3_b5 10000
cgc3_b5_c gc3_b5 0 1e-07
rgc3_b5_rl gc3_b5 0 2.2e+07
ngc3_b5_sh1p gc3_b5_n gc3_b5 vdd vsrc pch W=2.4e-06 L=5e-07
ngc3_b5_sh1n gc3_b5_n gc3_b5 0 0 nch W=1.2e-06 L=5e-07
ngc3_b5_sh2p gc3_b5_q gc3_b5_n vdd vsrc pch W=2.4e-06 L=5e-07
ngc3_b5_sh2n gc3_b5_q gc3_b5_n 0 0 nch W=1.2e-06 L=5e-07
cgc3_e6_cm gc3_e6_vm 0 1e-07
rgc3_e6_rm gc3_e6_vm vrest 1e+06
ngc3_e6_bias0 gc3_e6_vm istep_n 0 0 nch W=4e-06 L=4e-06
ngc3_e6_bias1 gc3_e6_vm istep_n 0 0 nch W=4e-06 L=4e-06
ngc3_e6_bias2 gc3_e6_vm istep_n 0 0 nch W=4e-06 L=4e-06
ngc3_e6_bias3 gc3_e6_vm istep_n 0 0 nch W=4e-06 L=4e-06
ngc3_e6_bias4 gc3_e6_vm istep_n 0 0 nch W=4e-06 L=4e-06
ngc3_e6_bias5 gc3_e6_vm istep_n 0 0 nch W=4e-06 L=4e-06
rgc3_e6_kb vdd gc3_e6_knb 1e+06
ngc3_e6_kmb gc3_e6_knb gc3_e6_knb 0 0 nch W=4e-06 L=4e-06
ngc3_e6_kmt gc3_e6_ktail gc3_e6_knb 0 0 nch W=4e-06 L=4e-06
ngc3_e6_km1 gc3_e6_kd1 gc3_e6_vm gc3_e6_ktail 0 nch W=4e-06 L=4e-06
ngc3_e6_km2 gc3_e6_ko1 gc3_e6_h gc3_e6_ktail 0 nch W=4e-06 L=4e-06
ngc3_e6_km3 gc3_e6_kd1 gc3_e6_kd1 vdd vsrc pch W=4e-06 L=4e-06
ngc3_e6_km4 gc3_e6_ko1 gc3_e6_kd1 vdd vsrc pch W=4e-06 L=4e-06
ngc3_e6_ki1p gc3_e6_qb gc3_e6_ko1 vdd vsrc pch W=2.4e-06 L=5e-07
ngc3_e6_ki1n gc3_e6_qb gc3_e6_ko1 0 0 nch W=1.2e-06 L=5e-07
ngc3_e6_ki2p gc3_e6_q gc3_e6_qb vdd vsrc pch W=2.4e-06 L=5e-07
ngc3_e6_ki2n gc3_e6_q gc3_e6_qb 0 0 nch W=1.2e-06 L=5e-07
rgc3_e6_hra gc3_e6_h vthe 1e+06
rgc3_e6_hrf gc3_e6_h gc3_e6_qb 1.9e+07
cgc3_e6_hc gc3_e6_h 0 2.1e-09
ngc3_e6_dis gc3_e6_vm gc3_e6_q gc3_e6_vmd 0 nch W=4e-06 L=1e-06
rgc3_e6_rdis gc3_e6_vmd vrest 220000
ngc3_e6_rp gc3_e6_rt gc3_e6_qb vdd vsrc pch W=2e-06 L=1e-06
rgc3_e6_rrc gc3_e6_rt gc3_e6_rec 10000
cgc3_e6_rc gc3_e6_rec 0 1e-07
rgc3_e6_rr gc3_e6_rec 0 8.2e+06
ngc3_e6_sh1 gc3_e6_vm gc3_e6_rec gc3_e6_vms 0 nch W=2e-06 L=1e-06
ngc3_e6_sh2 gc3_e6_vms gc3_e6_qb vrest 0 nch W=2e-06 L=1e-06
ngc3_e6_porh gc3_e6_h por_hold vthe 0 nch W=2e-06 L=1e-06
ngc3_e6_porm gc3_e6_vm por_hold vrest 0 nch W=2e-06 L=1e-06
ngc3_e6_ip gc3_e6_vm s3_yb vdd vsrc pch W=4e-06 L=4e-06
ngc3_e6_in gc3_e6_vm s3_za 0 0 nch W=4e-06 L=4e-06
ngc3_b6_sw gc3_b6_t gc3_e6_qb vdd vsrc pch W=2e-06 L=1e-06
rgc3_b6_rc gc3_b6_t gc3_b6 10000
cgc3_b6_c gc3_b6 0 1e-07
rgc3_b6_rl gc3_b6 0 2.2e+07
ngc3_b6_sh1p gc3_b6_n gc3_b6 vdd vsrc pch W=2.4e-06 L=5e-07
ngc3_b6_sh1n gc3_b6_n gc3_b6 0 0 nch W=1.2e-06 L=5e-07
ngc3_b6_sh2p gc3_b6_q gc3_b6_n vdd vsrc pch W=2.4e-06 L=5e-07
ngc3_b6_sh2n gc3_b6_q gc3_b6_n 0 0 nch W=1.2e-06 L=5e-07
cgc3_e7_cm gc3_e7_vm 0 1e-07
rgc3_e7_rm gc3_e7_vm vrest 1e+06
ngc3_e7_bias0 gc3_e7_vm istep_n 0 0 nch W=4e-06 L=4e-06
ngc3_e7_bias1 gc3_e7_vm istep_n 0 0 nch W=4e-06 L=4e-06
ngc3_e7_bias2 gc3_e7_vm istep_n 0 0 nch W=4e-06 L=4e-06
ngc3_e7_bias3 gc3_e7_vm istep_n 0 0 nch W=4e-06 L=4e-06
ngc3_e7_bias4 gc3_e7_vm istep_n 0 0 nch W=4e-06 L=4e-06
ngc3_e7_bias5 gc3_e7_vm istep_n 0 0 nch W=4e-06 L=4e-06
ngc3_e7_bias6 gc3_e7_vm istep_n 0 0 nch W=4e-06 L=4e-06
rgc3_e7_kb vdd gc3_e7_knb 1e+06
ngc3_e7_kmb gc3_e7_knb gc3_e7_knb 0 0 nch W=4e-06 L=4e-06
ngc3_e7_kmt gc3_e7_ktail gc3_e7_knb 0 0 nch W=4e-06 L=4e-06
ngc3_e7_km1 gc3_e7_kd1 gc3_e7_vm gc3_e7_ktail 0 nch W=4e-06 L=4e-06
ngc3_e7_km2 gc3_e7_ko1 gc3_e7_h gc3_e7_ktail 0 nch W=4e-06 L=4e-06
ngc3_e7_km3 gc3_e7_kd1 gc3_e7_kd1 vdd vsrc pch W=4e-06 L=4e-06
ngc3_e7_km4 gc3_e7_ko1 gc3_e7_kd1 vdd vsrc pch W=4e-06 L=4e-06
ngc3_e7_ki1p gc3_e7_qb gc3_e7_ko1 vdd vsrc pch W=2.4e-06 L=5e-07
ngc3_e7_ki1n gc3_e7_qb gc3_e7_ko1 0 0 nch W=1.2e-06 L=5e-07
ngc3_e7_ki2p gc3_e7_q gc3_e7_qb vdd vsrc pch W=2.4e-06 L=5e-07
ngc3_e7_ki2n gc3_e7_q gc3_e7_qb 0 0 nch W=1.2e-06 L=5e-07
rgc3_e7_hra gc3_e7_h vthe 1e+06
rgc3_e7_hrf gc3_e7_h gc3_e7_qb 1.9e+07
cgc3_e7_hc gc3_e7_h 0 2.1e-09
ngc3_e7_dis gc3_e7_vm gc3_e7_q gc3_e7_vmd 0 nch W=4e-06 L=1e-06
rgc3_e7_rdis gc3_e7_vmd vrest 220000
ngc3_e7_rp gc3_e7_rt gc3_e7_qb vdd vsrc pch W=2e-06 L=1e-06
rgc3_e7_rrc gc3_e7_rt gc3_e7_rec 10000
cgc3_e7_rc gc3_e7_rec 0 1e-07
rgc3_e7_rr gc3_e7_rec 0 8.2e+06
ngc3_e7_sh1 gc3_e7_vm gc3_e7_rec gc3_e7_vms 0 nch W=2e-06 L=1e-06
ngc3_e7_sh2 gc3_e7_vms gc3_e7_qb vrest 0 nch W=2e-06 L=1e-06
ngc3_e7_porh gc3_e7_h por_hold vthe 0 nch W=2e-06 L=1e-06
ngc3_e7_porm gc3_e7_vm por_hold vrest 0 nch W=2e-06 L=1e-06
ngc3_e7_ip gc3_e7_vm s3_yb vdd vsrc pch W=4e-06 L=4e-06
ngc3_e7_in gc3_e7_vm s3_za 0 0 nch W=4e-06 L=4e-06
ngc3_b7_sw gc3_b7_t gc3_e7_qb vdd vsrc pch W=2e-06 L=1e-06
rgc3_b7_rc gc3_b7_t gc3_b7 10000
cgc3_b7_c gc3_b7 0 1e-07
rgc3_b7_rl gc3_b7 0 2.2e+07
ngc3_b7_sh1p gc3_b7_n gc3_b7 vdd vsrc pch W=2.4e-06 L=5e-07
ngc3_b7_sh1n gc3_b7_n gc3_b7 0 0 nch W=1.2e-06 L=5e-07
ngc3_b7_sh2p gc3_b7_q gc3_b7_n vdd vsrc pch W=2.4e-06 L=5e-07
ngc3_b7_sh2n gc3_b7_q gc3_b7_n 0 0 nch W=1.2e-06 L=5e-07
cgc3_e8_cm gc3_e8_vm 0 1e-07
rgc3_e8_rm gc3_e8_vm vrest 1e+06
ngc3_e8_bias0 gc3_e8_vm istep_n 0 0 nch W=4e-06 L=4e-06
ngc3_e8_bias1 gc3_e8_vm istep_n 0 0 nch W=4e-06 L=4e-06
ngc3_e8_bias2 gc3_e8_vm istep_n 0 0 nch W=4e-06 L=4e-06
ngc3_e8_bias3 gc3_e8_vm istep_n 0 0 nch W=4e-06 L=4e-06
ngc3_e8_bias4 gc3_e8_vm istep_n 0 0 nch W=4e-06 L=4e-06
ngc3_e8_bias5 gc3_e8_vm istep_n 0 0 nch W=4e-06 L=4e-06
ngc3_e8_bias6 gc3_e8_vm istep_n 0 0 nch W=4e-06 L=4e-06
ngc3_e8_bias7 gc3_e8_vm istep_n 0 0 nch W=4e-06 L=4e-06
rgc3_e8_kb vdd gc3_e8_knb 1e+06
ngc3_e8_kmb gc3_e8_knb gc3_e8_knb 0 0 nch W=4e-06 L=4e-06
ngc3_e8_kmt gc3_e8_ktail gc3_e8_knb 0 0 nch W=4e-06 L=4e-06
ngc3_e8_km1 gc3_e8_kd1 gc3_e8_vm gc3_e8_ktail 0 nch W=4e-06 L=4e-06
ngc3_e8_km2 gc3_e8_ko1 gc3_e8_h gc3_e8_ktail 0 nch W=4e-06 L=4e-06
ngc3_e8_km3 gc3_e8_kd1 gc3_e8_kd1 vdd vsrc pch W=4e-06 L=4e-06
ngc3_e8_km4 gc3_e8_ko1 gc3_e8_kd1 vdd vsrc pch W=4e-06 L=4e-06
ngc3_e8_ki1p gc3_e8_qb gc3_e8_ko1 vdd vsrc pch W=2.4e-06 L=5e-07
ngc3_e8_ki1n gc3_e8_qb gc3_e8_ko1 0 0 nch W=1.2e-06 L=5e-07
ngc3_e8_ki2p gc3_e8_q gc3_e8_qb vdd vsrc pch W=2.4e-06 L=5e-07
ngc3_e8_ki2n gc3_e8_q gc3_e8_qb 0 0 nch W=1.2e-06 L=5e-07
rgc3_e8_hra gc3_e8_h vthe 1e+06
rgc3_e8_hrf gc3_e8_h gc3_e8_qb 1.9e+07
cgc3_e8_hc gc3_e8_h 0 2.1e-09
ngc3_e8_dis gc3_e8_vm gc3_e8_q gc3_e8_vmd 0 nch W=4e-06 L=1e-06
rgc3_e8_rdis gc3_e8_vmd vrest 220000
ngc3_e8_rp gc3_e8_rt gc3_e8_qb vdd vsrc pch W=2e-06 L=1e-06
rgc3_e8_rrc gc3_e8_rt gc3_e8_rec 10000
cgc3_e8_rc gc3_e8_rec 0 1e-07
rgc3_e8_rr gc3_e8_rec 0 8.2e+06
ngc3_e8_sh1 gc3_e8_vm gc3_e8_rec gc3_e8_vms 0 nch W=2e-06 L=1e-06
ngc3_e8_sh2 gc3_e8_vms gc3_e8_qb vrest 0 nch W=2e-06 L=1e-06
ngc3_e8_porh gc3_e8_h por_hold vthe 0 nch W=2e-06 L=1e-06
ngc3_e8_porm gc3_e8_vm por_hold vrest 0 nch W=2e-06 L=1e-06
ngc3_e8_ip gc3_e8_vm s3_yb vdd vsrc pch W=4e-06 L=4e-06
ngc3_e8_in gc3_e8_vm s3_za 0 0 nch W=4e-06 L=4e-06
ngc3_b8_sw gc3_b8_t gc3_e8_qb vdd vsrc pch W=2e-06 L=1e-06
rgc3_b8_rc gc3_b8_t gc3_b8 10000
cgc3_b8_c gc3_b8 0 1e-07
rgc3_b8_rl gc3_b8 0 2.2e+07
ngc3_b8_sh1p gc3_b8_n gc3_b8 vdd vsrc pch W=2.4e-06 L=5e-07
ngc3_b8_sh1n gc3_b8_n gc3_b8 0 0 nch W=1.2e-06 L=5e-07
ngc3_b8_sh2p gc3_b8_q gc3_b8_n vdd vsrc pch W=2.4e-06 L=5e-07
ngc3_b8_sh2n gc3_b8_q gc3_b8_n 0 0 nch W=1.2e-06 L=5e-07
cgc3_e9_cm gc3_e9_vm 0 1e-07
rgc3_e9_rm gc3_e9_vm vrest 1e+06
ngc3_e9_bias0 gc3_e9_vm istep_n 0 0 nch W=4e-06 L=4e-06
ngc3_e9_bias1 gc3_e9_vm istep_n 0 0 nch W=4e-06 L=4e-06
ngc3_e9_bias2 gc3_e9_vm istep_n 0 0 nch W=4e-06 L=4e-06
ngc3_e9_bias3 gc3_e9_vm istep_n 0 0 nch W=4e-06 L=4e-06
ngc3_e9_bias4 gc3_e9_vm istep_n 0 0 nch W=4e-06 L=4e-06
ngc3_e9_bias5 gc3_e9_vm istep_n 0 0 nch W=4e-06 L=4e-06
ngc3_e9_bias6 gc3_e9_vm istep_n 0 0 nch W=4e-06 L=4e-06
ngc3_e9_bias7 gc3_e9_vm istep_n 0 0 nch W=4e-06 L=4e-06
ngc3_e9_bias8 gc3_e9_vm istep_n 0 0 nch W=4e-06 L=4e-06
rgc3_e9_kb vdd gc3_e9_knb 1e+06
ngc3_e9_kmb gc3_e9_knb gc3_e9_knb 0 0 nch W=4e-06 L=4e-06
ngc3_e9_kmt gc3_e9_ktail gc3_e9_knb 0 0 nch W=4e-06 L=4e-06
ngc3_e9_km1 gc3_e9_kd1 gc3_e9_vm gc3_e9_ktail 0 nch W=4e-06 L=4e-06
ngc3_e9_km2 gc3_e9_ko1 gc3_e9_h gc3_e9_ktail 0 nch W=4e-06 L=4e-06
ngc3_e9_km3 gc3_e9_kd1 gc3_e9_kd1 vdd vsrc pch W=4e-06 L=4e-06
ngc3_e9_km4 gc3_e9_ko1 gc3_e9_kd1 vdd vsrc pch W=4e-06 L=4e-06
ngc3_e9_ki1p gc3_e9_qb gc3_e9_ko1 vdd vsrc pch W=2.4e-06 L=5e-07
ngc3_e9_ki1n gc3_e9_qb gc3_e9_ko1 0 0 nch W=1.2e-06 L=5e-07
ngc3_e9_ki2p gc3_e9_q gc3_e9_qb vdd vsrc pch W=2.4e-06 L=5e-07
ngc3_e9_ki2n gc3_e9_q gc3_e9_qb 0 0 nch W=1.2e-06 L=5e-07
rgc3_e9_hra gc3_e9_h vthe 1e+06
rgc3_e9_hrf gc3_e9_h gc3_e9_qb 1.9e+07
cgc3_e9_hc gc3_e9_h 0 2.1e-09
ngc3_e9_dis gc3_e9_vm gc3_e9_q gc3_e9_vmd 0 nch W=4e-06 L=1e-06
rgc3_e9_rdis gc3_e9_vmd vrest 220000
ngc3_e9_rp gc3_e9_rt gc3_e9_qb vdd vsrc pch W=2e-06 L=1e-06
rgc3_e9_rrc gc3_e9_rt gc3_e9_rec 10000
cgc3_e9_rc gc3_e9_rec 0 1e-07
rgc3_e9_rr gc3_e9_rec 0 8.2e+06
ngc3_e9_sh1 gc3_e9_vm gc3_e9_rec gc3_e9_vms 0 nch W=2e-06 L=1e-06
ngc3_e9_sh2 gc3_e9_vms gc3_e9_qb vrest 0 nch W=2e-06 L=1e-06
ngc3_e9_porh gc3_e9_h por_hold vthe 0 nch W=2e-06 L=1e-06
ngc3_e9_porm gc3_e9_vm por_hold vrest 0 nch W=2e-06 L=1e-06
ngc3_e9_ip gc3_e9_vm s3_yb vdd vsrc pch W=4e-06 L=4e-06
ngc3_e9_in gc3_e9_vm s3_za 0 0 nch W=4e-06 L=4e-06
ngc3_b9_sw gc3_b9_t gc3_e9_qb vdd vsrc pch W=2e-06 L=1e-06
rgc3_b9_rc gc3_b9_t gc3_b9 10000
cgc3_b9_c gc3_b9 0 1e-07
rgc3_b9_rl gc3_b9 0 2.2e+07
ngc3_b9_sh1p gc3_b9_n gc3_b9 vdd vsrc pch W=2.4e-06 L=5e-07
ngc3_b9_sh1n gc3_b9_n gc3_b9 0 0 nch W=1.2e-06 L=5e-07
ngc3_b9_sh2p gc3_b9_q gc3_b9_n vdd vsrc pch W=2.4e-06 L=5e-07
ngc3_b9_sh2n gc3_b9_q gc3_b9_n 0 0 nch W=1.2e-06 L=5e-07
cgc3_e10_cm gc3_e10_vm 0 1e-07
rgc3_e10_rm gc3_e10_vm vrest 1e+06
ngc3_e10_bias0 gc3_e10_vm istep_n 0 0 nch W=4e-06 L=4e-06
ngc3_e10_bias1 gc3_e10_vm istep_n 0 0 nch W=4e-06 L=4e-06
ngc3_e10_bias2 gc3_e10_vm istep_n 0 0 nch W=4e-06 L=4e-06
ngc3_e10_bias3 gc3_e10_vm istep_n 0 0 nch W=4e-06 L=4e-06
ngc3_e10_bias4 gc3_e10_vm istep_n 0 0 nch W=4e-06 L=4e-06
ngc3_e10_bias5 gc3_e10_vm istep_n 0 0 nch W=4e-06 L=4e-06
ngc3_e10_bias6 gc3_e10_vm istep_n 0 0 nch W=4e-06 L=4e-06
ngc3_e10_bias7 gc3_e10_vm istep_n 0 0 nch W=4e-06 L=4e-06
ngc3_e10_bias8 gc3_e10_vm istep_n 0 0 nch W=4e-06 L=4e-06
ngc3_e10_bias9 gc3_e10_vm istep_n 0 0 nch W=4e-06 L=4e-06
rgc3_e10_kb vdd gc3_e10_knb 1e+06
ngc3_e10_kmb gc3_e10_knb gc3_e10_knb 0 0 nch W=4e-06 L=4e-06
ngc3_e10_kmt gc3_e10_ktail gc3_e10_knb 0 0 nch W=4e-06 L=4e-06
ngc3_e10_km1 gc3_e10_kd1 gc3_e10_vm gc3_e10_ktail 0 nch W=4e-06 L=4e-06
ngc3_e10_km2 gc3_e10_ko1 gc3_e10_h gc3_e10_ktail 0 nch W=4e-06 L=4e-06
ngc3_e10_km3 gc3_e10_kd1 gc3_e10_kd1 vdd vsrc pch W=4e-06 L=4e-06
ngc3_e10_km4 gc3_e10_ko1 gc3_e10_kd1 vdd vsrc pch W=4e-06 L=4e-06
ngc3_e10_ki1p gc3_e10_qb gc3_e10_ko1 vdd vsrc pch W=2.4e-06 L=5e-07
ngc3_e10_ki1n gc3_e10_qb gc3_e10_ko1 0 0 nch W=1.2e-06 L=5e-07
ngc3_e10_ki2p gc3_e10_q gc3_e10_qb vdd vsrc pch W=2.4e-06 L=5e-07
ngc3_e10_ki2n gc3_e10_q gc3_e10_qb 0 0 nch W=1.2e-06 L=5e-07
rgc3_e10_hra gc3_e10_h vthe 1e+06
rgc3_e10_hrf gc3_e10_h gc3_e10_qb 1.9e+07
cgc3_e10_hc gc3_e10_h 0 2.1e-09
ngc3_e10_dis gc3_e10_vm gc3_e10_q gc3_e10_vmd 0 nch W=4e-06 L=1e-06
rgc3_e10_rdis gc3_e10_vmd vrest 220000
ngc3_e10_rp gc3_e10_rt gc3_e10_qb vdd vsrc pch W=2e-06 L=1e-06
rgc3_e10_rrc gc3_e10_rt gc3_e10_rec 10000
cgc3_e10_rc gc3_e10_rec 0 1e-07
rgc3_e10_rr gc3_e10_rec 0 8.2e+06
ngc3_e10_sh1 gc3_e10_vm gc3_e10_rec gc3_e10_vms 0 nch W=2e-06 L=1e-06
ngc3_e10_sh2 gc3_e10_vms gc3_e10_qb vrest 0 nch W=2e-06 L=1e-06
ngc3_e10_porh gc3_e10_h por_hold vthe 0 nch W=2e-06 L=1e-06
ngc3_e10_porm gc3_e10_vm por_hold vrest 0 nch W=2e-06 L=1e-06
ngc3_e10_ip gc3_e10_vm s3_yb vdd vsrc pch W=4e-06 L=4e-06
ngc3_e10_in gc3_e10_vm s3_za 0 0 nch W=4e-06 L=4e-06
ngc3_b10_sw gc3_b10_t gc3_e10_qb vdd vsrc pch W=2e-06 L=1e-06
rgc3_b10_rc gc3_b10_t gc3_b10 10000
cgc3_b10_c gc3_b10 0 1e-07
rgc3_b10_rl gc3_b10 0 2.2e+07
ngc3_b10_sh1p gc3_b10_n gc3_b10 vdd vsrc pch W=2.4e-06 L=5e-07
ngc3_b10_sh1n gc3_b10_n gc3_b10 0 0 nch W=1.2e-06 L=5e-07
ngc3_b10_sh2p gc3_b10_q gc3_b10_n vdd vsrc pch W=2.4e-06 L=5e-07
ngc3_b10_sh2n gc3_b10_q gc3_b10_n 0 0 nch W=1.2e-06 L=5e-07
ngc3_and_a0_npa gc3_and_a0_nb gc3_b1_q vdd vsrc pch W=2.4e-06 L=5e-07
ngc3_and_a0_npb gc3_and_a0_nb gc3_b2_q vdd vsrc pch W=2.4e-06 L=5e-07
ngc3_and_a0_nna gc3_and_a0_nb gc3_b1_q gc3_and_a0_nx 0 nch W=2.4e-06 L=5e-07
ngc3_and_a0_nnb gc3_and_a0_nx gc3_b2_q 0 0 nch W=2.4e-06 L=5e-07
ngc3_and_a0_ip gc3_and_g0 gc3_and_a0_nb vdd vsrc pch W=2.4e-06 L=5e-07
ngc3_and_a0_in gc3_and_g0 gc3_and_a0_nb 0 0 nch W=1.2e-06 L=5e-07
ngc3_and_a1_npa gc3_and_a1_nb gc3_b3_q vdd vsrc pch W=2.4e-06 L=5e-07
ngc3_and_a1_npb gc3_and_a1_nb gc3_b4_q vdd vsrc pch W=2.4e-06 L=5e-07
ngc3_and_a1_nna gc3_and_a1_nb gc3_b3_q gc3_and_a1_nx 0 nch W=2.4e-06 L=5e-07
ngc3_and_a1_nnb gc3_and_a1_nx gc3_b4_q 0 0 nch W=2.4e-06 L=5e-07
ngc3_and_a1_ip gc3_and_g1 gc3_and_a1_nb vdd vsrc pch W=2.4e-06 L=5e-07
ngc3_and_a1_in gc3_and_g1 gc3_and_a1_nb 0 0 nch W=1.2e-06 L=5e-07
ngc3_and_a2_npa gc3_and_a2_nb gc3_b5_q vdd vsrc pch W=2.4e-06 L=5e-07
ngc3_and_a2_npb gc3_and_a2_nb gc3_b6_q vdd vsrc pch W=2.4e-06 L=5e-07
ngc3_and_a2_nna gc3_and_a2_nb gc3_b5_q gc3_and_a2_nx 0 nch W=2.4e-06 L=5e-07
ngc3_and_a2_nnb gc3_and_a2_nx gc3_b6_q 0 0 nch W=2.4e-06 L=5e-07
ngc3_and_a2_ip gc3_and_g2 gc3_and_a2_nb vdd vsrc pch W=2.4e-06 L=5e-07
ngc3_and_a2_in gc3_and_g2 gc3_and_a2_nb 0 0 nch W=1.2e-06 L=5e-07
ngc3_and_a3_npa gc3_and_a3_nb gc3_b7_q vdd vsrc pch W=2.4e-06 L=5e-07
ngc3_and_a3_npb gc3_and_a3_nb gc3_b8_q vdd vsrc pch W=2.4e-06 L=5e-07
ngc3_and_a3_nna gc3_and_a3_nb gc3_b7_q gc3_and_a3_nx 0 nch W=2.4e-06 L=5e-07
ngc3_and_a3_nnb gc3_and_a3_nx gc3_b8_q 0 0 nch W=2.4e-06 L=5e-07
ngc3_and_a3_ip gc3_and_g3 gc3_and_a3_nb vdd vsrc pch W=2.4e-06 L=5e-07
ngc3_and_a3_in gc3_and_g3 gc3_and_a3_nb 0 0 nch W=1.2e-06 L=5e-07
ngc3_and_a4_npa gc3_and_a4_nb gc3_b9_q vdd vsrc pch W=2.4e-06 L=5e-07
ngc3_and_a4_npb gc3_and_a4_nb gc3_b10_q vdd vsrc pch W=2.4e-06 L=5e-07
ngc3_and_a4_nna gc3_and_a4_nb gc3_b9_q gc3_and_a4_nx 0 nch W=2.4e-06 L=5e-07
ngc3_and_a4_nnb gc3_and_a4_nx gc3_b10_q 0 0 nch W=2.4e-06 L=5e-07
ngc3_and_a4_ip gc3_and_g4 gc3_and_a4_nb vdd vsrc pch W=2.4e-06 L=5e-07
ngc3_and_a4_in gc3_and_g4 gc3_and_a4_nb 0 0 nch W=1.2e-06 L=5e-07
ngc3_and_a5_npa gc3_and_a5_nb gc3_and_g0 vdd vsrc pch W=2.4e-06 L=5e-07
ngc3_and_a5_npb gc3_and_a5_nb gc3_and_g1 vdd vsrc pch W=2.4e-06 L=5e-07
ngc3_and_a5_nna gc3_and_a5_nb gc3_and_g0 gc3_and_a5_nx 0 nch W=2.4e-06 L=5e-07
ngc3_and_a5_nnb gc3_and_a5_nx gc3_and_g1 0 0 nch W=2.4e-06 L=5e-07
ngc3_and_a5_ip gc3_and_g5 gc3_and_a5_nb vdd vsrc pch W=2.4e-06 L=5e-07
ngc3_and_a5_in gc3_and_g5 gc3_and_a5_nb 0 0 nch W=1.2e-06 L=5e-07
ngc3_and_a6_npa gc3_and_a6_nb gc3_and_g2 vdd vsrc pch W=2.4e-06 L=5e-07
ngc3_and_a6_npb gc3_and_a6_nb gc3_and_g3 vdd vsrc pch W=2.4e-06 L=5e-07
ngc3_and_a6_nna gc3_and_a6_nb gc3_and_g2 gc3_and_a6_nx 0 nch W=2.4e-06 L=5e-07
ngc3_and_a6_nnb gc3_and_a6_nx gc3_and_g3 0 0 nch W=2.4e-06 L=5e-07
ngc3_and_a6_ip gc3_and_g6 gc3_and_a6_nb vdd vsrc pch W=2.4e-06 L=5e-07
ngc3_and_a6_in gc3_and_g6 gc3_and_a6_nb 0 0 nch W=1.2e-06 L=5e-07
ngc3_and_a7_npa gc3_and_a7_nb gc3_and_g5 vdd vsrc pch W=2.4e-06 L=5e-07
ngc3_and_a7_npb gc3_and_a7_nb gc3_and_g6 vdd vsrc pch W=2.4e-06 L=5e-07
ngc3_and_a7_nna gc3_and_a7_nb gc3_and_g5 gc3_and_a7_nx 0 nch W=2.4e-06 L=5e-07
ngc3_and_a7_nnb gc3_and_a7_nx gc3_and_g6 0 0 nch W=2.4e-06 L=5e-07
ngc3_and_a7_ip gc3_and_g7 gc3_and_a7_nb vdd vsrc pch W=2.4e-06 L=5e-07
ngc3_and_a7_in gc3_and_g7 gc3_and_a7_nb 0 0 nch W=1.2e-06 L=5e-07
ngc3_and_a8_npa gc3_and_a8_nb gc3_and_g7 vdd vsrc pch W=2.4e-06 L=5e-07
ngc3_and_a8_npb gc3_and_a8_nb gc3_and_g4 vdd vsrc pch W=2.4e-06 L=5e-07
ngc3_and_a8_nna gc3_and_a8_nb gc3_and_g7 gc3_and_a8_nx 0 nch W=2.4e-06 L=5e-07
ngc3_and_a8_nnb gc3_and_a8_nx gc3_and_g4 0 0 nch W=2.4e-06 L=5e-07
ngc3_and_a8_ip gc3_and_g8 gc3_and_a8_nb vdd vsrc pch W=2.4e-06 L=5e-07
ngc3_and_a8_in gc3_and_g8 gc3_and_a8_nb 0 0 nch W=1.2e-06 L=5e-07
ngc3_gip gc3_gb gc3_and_g8 vdd vsrc pch W=2.4e-06 L=5e-07
ngc3_gin gc3_gb gc3_and_g8 0 0 nch W=1.2e-06 L=5e-07
cgc3_col_cm gc3_col_vm 0 1e-07
rgc3_col_rm gc3_col_vm vrest 1e+06
rgc3_col_kb vdd gc3_col_knb 1e+06
ngc3_col_kmb gc3_col_knb gc3_col_knb 0 0 nch W=4e-06 L=4e-06
ngc3_col_kmt gc3_col_ktail gc3_col_knb 0 0 nch W=4e-06 L=4e-06
ngc3_col_km1 gc3_col_kd1 gc3_col_vm gc3_col_ktail 0 nch W=4e-06 L=4e-06
ngc3_col_km2 gc3_col_ko1 gc3_col_h gc3_col_ktail 0 nch W=4e-06 L=4e-06
ngc3_col_km3 gc3_col_kd1 gc3_col_kd1 vdd vsrc pch W=4e-06 L=4e-06
ngc3_col_km4 gc3_col_ko1 gc3_col_kd1 vdd vsrc pch W=4e-06 L=4e-06
ngc3_col_ki1p gc3_col_qb gc3_col_ko1 vdd vsrc pch W=2.4e-06 L=5e-07
ngc3_col_ki1n gc3_col_qb gc3_col_ko1 0 0 nch W=1.2e-06 L=5e-07
ngc3_col_ki2p gc3_col_q gc3_col_qb vdd vsrc pch W=2.4e-06 L=5e-07
ngc3_col_ki2n gc3_col_q gc3_col_qb 0 0 nch W=1.2e-06 L=5e-07
rgc3_col_hra gc3_col_h vthe 1e+06
rgc3_col_hrf gc3_col_h gc3_col_qb 1.9e+07
cgc3_col_hc gc3_col_h 0 2.1e-09
ngc3_col_dis gc3_col_vm gc3_col_q gc3_col_vmd 0 nch W=4e-06 L=1e-06
rgc3_col_rdis gc3_col_vmd vrest 220000
ngc3_col_rp gc3_col_rt gc3_col_qb vdd vsrc pch W=2e-06 L=1e-06
rgc3_col_rrc gc3_col_rt gc3_col_rec 10000
cgc3_col_rc gc3_col_rec 0 1e-07
rgc3_col_rr gc3_col_rec 0 8.2e+06
ngc3_col_sh1 gc3_col_vm gc3_col_rec gc3_col_vms 0 nch W=2e-06 L=1e-06
ngc3_col_sh2 gc3_col_vms gc3_col_qb vrest 0 nch W=2e-06 L=1e-06
ngc3_col_porh gc3_col_h por_hold vthe 0 nch W=2e-06 L=1e-06
ngc3_col_porm gc3_col_vm por_hold vrest 0 nch W=2e-06 L=1e-06
ngc3_cin_sw gc3_cin_x gc3_gb vdd vsrc pch W=4e-06 L=1e-06
ngc3_cin_cp gc3_col_vm ilimp_n gc3_cin_x vsrc pch W=4e-06 L=4e-06
ngc3_op_tsw gc3_op_tt gc3_col_qb vdd vsrc pch W=2e-06 L=1e-06
rgc3_op_trc gc3_op_tt gc3_op_at 10000
cgc3_op_tc gc3_op_at 0 1e-07
rgc3_op_trl gc3_op_at 0 2.2e+07
ngc3_op_sh1p gc3_op_an gc3_op_at vdd vsrc pch W=2.4e-06 L=5e-07
ngc3_op_sh1n gc3_op_an gc3_op_at 0 0 nch W=1.2e-06 L=5e-07
ngc3_op_sh2p gc3_op_aq gc3_op_an vdd vsrc pch W=2.4e-06 L=5e-07
ngc3_op_sh2n gc3_op_aq gc3_op_an 0 0 nch W=1.2e-06 L=5e-07
ngc3_op_abp gc3_op_aqb gc3_op_aq vdd vsrc pch W=2.4e-06 L=5e-07
ngc3_op_abn gc3_op_aqb gc3_op_aq 0 0 nch W=1.2e-06 L=5e-07
rgc3_op_dr gc3_op_aq gc3_op_ad 1e+06
cgc3_op_dc gc3_op_ad 0 3.3e-07
ngc3_op_d2p gc3_op_adn gc3_op_ad vdd vsrc pch W=2.4e-06 L=5e-07
ngc3_op_d2n gc3_op_adn gc3_op_ad 0 0 nch W=1.2e-06 L=5e-07
ngc3_op_gpa gc3_op_pb gc3_op_aq vdd vsrc pch W=2.4e-06 L=5e-07
ngc3_op_gpb gc3_op_pb gc3_op_adn vdd vsrc pch W=2.4e-06 L=5e-07
ngc3_op_gna gc3_op_pb gc3_op_aq gc3_op_gx 0 nch W=2.4e-06 L=5e-07
ngc3_op_gnb gc3_op_gx gc3_op_adn 0 0 nch W=2.4e-06 L=5e-07
ngc3_op_op gc3_op_p gc3_op_pb vdd vsrc pch W=2.4e-06 L=5e-07
ngc3_op_on gc3_op_p gc3_op_pb 0 0 nch W=1.2e-06 L=5e-07
cgc4_e1_cm gc4_e1_vm 0 1e-07
rgc4_e1_rm gc4_e1_vm vrest 1e+06
ngc4_e1_bias0 gc4_e1_vm istep_n 0 0 nch W=4e-06 L=4e-06
rgc4_e1_kb vdd gc4_e1_knb 1e+06
ngc4_e1_kmb gc4_e1_knb gc4_e1_knb 0 0 nch W=4e-06 L=4e-06
ngc4_e1_kmt gc4_e1_ktail gc4_e1_knb 0 0 nch W=4e-06 L=4e-06
ngc4_e1_km1 gc4_e1_kd1 gc4_e1_vm gc4_e1_ktail 0 nch W=4e-06 L=4e-06
ngc4_e1_km2 gc4_e1_ko1 gc4_e1_h gc4_e1_ktail 0 nch W=4e-06 L=4e-06
ngc4_e1_km3 gc4_e1_kd1 gc4_e1_kd1 vdd vsrc pch W=4e-06 L=4e-06
ngc4_e1_km4 gc4_e1_ko1 gc4_e1_kd1 vdd vsrc pch W=4e-06 L=4e-06
ngc4_e1_ki1p gc4_e1_qb gc4_e1_ko1 vdd vsrc pch W=2.4e-06 L=5e-07
ngc4_e1_ki1n gc4_e1_qb gc4_e1_ko1 0 0 nch W=1.2e-06 L=5e-07
ngc4_e1_ki2p gc4_e1_q gc4_e1_qb vdd vsrc pch W=2.4e-06 L=5e-07
ngc4_e1_ki2n gc4_e1_q gc4_e1_qb 0 0 nch W=1.2e-06 L=5e-07
rgc4_e1_hra gc4_e1_h vthe 1e+06
rgc4_e1_hrf gc4_e1_h gc4_e1_qb 1.9e+07
cgc4_e1_hc gc4_e1_h 0 2.1e-09
ngc4_e1_dis gc4_e1_vm gc4_e1_q gc4_e1_vmd 0 nch W=4e-06 L=1e-06
rgc4_e1_rdis gc4_e1_vmd vrest 220000
ngc4_e1_rp gc4_e1_rt gc4_e1_qb vdd vsrc pch W=2e-06 L=1e-06
rgc4_e1_rrc gc4_e1_rt gc4_e1_rec 10000
cgc4_e1_rc gc4_e1_rec 0 1e-07
rgc4_e1_rr gc4_e1_rec 0 8.2e+06
ngc4_e1_sh1 gc4_e1_vm gc4_e1_rec gc4_e1_vms 0 nch W=2e-06 L=1e-06
ngc4_e1_sh2 gc4_e1_vms gc4_e1_qb vrest 0 nch W=2e-06 L=1e-06
ngc4_e1_porh gc4_e1_h por_hold vthe 0 nch W=2e-06 L=1e-06
ngc4_e1_porm gc4_e1_vm por_hold vrest 0 nch W=2e-06 L=1e-06
ngc4_e1_ip gc4_e1_vm s4_yb vdd vsrc pch W=4e-06 L=4e-06
ngc4_e1_in gc4_e1_vm s4_za 0 0 nch W=4e-06 L=4e-06
ngc4_b1_sw gc4_b1_t gc4_e1_qb vdd vsrc pch W=2e-06 L=1e-06
rgc4_b1_rc gc4_b1_t gc4_b1 10000
cgc4_b1_c gc4_b1 0 1e-07
rgc4_b1_rl gc4_b1 0 2.2e+07
ngc4_b1_sh1p gc4_b1_n gc4_b1 vdd vsrc pch W=2.4e-06 L=5e-07
ngc4_b1_sh1n gc4_b1_n gc4_b1 0 0 nch W=1.2e-06 L=5e-07
ngc4_b1_sh2p gc4_b1_q gc4_b1_n vdd vsrc pch W=2.4e-06 L=5e-07
ngc4_b1_sh2n gc4_b1_q gc4_b1_n 0 0 nch W=1.2e-06 L=5e-07
cgc4_e2_cm gc4_e2_vm 0 1e-07
rgc4_e2_rm gc4_e2_vm vrest 1e+06
ngc4_e2_bias0 gc4_e2_vm istep_n 0 0 nch W=4e-06 L=4e-06
ngc4_e2_bias1 gc4_e2_vm istep_n 0 0 nch W=4e-06 L=4e-06
rgc4_e2_kb vdd gc4_e2_knb 1e+06
ngc4_e2_kmb gc4_e2_knb gc4_e2_knb 0 0 nch W=4e-06 L=4e-06
ngc4_e2_kmt gc4_e2_ktail gc4_e2_knb 0 0 nch W=4e-06 L=4e-06
ngc4_e2_km1 gc4_e2_kd1 gc4_e2_vm gc4_e2_ktail 0 nch W=4e-06 L=4e-06
ngc4_e2_km2 gc4_e2_ko1 gc4_e2_h gc4_e2_ktail 0 nch W=4e-06 L=4e-06
ngc4_e2_km3 gc4_e2_kd1 gc4_e2_kd1 vdd vsrc pch W=4e-06 L=4e-06
ngc4_e2_km4 gc4_e2_ko1 gc4_e2_kd1 vdd vsrc pch W=4e-06 L=4e-06
ngc4_e2_ki1p gc4_e2_qb gc4_e2_ko1 vdd vsrc pch W=2.4e-06 L=5e-07
ngc4_e2_ki1n gc4_e2_qb gc4_e2_ko1 0 0 nch W=1.2e-06 L=5e-07
ngc4_e2_ki2p gc4_e2_q gc4_e2_qb vdd vsrc pch W=2.4e-06 L=5e-07
ngc4_e2_ki2n gc4_e2_q gc4_e2_qb 0 0 nch W=1.2e-06 L=5e-07
rgc4_e2_hra gc4_e2_h vthe 1e+06
rgc4_e2_hrf gc4_e2_h gc4_e2_qb 1.9e+07
cgc4_e2_hc gc4_e2_h 0 2.1e-09
ngc4_e2_dis gc4_e2_vm gc4_e2_q gc4_e2_vmd 0 nch W=4e-06 L=1e-06
rgc4_e2_rdis gc4_e2_vmd vrest 220000
ngc4_e2_rp gc4_e2_rt gc4_e2_qb vdd vsrc pch W=2e-06 L=1e-06
rgc4_e2_rrc gc4_e2_rt gc4_e2_rec 10000
cgc4_e2_rc gc4_e2_rec 0 1e-07
rgc4_e2_rr gc4_e2_rec 0 8.2e+06
ngc4_e2_sh1 gc4_e2_vm gc4_e2_rec gc4_e2_vms 0 nch W=2e-06 L=1e-06
ngc4_e2_sh2 gc4_e2_vms gc4_e2_qb vrest 0 nch W=2e-06 L=1e-06
ngc4_e2_porh gc4_e2_h por_hold vthe 0 nch W=2e-06 L=1e-06
ngc4_e2_porm gc4_e2_vm por_hold vrest 0 nch W=2e-06 L=1e-06
ngc4_e2_ip gc4_e2_vm s4_yb vdd vsrc pch W=4e-06 L=4e-06
ngc4_e2_in gc4_e2_vm s4_za 0 0 nch W=4e-06 L=4e-06
ngc4_b2_sw gc4_b2_t gc4_e2_qb vdd vsrc pch W=2e-06 L=1e-06
rgc4_b2_rc gc4_b2_t gc4_b2 10000
cgc4_b2_c gc4_b2 0 1e-07
rgc4_b2_rl gc4_b2 0 2.2e+07
ngc4_b2_sh1p gc4_b2_n gc4_b2 vdd vsrc pch W=2.4e-06 L=5e-07
ngc4_b2_sh1n gc4_b2_n gc4_b2 0 0 nch W=1.2e-06 L=5e-07
ngc4_b2_sh2p gc4_b2_q gc4_b2_n vdd vsrc pch W=2.4e-06 L=5e-07
ngc4_b2_sh2n gc4_b2_q gc4_b2_n 0 0 nch W=1.2e-06 L=5e-07
cgc4_e3_cm gc4_e3_vm 0 1e-07
rgc4_e3_rm gc4_e3_vm vrest 1e+06
ngc4_e3_bias0 gc4_e3_vm istep_n 0 0 nch W=4e-06 L=4e-06
ngc4_e3_bias1 gc4_e3_vm istep_n 0 0 nch W=4e-06 L=4e-06
ngc4_e3_bias2 gc4_e3_vm istep_n 0 0 nch W=4e-06 L=4e-06
rgc4_e3_kb vdd gc4_e3_knb 1e+06
ngc4_e3_kmb gc4_e3_knb gc4_e3_knb 0 0 nch W=4e-06 L=4e-06
ngc4_e3_kmt gc4_e3_ktail gc4_e3_knb 0 0 nch W=4e-06 L=4e-06
ngc4_e3_km1 gc4_e3_kd1 gc4_e3_vm gc4_e3_ktail 0 nch W=4e-06 L=4e-06
ngc4_e3_km2 gc4_e3_ko1 gc4_e3_h gc4_e3_ktail 0 nch W=4e-06 L=4e-06
ngc4_e3_km3 gc4_e3_kd1 gc4_e3_kd1 vdd vsrc pch W=4e-06 L=4e-06
ngc4_e3_km4 gc4_e3_ko1 gc4_e3_kd1 vdd vsrc pch W=4e-06 L=4e-06
ngc4_e3_ki1p gc4_e3_qb gc4_e3_ko1 vdd vsrc pch W=2.4e-06 L=5e-07
ngc4_e3_ki1n gc4_e3_qb gc4_e3_ko1 0 0 nch W=1.2e-06 L=5e-07
ngc4_e3_ki2p gc4_e3_q gc4_e3_qb vdd vsrc pch W=2.4e-06 L=5e-07
ngc4_e3_ki2n gc4_e3_q gc4_e3_qb 0 0 nch W=1.2e-06 L=5e-07
rgc4_e3_hra gc4_e3_h vthe 1e+06
rgc4_e3_hrf gc4_e3_h gc4_e3_qb 1.9e+07
cgc4_e3_hc gc4_e3_h 0 2.1e-09
ngc4_e3_dis gc4_e3_vm gc4_e3_q gc4_e3_vmd 0 nch W=4e-06 L=1e-06
rgc4_e3_rdis gc4_e3_vmd vrest 220000
ngc4_e3_rp gc4_e3_rt gc4_e3_qb vdd vsrc pch W=2e-06 L=1e-06
rgc4_e3_rrc gc4_e3_rt gc4_e3_rec 10000
cgc4_e3_rc gc4_e3_rec 0 1e-07
rgc4_e3_rr gc4_e3_rec 0 8.2e+06
ngc4_e3_sh1 gc4_e3_vm gc4_e3_rec gc4_e3_vms 0 nch W=2e-06 L=1e-06
ngc4_e3_sh2 gc4_e3_vms gc4_e3_qb vrest 0 nch W=2e-06 L=1e-06
ngc4_e3_porh gc4_e3_h por_hold vthe 0 nch W=2e-06 L=1e-06
ngc4_e3_porm gc4_e3_vm por_hold vrest 0 nch W=2e-06 L=1e-06
ngc4_e3_ip gc4_e3_vm s4_yb vdd vsrc pch W=4e-06 L=4e-06
ngc4_e3_in gc4_e3_vm s4_za 0 0 nch W=4e-06 L=4e-06
ngc4_b3_sw gc4_b3_t gc4_e3_qb vdd vsrc pch W=2e-06 L=1e-06
rgc4_b3_rc gc4_b3_t gc4_b3 10000
cgc4_b3_c gc4_b3 0 1e-07
rgc4_b3_rl gc4_b3 0 2.2e+07
ngc4_b3_sh1p gc4_b3_n gc4_b3 vdd vsrc pch W=2.4e-06 L=5e-07
ngc4_b3_sh1n gc4_b3_n gc4_b3 0 0 nch W=1.2e-06 L=5e-07
ngc4_b3_sh2p gc4_b3_q gc4_b3_n vdd vsrc pch W=2.4e-06 L=5e-07
ngc4_b3_sh2n gc4_b3_q gc4_b3_n 0 0 nch W=1.2e-06 L=5e-07
cgc4_e4_cm gc4_e4_vm 0 1e-07
rgc4_e4_rm gc4_e4_vm vrest 1e+06
ngc4_e4_bias0 gc4_e4_vm istep_n 0 0 nch W=4e-06 L=4e-06
ngc4_e4_bias1 gc4_e4_vm istep_n 0 0 nch W=4e-06 L=4e-06
ngc4_e4_bias2 gc4_e4_vm istep_n 0 0 nch W=4e-06 L=4e-06
ngc4_e4_bias3 gc4_e4_vm istep_n 0 0 nch W=4e-06 L=4e-06
rgc4_e4_kb vdd gc4_e4_knb 1e+06
ngc4_e4_kmb gc4_e4_knb gc4_e4_knb 0 0 nch W=4e-06 L=4e-06
ngc4_e4_kmt gc4_e4_ktail gc4_e4_knb 0 0 nch W=4e-06 L=4e-06
ngc4_e4_km1 gc4_e4_kd1 gc4_e4_vm gc4_e4_ktail 0 nch W=4e-06 L=4e-06
ngc4_e4_km2 gc4_e4_ko1 gc4_e4_h gc4_e4_ktail 0 nch W=4e-06 L=4e-06
ngc4_e4_km3 gc4_e4_kd1 gc4_e4_kd1 vdd vsrc pch W=4e-06 L=4e-06
ngc4_e4_km4 gc4_e4_ko1 gc4_e4_kd1 vdd vsrc pch W=4e-06 L=4e-06
ngc4_e4_ki1p gc4_e4_qb gc4_e4_ko1 vdd vsrc pch W=2.4e-06 L=5e-07
ngc4_e4_ki1n gc4_e4_qb gc4_e4_ko1 0 0 nch W=1.2e-06 L=5e-07
ngc4_e4_ki2p gc4_e4_q gc4_e4_qb vdd vsrc pch W=2.4e-06 L=5e-07
ngc4_e4_ki2n gc4_e4_q gc4_e4_qb 0 0 nch W=1.2e-06 L=5e-07
rgc4_e4_hra gc4_e4_h vthe 1e+06
rgc4_e4_hrf gc4_e4_h gc4_e4_qb 1.9e+07
cgc4_e4_hc gc4_e4_h 0 2.1e-09
ngc4_e4_dis gc4_e4_vm gc4_e4_q gc4_e4_vmd 0 nch W=4e-06 L=1e-06
rgc4_e4_rdis gc4_e4_vmd vrest 220000
ngc4_e4_rp gc4_e4_rt gc4_e4_qb vdd vsrc pch W=2e-06 L=1e-06
rgc4_e4_rrc gc4_e4_rt gc4_e4_rec 10000
cgc4_e4_rc gc4_e4_rec 0 1e-07
rgc4_e4_rr gc4_e4_rec 0 8.2e+06
ngc4_e4_sh1 gc4_e4_vm gc4_e4_rec gc4_e4_vms 0 nch W=2e-06 L=1e-06
ngc4_e4_sh2 gc4_e4_vms gc4_e4_qb vrest 0 nch W=2e-06 L=1e-06
ngc4_e4_porh gc4_e4_h por_hold vthe 0 nch W=2e-06 L=1e-06
ngc4_e4_porm gc4_e4_vm por_hold vrest 0 nch W=2e-06 L=1e-06
ngc4_e4_ip gc4_e4_vm s4_yb vdd vsrc pch W=4e-06 L=4e-06
ngc4_e4_in gc4_e4_vm s4_za 0 0 nch W=4e-06 L=4e-06
ngc4_b4_sw gc4_b4_t gc4_e4_qb vdd vsrc pch W=2e-06 L=1e-06
rgc4_b4_rc gc4_b4_t gc4_b4 10000
cgc4_b4_c gc4_b4 0 1e-07
rgc4_b4_rl gc4_b4 0 2.2e+07
ngc4_b4_sh1p gc4_b4_n gc4_b4 vdd vsrc pch W=2.4e-06 L=5e-07
ngc4_b4_sh1n gc4_b4_n gc4_b4 0 0 nch W=1.2e-06 L=5e-07
ngc4_b4_sh2p gc4_b4_q gc4_b4_n vdd vsrc pch W=2.4e-06 L=5e-07
ngc4_b4_sh2n gc4_b4_q gc4_b4_n 0 0 nch W=1.2e-06 L=5e-07
cgc4_e5_cm gc4_e5_vm 0 1e-07
rgc4_e5_rm gc4_e5_vm vrest 1e+06
ngc4_e5_bias0 gc4_e5_vm istep_n 0 0 nch W=4e-06 L=4e-06
ngc4_e5_bias1 gc4_e5_vm istep_n 0 0 nch W=4e-06 L=4e-06
ngc4_e5_bias2 gc4_e5_vm istep_n 0 0 nch W=4e-06 L=4e-06
ngc4_e5_bias3 gc4_e5_vm istep_n 0 0 nch W=4e-06 L=4e-06
ngc4_e5_bias4 gc4_e5_vm istep_n 0 0 nch W=4e-06 L=4e-06
rgc4_e5_kb vdd gc4_e5_knb 1e+06
ngc4_e5_kmb gc4_e5_knb gc4_e5_knb 0 0 nch W=4e-06 L=4e-06
ngc4_e5_kmt gc4_e5_ktail gc4_e5_knb 0 0 nch W=4e-06 L=4e-06
ngc4_e5_km1 gc4_e5_kd1 gc4_e5_vm gc4_e5_ktail 0 nch W=4e-06 L=4e-06
ngc4_e5_km2 gc4_e5_ko1 gc4_e5_h gc4_e5_ktail 0 nch W=4e-06 L=4e-06
ngc4_e5_km3 gc4_e5_kd1 gc4_e5_kd1 vdd vsrc pch W=4e-06 L=4e-06
ngc4_e5_km4 gc4_e5_ko1 gc4_e5_kd1 vdd vsrc pch W=4e-06 L=4e-06
ngc4_e5_ki1p gc4_e5_qb gc4_e5_ko1 vdd vsrc pch W=2.4e-06 L=5e-07
ngc4_e5_ki1n gc4_e5_qb gc4_e5_ko1 0 0 nch W=1.2e-06 L=5e-07
ngc4_e5_ki2p gc4_e5_q gc4_e5_qb vdd vsrc pch W=2.4e-06 L=5e-07
ngc4_e5_ki2n gc4_e5_q gc4_e5_qb 0 0 nch W=1.2e-06 L=5e-07
rgc4_e5_hra gc4_e5_h vthe 1e+06
rgc4_e5_hrf gc4_e5_h gc4_e5_qb 1.9e+07
cgc4_e5_hc gc4_e5_h 0 2.1e-09
ngc4_e5_dis gc4_e5_vm gc4_e5_q gc4_e5_vmd 0 nch W=4e-06 L=1e-06
rgc4_e5_rdis gc4_e5_vmd vrest 220000
ngc4_e5_rp gc4_e5_rt gc4_e5_qb vdd vsrc pch W=2e-06 L=1e-06
rgc4_e5_rrc gc4_e5_rt gc4_e5_rec 10000
cgc4_e5_rc gc4_e5_rec 0 1e-07
rgc4_e5_rr gc4_e5_rec 0 8.2e+06
ngc4_e5_sh1 gc4_e5_vm gc4_e5_rec gc4_e5_vms 0 nch W=2e-06 L=1e-06
ngc4_e5_sh2 gc4_e5_vms gc4_e5_qb vrest 0 nch W=2e-06 L=1e-06
ngc4_e5_porh gc4_e5_h por_hold vthe 0 nch W=2e-06 L=1e-06
ngc4_e5_porm gc4_e5_vm por_hold vrest 0 nch W=2e-06 L=1e-06
ngc4_e5_ip gc4_e5_vm s4_yb vdd vsrc pch W=4e-06 L=4e-06
ngc4_e5_in gc4_e5_vm s4_za 0 0 nch W=4e-06 L=4e-06
ngc4_b5_sw gc4_b5_t gc4_e5_qb vdd vsrc pch W=2e-06 L=1e-06
rgc4_b5_rc gc4_b5_t gc4_b5 10000
cgc4_b5_c gc4_b5 0 1e-07
rgc4_b5_rl gc4_b5 0 2.2e+07
ngc4_b5_sh1p gc4_b5_n gc4_b5 vdd vsrc pch W=2.4e-06 L=5e-07
ngc4_b5_sh1n gc4_b5_n gc4_b5 0 0 nch W=1.2e-06 L=5e-07
ngc4_b5_sh2p gc4_b5_q gc4_b5_n vdd vsrc pch W=2.4e-06 L=5e-07
ngc4_b5_sh2n gc4_b5_q gc4_b5_n 0 0 nch W=1.2e-06 L=5e-07
cgc4_e6_cm gc4_e6_vm 0 1e-07
rgc4_e6_rm gc4_e6_vm vrest 1e+06
ngc4_e6_bias0 gc4_e6_vm istep_n 0 0 nch W=4e-06 L=4e-06
ngc4_e6_bias1 gc4_e6_vm istep_n 0 0 nch W=4e-06 L=4e-06
ngc4_e6_bias2 gc4_e6_vm istep_n 0 0 nch W=4e-06 L=4e-06
ngc4_e6_bias3 gc4_e6_vm istep_n 0 0 nch W=4e-06 L=4e-06
ngc4_e6_bias4 gc4_e6_vm istep_n 0 0 nch W=4e-06 L=4e-06
ngc4_e6_bias5 gc4_e6_vm istep_n 0 0 nch W=4e-06 L=4e-06
rgc4_e6_kb vdd gc4_e6_knb 1e+06
ngc4_e6_kmb gc4_e6_knb gc4_e6_knb 0 0 nch W=4e-06 L=4e-06
ngc4_e6_kmt gc4_e6_ktail gc4_e6_knb 0 0 nch W=4e-06 L=4e-06
ngc4_e6_km1 gc4_e6_kd1 gc4_e6_vm gc4_e6_ktail 0 nch W=4e-06 L=4e-06
ngc4_e6_km2 gc4_e6_ko1 gc4_e6_h gc4_e6_ktail 0 nch W=4e-06 L=4e-06
ngc4_e6_km3 gc4_e6_kd1 gc4_e6_kd1 vdd vsrc pch W=4e-06 L=4e-06
ngc4_e6_km4 gc4_e6_ko1 gc4_e6_kd1 vdd vsrc pch W=4e-06 L=4e-06
ngc4_e6_ki1p gc4_e6_qb gc4_e6_ko1 vdd vsrc pch W=2.4e-06 L=5e-07
ngc4_e6_ki1n gc4_e6_qb gc4_e6_ko1 0 0 nch W=1.2e-06 L=5e-07
ngc4_e6_ki2p gc4_e6_q gc4_e6_qb vdd vsrc pch W=2.4e-06 L=5e-07
ngc4_e6_ki2n gc4_e6_q gc4_e6_qb 0 0 nch W=1.2e-06 L=5e-07
rgc4_e6_hra gc4_e6_h vthe 1e+06
rgc4_e6_hrf gc4_e6_h gc4_e6_qb 1.9e+07
cgc4_e6_hc gc4_e6_h 0 2.1e-09
ngc4_e6_dis gc4_e6_vm gc4_e6_q gc4_e6_vmd 0 nch W=4e-06 L=1e-06
rgc4_e6_rdis gc4_e6_vmd vrest 220000
ngc4_e6_rp gc4_e6_rt gc4_e6_qb vdd vsrc pch W=2e-06 L=1e-06
rgc4_e6_rrc gc4_e6_rt gc4_e6_rec 10000
cgc4_e6_rc gc4_e6_rec 0 1e-07
rgc4_e6_rr gc4_e6_rec 0 8.2e+06
ngc4_e6_sh1 gc4_e6_vm gc4_e6_rec gc4_e6_vms 0 nch W=2e-06 L=1e-06
ngc4_e6_sh2 gc4_e6_vms gc4_e6_qb vrest 0 nch W=2e-06 L=1e-06
ngc4_e6_porh gc4_e6_h por_hold vthe 0 nch W=2e-06 L=1e-06
ngc4_e6_porm gc4_e6_vm por_hold vrest 0 nch W=2e-06 L=1e-06
ngc4_e6_ip gc4_e6_vm s4_yb vdd vsrc pch W=4e-06 L=4e-06
ngc4_e6_in gc4_e6_vm s4_za 0 0 nch W=4e-06 L=4e-06
ngc4_b6_sw gc4_b6_t gc4_e6_qb vdd vsrc pch W=2e-06 L=1e-06
rgc4_b6_rc gc4_b6_t gc4_b6 10000
cgc4_b6_c gc4_b6 0 1e-07
rgc4_b6_rl gc4_b6 0 2.2e+07
ngc4_b6_sh1p gc4_b6_n gc4_b6 vdd vsrc pch W=2.4e-06 L=5e-07
ngc4_b6_sh1n gc4_b6_n gc4_b6 0 0 nch W=1.2e-06 L=5e-07
ngc4_b6_sh2p gc4_b6_q gc4_b6_n vdd vsrc pch W=2.4e-06 L=5e-07
ngc4_b6_sh2n gc4_b6_q gc4_b6_n 0 0 nch W=1.2e-06 L=5e-07
cgc4_e7_cm gc4_e7_vm 0 1e-07
rgc4_e7_rm gc4_e7_vm vrest 1e+06
ngc4_e7_bias0 gc4_e7_vm istep_n 0 0 nch W=4e-06 L=4e-06
ngc4_e7_bias1 gc4_e7_vm istep_n 0 0 nch W=4e-06 L=4e-06
ngc4_e7_bias2 gc4_e7_vm istep_n 0 0 nch W=4e-06 L=4e-06
ngc4_e7_bias3 gc4_e7_vm istep_n 0 0 nch W=4e-06 L=4e-06
ngc4_e7_bias4 gc4_e7_vm istep_n 0 0 nch W=4e-06 L=4e-06
ngc4_e7_bias5 gc4_e7_vm istep_n 0 0 nch W=4e-06 L=4e-06
ngc4_e7_bias6 gc4_e7_vm istep_n 0 0 nch W=4e-06 L=4e-06
rgc4_e7_kb vdd gc4_e7_knb 1e+06
ngc4_e7_kmb gc4_e7_knb gc4_e7_knb 0 0 nch W=4e-06 L=4e-06
ngc4_e7_kmt gc4_e7_ktail gc4_e7_knb 0 0 nch W=4e-06 L=4e-06
ngc4_e7_km1 gc4_e7_kd1 gc4_e7_vm gc4_e7_ktail 0 nch W=4e-06 L=4e-06
ngc4_e7_km2 gc4_e7_ko1 gc4_e7_h gc4_e7_ktail 0 nch W=4e-06 L=4e-06
ngc4_e7_km3 gc4_e7_kd1 gc4_e7_kd1 vdd vsrc pch W=4e-06 L=4e-06
ngc4_e7_km4 gc4_e7_ko1 gc4_e7_kd1 vdd vsrc pch W=4e-06 L=4e-06
ngc4_e7_ki1p gc4_e7_qb gc4_e7_ko1 vdd vsrc pch W=2.4e-06 L=5e-07
ngc4_e7_ki1n gc4_e7_qb gc4_e7_ko1 0 0 nch W=1.2e-06 L=5e-07
ngc4_e7_ki2p gc4_e7_q gc4_e7_qb vdd vsrc pch W=2.4e-06 L=5e-07
ngc4_e7_ki2n gc4_e7_q gc4_e7_qb 0 0 nch W=1.2e-06 L=5e-07
rgc4_e7_hra gc4_e7_h vthe 1e+06
rgc4_e7_hrf gc4_e7_h gc4_e7_qb 1.9e+07
cgc4_e7_hc gc4_e7_h 0 2.1e-09
ngc4_e7_dis gc4_e7_vm gc4_e7_q gc4_e7_vmd 0 nch W=4e-06 L=1e-06
rgc4_e7_rdis gc4_e7_vmd vrest 220000
ngc4_e7_rp gc4_e7_rt gc4_e7_qb vdd vsrc pch W=2e-06 L=1e-06
rgc4_e7_rrc gc4_e7_rt gc4_e7_rec 10000
cgc4_e7_rc gc4_e7_rec 0 1e-07
rgc4_e7_rr gc4_e7_rec 0 8.2e+06
ngc4_e7_sh1 gc4_e7_vm gc4_e7_rec gc4_e7_vms 0 nch W=2e-06 L=1e-06
ngc4_e7_sh2 gc4_e7_vms gc4_e7_qb vrest 0 nch W=2e-06 L=1e-06
ngc4_e7_porh gc4_e7_h por_hold vthe 0 nch W=2e-06 L=1e-06
ngc4_e7_porm gc4_e7_vm por_hold vrest 0 nch W=2e-06 L=1e-06
ngc4_e7_ip gc4_e7_vm s4_yb vdd vsrc pch W=4e-06 L=4e-06
ngc4_e7_in gc4_e7_vm s4_za 0 0 nch W=4e-06 L=4e-06
ngc4_b7_sw gc4_b7_t gc4_e7_qb vdd vsrc pch W=2e-06 L=1e-06
rgc4_b7_rc gc4_b7_t gc4_b7 10000
cgc4_b7_c gc4_b7 0 1e-07
rgc4_b7_rl gc4_b7 0 2.2e+07
ngc4_b7_sh1p gc4_b7_n gc4_b7 vdd vsrc pch W=2.4e-06 L=5e-07
ngc4_b7_sh1n gc4_b7_n gc4_b7 0 0 nch W=1.2e-06 L=5e-07
ngc4_b7_sh2p gc4_b7_q gc4_b7_n vdd vsrc pch W=2.4e-06 L=5e-07
ngc4_b7_sh2n gc4_b7_q gc4_b7_n 0 0 nch W=1.2e-06 L=5e-07
cgc4_e8_cm gc4_e8_vm 0 1e-07
rgc4_e8_rm gc4_e8_vm vrest 1e+06
ngc4_e8_bias0 gc4_e8_vm istep_n 0 0 nch W=4e-06 L=4e-06
ngc4_e8_bias1 gc4_e8_vm istep_n 0 0 nch W=4e-06 L=4e-06
ngc4_e8_bias2 gc4_e8_vm istep_n 0 0 nch W=4e-06 L=4e-06
ngc4_e8_bias3 gc4_e8_vm istep_n 0 0 nch W=4e-06 L=4e-06
ngc4_e8_bias4 gc4_e8_vm istep_n 0 0 nch W=4e-06 L=4e-06
ngc4_e8_bias5 gc4_e8_vm istep_n 0 0 nch W=4e-06 L=4e-06
ngc4_e8_bias6 gc4_e8_vm istep_n 0 0 nch W=4e-06 L=4e-06
ngc4_e8_bias7 gc4_e8_vm istep_n 0 0 nch W=4e-06 L=4e-06
rgc4_e8_kb vdd gc4_e8_knb 1e+06
ngc4_e8_kmb gc4_e8_knb gc4_e8_knb 0 0 nch W=4e-06 L=4e-06
ngc4_e8_kmt gc4_e8_ktail gc4_e8_knb 0 0 nch W=4e-06 L=4e-06
ngc4_e8_km1 gc4_e8_kd1 gc4_e8_vm gc4_e8_ktail 0 nch W=4e-06 L=4e-06
ngc4_e8_km2 gc4_e8_ko1 gc4_e8_h gc4_e8_ktail 0 nch W=4e-06 L=4e-06
ngc4_e8_km3 gc4_e8_kd1 gc4_e8_kd1 vdd vsrc pch W=4e-06 L=4e-06
ngc4_e8_km4 gc4_e8_ko1 gc4_e8_kd1 vdd vsrc pch W=4e-06 L=4e-06
ngc4_e8_ki1p gc4_e8_qb gc4_e8_ko1 vdd vsrc pch W=2.4e-06 L=5e-07
ngc4_e8_ki1n gc4_e8_qb gc4_e8_ko1 0 0 nch W=1.2e-06 L=5e-07
ngc4_e8_ki2p gc4_e8_q gc4_e8_qb vdd vsrc pch W=2.4e-06 L=5e-07
ngc4_e8_ki2n gc4_e8_q gc4_e8_qb 0 0 nch W=1.2e-06 L=5e-07
rgc4_e8_hra gc4_e8_h vthe 1e+06
rgc4_e8_hrf gc4_e8_h gc4_e8_qb 1.9e+07
cgc4_e8_hc gc4_e8_h 0 2.1e-09
ngc4_e8_dis gc4_e8_vm gc4_e8_q gc4_e8_vmd 0 nch W=4e-06 L=1e-06
rgc4_e8_rdis gc4_e8_vmd vrest 220000
ngc4_e8_rp gc4_e8_rt gc4_e8_qb vdd vsrc pch W=2e-06 L=1e-06
rgc4_e8_rrc gc4_e8_rt gc4_e8_rec 10000
cgc4_e8_rc gc4_e8_rec 0 1e-07
rgc4_e8_rr gc4_e8_rec 0 8.2e+06
ngc4_e8_sh1 gc4_e8_vm gc4_e8_rec gc4_e8_vms 0 nch W=2e-06 L=1e-06
ngc4_e8_sh2 gc4_e8_vms gc4_e8_qb vrest 0 nch W=2e-06 L=1e-06
ngc4_e8_porh gc4_e8_h por_hold vthe 0 nch W=2e-06 L=1e-06
ngc4_e8_porm gc4_e8_vm por_hold vrest 0 nch W=2e-06 L=1e-06
ngc4_e8_ip gc4_e8_vm s4_yb vdd vsrc pch W=4e-06 L=4e-06
ngc4_e8_in gc4_e8_vm s4_za 0 0 nch W=4e-06 L=4e-06
ngc4_b8_sw gc4_b8_t gc4_e8_qb vdd vsrc pch W=2e-06 L=1e-06
rgc4_b8_rc gc4_b8_t gc4_b8 10000
cgc4_b8_c gc4_b8 0 1e-07
rgc4_b8_rl gc4_b8 0 2.2e+07
ngc4_b8_sh1p gc4_b8_n gc4_b8 vdd vsrc pch W=2.4e-06 L=5e-07
ngc4_b8_sh1n gc4_b8_n gc4_b8 0 0 nch W=1.2e-06 L=5e-07
ngc4_b8_sh2p gc4_b8_q gc4_b8_n vdd vsrc pch W=2.4e-06 L=5e-07
ngc4_b8_sh2n gc4_b8_q gc4_b8_n 0 0 nch W=1.2e-06 L=5e-07
cgc4_e9_cm gc4_e9_vm 0 1e-07
rgc4_e9_rm gc4_e9_vm vrest 1e+06
ngc4_e9_bias0 gc4_e9_vm istep_n 0 0 nch W=4e-06 L=4e-06
ngc4_e9_bias1 gc4_e9_vm istep_n 0 0 nch W=4e-06 L=4e-06
ngc4_e9_bias2 gc4_e9_vm istep_n 0 0 nch W=4e-06 L=4e-06
ngc4_e9_bias3 gc4_e9_vm istep_n 0 0 nch W=4e-06 L=4e-06
ngc4_e9_bias4 gc4_e9_vm istep_n 0 0 nch W=4e-06 L=4e-06
ngc4_e9_bias5 gc4_e9_vm istep_n 0 0 nch W=4e-06 L=4e-06
ngc4_e9_bias6 gc4_e9_vm istep_n 0 0 nch W=4e-06 L=4e-06
ngc4_e9_bias7 gc4_e9_vm istep_n 0 0 nch W=4e-06 L=4e-06
ngc4_e9_bias8 gc4_e9_vm istep_n 0 0 nch W=4e-06 L=4e-06
rgc4_e9_kb vdd gc4_e9_knb 1e+06
ngc4_e9_kmb gc4_e9_knb gc4_e9_knb 0 0 nch W=4e-06 L=4e-06
ngc4_e9_kmt gc4_e9_ktail gc4_e9_knb 0 0 nch W=4e-06 L=4e-06
ngc4_e9_km1 gc4_e9_kd1 gc4_e9_vm gc4_e9_ktail 0 nch W=4e-06 L=4e-06
ngc4_e9_km2 gc4_e9_ko1 gc4_e9_h gc4_e9_ktail 0 nch W=4e-06 L=4e-06
ngc4_e9_km3 gc4_e9_kd1 gc4_e9_kd1 vdd vsrc pch W=4e-06 L=4e-06
ngc4_e9_km4 gc4_e9_ko1 gc4_e9_kd1 vdd vsrc pch W=4e-06 L=4e-06
ngc4_e9_ki1p gc4_e9_qb gc4_e9_ko1 vdd vsrc pch W=2.4e-06 L=5e-07
ngc4_e9_ki1n gc4_e9_qb gc4_e9_ko1 0 0 nch W=1.2e-06 L=5e-07
ngc4_e9_ki2p gc4_e9_q gc4_e9_qb vdd vsrc pch W=2.4e-06 L=5e-07
ngc4_e9_ki2n gc4_e9_q gc4_e9_qb 0 0 nch W=1.2e-06 L=5e-07
rgc4_e9_hra gc4_e9_h vthe 1e+06
rgc4_e9_hrf gc4_e9_h gc4_e9_qb 1.9e+07
cgc4_e9_hc gc4_e9_h 0 2.1e-09
ngc4_e9_dis gc4_e9_vm gc4_e9_q gc4_e9_vmd 0 nch W=4e-06 L=1e-06
rgc4_e9_rdis gc4_e9_vmd vrest 220000
ngc4_e9_rp gc4_e9_rt gc4_e9_qb vdd vsrc pch W=2e-06 L=1e-06
rgc4_e9_rrc gc4_e9_rt gc4_e9_rec 10000
cgc4_e9_rc gc4_e9_rec 0 1e-07
rgc4_e9_rr gc4_e9_rec 0 8.2e+06
ngc4_e9_sh1 gc4_e9_vm gc4_e9_rec gc4_e9_vms 0 nch W=2e-06 L=1e-06
ngc4_e9_sh2 gc4_e9_vms gc4_e9_qb vrest 0 nch W=2e-06 L=1e-06
ngc4_e9_porh gc4_e9_h por_hold vthe 0 nch W=2e-06 L=1e-06
ngc4_e9_porm gc4_e9_vm por_hold vrest 0 nch W=2e-06 L=1e-06
ngc4_e9_ip gc4_e9_vm s4_yb vdd vsrc pch W=4e-06 L=4e-06
ngc4_e9_in gc4_e9_vm s4_za 0 0 nch W=4e-06 L=4e-06
ngc4_b9_sw gc4_b9_t gc4_e9_qb vdd vsrc pch W=2e-06 L=1e-06
rgc4_b9_rc gc4_b9_t gc4_b9 10000
cgc4_b9_c gc4_b9 0 1e-07
rgc4_b9_rl gc4_b9 0 2.2e+07
ngc4_b9_sh1p gc4_b9_n gc4_b9 vdd vsrc pch W=2.4e-06 L=5e-07
ngc4_b9_sh1n gc4_b9_n gc4_b9 0 0 nch W=1.2e-06 L=5e-07
ngc4_b9_sh2p gc4_b9_q gc4_b9_n vdd vsrc pch W=2.4e-06 L=5e-07
ngc4_b9_sh2n gc4_b9_q gc4_b9_n 0 0 nch W=1.2e-06 L=5e-07
cgc4_e10_cm gc4_e10_vm 0 1e-07
rgc4_e10_rm gc4_e10_vm vrest 1e+06
ngc4_e10_bias0 gc4_e10_vm istep_n 0 0 nch W=4e-06 L=4e-06
ngc4_e10_bias1 gc4_e10_vm istep_n 0 0 nch W=4e-06 L=4e-06
ngc4_e10_bias2 gc4_e10_vm istep_n 0 0 nch W=4e-06 L=4e-06
ngc4_e10_bias3 gc4_e10_vm istep_n 0 0 nch W=4e-06 L=4e-06
ngc4_e10_bias4 gc4_e10_vm istep_n 0 0 nch W=4e-06 L=4e-06
ngc4_e10_bias5 gc4_e10_vm istep_n 0 0 nch W=4e-06 L=4e-06
ngc4_e10_bias6 gc4_e10_vm istep_n 0 0 nch W=4e-06 L=4e-06
ngc4_e10_bias7 gc4_e10_vm istep_n 0 0 nch W=4e-06 L=4e-06
ngc4_e10_bias8 gc4_e10_vm istep_n 0 0 nch W=4e-06 L=4e-06
ngc4_e10_bias9 gc4_e10_vm istep_n 0 0 nch W=4e-06 L=4e-06
rgc4_e10_kb vdd gc4_e10_knb 1e+06
ngc4_e10_kmb gc4_e10_knb gc4_e10_knb 0 0 nch W=4e-06 L=4e-06
ngc4_e10_kmt gc4_e10_ktail gc4_e10_knb 0 0 nch W=4e-06 L=4e-06
ngc4_e10_km1 gc4_e10_kd1 gc4_e10_vm gc4_e10_ktail 0 nch W=4e-06 L=4e-06
ngc4_e10_km2 gc4_e10_ko1 gc4_e10_h gc4_e10_ktail 0 nch W=4e-06 L=4e-06
ngc4_e10_km3 gc4_e10_kd1 gc4_e10_kd1 vdd vsrc pch W=4e-06 L=4e-06
ngc4_e10_km4 gc4_e10_ko1 gc4_e10_kd1 vdd vsrc pch W=4e-06 L=4e-06
ngc4_e10_ki1p gc4_e10_qb gc4_e10_ko1 vdd vsrc pch W=2.4e-06 L=5e-07
ngc4_e10_ki1n gc4_e10_qb gc4_e10_ko1 0 0 nch W=1.2e-06 L=5e-07
ngc4_e10_ki2p gc4_e10_q gc4_e10_qb vdd vsrc pch W=2.4e-06 L=5e-07
ngc4_e10_ki2n gc4_e10_q gc4_e10_qb 0 0 nch W=1.2e-06 L=5e-07
rgc4_e10_hra gc4_e10_h vthe 1e+06
rgc4_e10_hrf gc4_e10_h gc4_e10_qb 1.9e+07
cgc4_e10_hc gc4_e10_h 0 2.1e-09
ngc4_e10_dis gc4_e10_vm gc4_e10_q gc4_e10_vmd 0 nch W=4e-06 L=1e-06
rgc4_e10_rdis gc4_e10_vmd vrest 220000
ngc4_e10_rp gc4_e10_rt gc4_e10_qb vdd vsrc pch W=2e-06 L=1e-06
rgc4_e10_rrc gc4_e10_rt gc4_e10_rec 10000
cgc4_e10_rc gc4_e10_rec 0 1e-07
rgc4_e10_rr gc4_e10_rec 0 8.2e+06
ngc4_e10_sh1 gc4_e10_vm gc4_e10_rec gc4_e10_vms 0 nch W=2e-06 L=1e-06
ngc4_e10_sh2 gc4_e10_vms gc4_e10_qb vrest 0 nch W=2e-06 L=1e-06
ngc4_e10_porh gc4_e10_h por_hold vthe 0 nch W=2e-06 L=1e-06
ngc4_e10_porm gc4_e10_vm por_hold vrest 0 nch W=2e-06 L=1e-06
ngc4_e10_ip gc4_e10_vm s4_yb vdd vsrc pch W=4e-06 L=4e-06
ngc4_e10_in gc4_e10_vm s4_za 0 0 nch W=4e-06 L=4e-06
ngc4_b10_sw gc4_b10_t gc4_e10_qb vdd vsrc pch W=2e-06 L=1e-06
rgc4_b10_rc gc4_b10_t gc4_b10 10000
cgc4_b10_c gc4_b10 0 1e-07
rgc4_b10_rl gc4_b10 0 2.2e+07
ngc4_b10_sh1p gc4_b10_n gc4_b10 vdd vsrc pch W=2.4e-06 L=5e-07
ngc4_b10_sh1n gc4_b10_n gc4_b10 0 0 nch W=1.2e-06 L=5e-07
ngc4_b10_sh2p gc4_b10_q gc4_b10_n vdd vsrc pch W=2.4e-06 L=5e-07
ngc4_b10_sh2n gc4_b10_q gc4_b10_n 0 0 nch W=1.2e-06 L=5e-07
ngc4_and_a0_npa gc4_and_a0_nb gc4_b1_q vdd vsrc pch W=2.4e-06 L=5e-07
ngc4_and_a0_npb gc4_and_a0_nb gc4_b2_q vdd vsrc pch W=2.4e-06 L=5e-07
ngc4_and_a0_nna gc4_and_a0_nb gc4_b1_q gc4_and_a0_nx 0 nch W=2.4e-06 L=5e-07
ngc4_and_a0_nnb gc4_and_a0_nx gc4_b2_q 0 0 nch W=2.4e-06 L=5e-07
ngc4_and_a0_ip gc4_and_g0 gc4_and_a0_nb vdd vsrc pch W=2.4e-06 L=5e-07
ngc4_and_a0_in gc4_and_g0 gc4_and_a0_nb 0 0 nch W=1.2e-06 L=5e-07
ngc4_and_a1_npa gc4_and_a1_nb gc4_b3_q vdd vsrc pch W=2.4e-06 L=5e-07
ngc4_and_a1_npb gc4_and_a1_nb gc4_b4_q vdd vsrc pch W=2.4e-06 L=5e-07
ngc4_and_a1_nna gc4_and_a1_nb gc4_b3_q gc4_and_a1_nx 0 nch W=2.4e-06 L=5e-07
ngc4_and_a1_nnb gc4_and_a1_nx gc4_b4_q 0 0 nch W=2.4e-06 L=5e-07
ngc4_and_a1_ip gc4_and_g1 gc4_and_a1_nb vdd vsrc pch W=2.4e-06 L=5e-07
ngc4_and_a1_in gc4_and_g1 gc4_and_a1_nb 0 0 nch W=1.2e-06 L=5e-07
ngc4_and_a2_npa gc4_and_a2_nb gc4_b5_q vdd vsrc pch W=2.4e-06 L=5e-07
ngc4_and_a2_npb gc4_and_a2_nb gc4_b6_q vdd vsrc pch W=2.4e-06 L=5e-07
ngc4_and_a2_nna gc4_and_a2_nb gc4_b5_q gc4_and_a2_nx 0 nch W=2.4e-06 L=5e-07
ngc4_and_a2_nnb gc4_and_a2_nx gc4_b6_q 0 0 nch W=2.4e-06 L=5e-07
ngc4_and_a2_ip gc4_and_g2 gc4_and_a2_nb vdd vsrc pch W=2.4e-06 L=5e-07
ngc4_and_a2_in gc4_and_g2 gc4_and_a2_nb 0 0 nch W=1.2e-06 L=5e-07
ngc4_and_a3_npa gc4_and_a3_nb gc4_b7_q vdd vsrc pch W=2.4e-06 L=5e-07
ngc4_and_a3_npb gc4_and_a3_nb gc4_b8_q vdd vsrc pch W=2.4e-06 L=5e-07
ngc4_and_a3_nna gc4_and_a3_nb gc4_b7_q gc4_and_a3_nx 0 nch W=2.4e-06 L=5e-07
ngc4_and_a3_nnb gc4_and_a3_nx gc4_b8_q 0 0 nch W=2.4e-06 L=5e-07
ngc4_and_a3_ip gc4_and_g3 gc4_and_a3_nb vdd vsrc pch W=2.4e-06 L=5e-07
ngc4_and_a3_in gc4_and_g3 gc4_and_a3_nb 0 0 nch W=1.2e-06 L=5e-07
ngc4_and_a4_npa gc4_and_a4_nb gc4_b9_q vdd vsrc pch W=2.4e-06 L=5e-07
ngc4_and_a4_npb gc4_and_a4_nb gc4_b10_q vdd vsrc pch W=2.4e-06 L=5e-07
ngc4_and_a4_nna gc4_and_a4_nb gc4_b9_q gc4_and_a4_nx 0 nch W=2.4e-06 L=5e-07
ngc4_and_a4_nnb gc4_and_a4_nx gc4_b10_q 0 0 nch W=2.4e-06 L=5e-07
ngc4_and_a4_ip gc4_and_g4 gc4_and_a4_nb vdd vsrc pch W=2.4e-06 L=5e-07
ngc4_and_a4_in gc4_and_g4 gc4_and_a4_nb 0 0 nch W=1.2e-06 L=5e-07
ngc4_and_a5_npa gc4_and_a5_nb gc4_and_g0 vdd vsrc pch W=2.4e-06 L=5e-07
ngc4_and_a5_npb gc4_and_a5_nb gc4_and_g1 vdd vsrc pch W=2.4e-06 L=5e-07
ngc4_and_a5_nna gc4_and_a5_nb gc4_and_g0 gc4_and_a5_nx 0 nch W=2.4e-06 L=5e-07
ngc4_and_a5_nnb gc4_and_a5_nx gc4_and_g1 0 0 nch W=2.4e-06 L=5e-07
ngc4_and_a5_ip gc4_and_g5 gc4_and_a5_nb vdd vsrc pch W=2.4e-06 L=5e-07
ngc4_and_a5_in gc4_and_g5 gc4_and_a5_nb 0 0 nch W=1.2e-06 L=5e-07
ngc4_and_a6_npa gc4_and_a6_nb gc4_and_g2 vdd vsrc pch W=2.4e-06 L=5e-07
ngc4_and_a6_npb gc4_and_a6_nb gc4_and_g3 vdd vsrc pch W=2.4e-06 L=5e-07
ngc4_and_a6_nna gc4_and_a6_nb gc4_and_g2 gc4_and_a6_nx 0 nch W=2.4e-06 L=5e-07
ngc4_and_a6_nnb gc4_and_a6_nx gc4_and_g3 0 0 nch W=2.4e-06 L=5e-07
ngc4_and_a6_ip gc4_and_g6 gc4_and_a6_nb vdd vsrc pch W=2.4e-06 L=5e-07
ngc4_and_a6_in gc4_and_g6 gc4_and_a6_nb 0 0 nch W=1.2e-06 L=5e-07
ngc4_and_a7_npa gc4_and_a7_nb gc4_and_g5 vdd vsrc pch W=2.4e-06 L=5e-07
ngc4_and_a7_npb gc4_and_a7_nb gc4_and_g6 vdd vsrc pch W=2.4e-06 L=5e-07
ngc4_and_a7_nna gc4_and_a7_nb gc4_and_g5 gc4_and_a7_nx 0 nch W=2.4e-06 L=5e-07
ngc4_and_a7_nnb gc4_and_a7_nx gc4_and_g6 0 0 nch W=2.4e-06 L=5e-07
ngc4_and_a7_ip gc4_and_g7 gc4_and_a7_nb vdd vsrc pch W=2.4e-06 L=5e-07
ngc4_and_a7_in gc4_and_g7 gc4_and_a7_nb 0 0 nch W=1.2e-06 L=5e-07
ngc4_and_a8_npa gc4_and_a8_nb gc4_and_g7 vdd vsrc pch W=2.4e-06 L=5e-07
ngc4_and_a8_npb gc4_and_a8_nb gc4_and_g4 vdd vsrc pch W=2.4e-06 L=5e-07
ngc4_and_a8_nna gc4_and_a8_nb gc4_and_g7 gc4_and_a8_nx 0 nch W=2.4e-06 L=5e-07
ngc4_and_a8_nnb gc4_and_a8_nx gc4_and_g4 0 0 nch W=2.4e-06 L=5e-07
ngc4_and_a8_ip gc4_and_g8 gc4_and_a8_nb vdd vsrc pch W=2.4e-06 L=5e-07
ngc4_and_a8_in gc4_and_g8 gc4_and_a8_nb 0 0 nch W=1.2e-06 L=5e-07
ngc4_gip gc4_gb gc4_and_g8 vdd vsrc pch W=2.4e-06 L=5e-07
ngc4_gin gc4_gb gc4_and_g8 0 0 nch W=1.2e-06 L=5e-07
cgc4_col_cm gc4_col_vm 0 1e-07
rgc4_col_rm gc4_col_vm vrest 1e+06
rgc4_col_kb vdd gc4_col_knb 1e+06
ngc4_col_kmb gc4_col_knb gc4_col_knb 0 0 nch W=4e-06 L=4e-06
ngc4_col_kmt gc4_col_ktail gc4_col_knb 0 0 nch W=4e-06 L=4e-06
ngc4_col_km1 gc4_col_kd1 gc4_col_vm gc4_col_ktail 0 nch W=4e-06 L=4e-06
ngc4_col_km2 gc4_col_ko1 gc4_col_h gc4_col_ktail 0 nch W=4e-06 L=4e-06
ngc4_col_km3 gc4_col_kd1 gc4_col_kd1 vdd vsrc pch W=4e-06 L=4e-06
ngc4_col_km4 gc4_col_ko1 gc4_col_kd1 vdd vsrc pch W=4e-06 L=4e-06
ngc4_col_ki1p gc4_col_qb gc4_col_ko1 vdd vsrc pch W=2.4e-06 L=5e-07
ngc4_col_ki1n gc4_col_qb gc4_col_ko1 0 0 nch W=1.2e-06 L=5e-07
ngc4_col_ki2p gc4_col_q gc4_col_qb vdd vsrc pch W=2.4e-06 L=5e-07
ngc4_col_ki2n gc4_col_q gc4_col_qb 0 0 nch W=1.2e-06 L=5e-07
rgc4_col_hra gc4_col_h vthe 1e+06
rgc4_col_hrf gc4_col_h gc4_col_qb 1.9e+07
cgc4_col_hc gc4_col_h 0 2.1e-09
ngc4_col_dis gc4_col_vm gc4_col_q gc4_col_vmd 0 nch W=4e-06 L=1e-06
rgc4_col_rdis gc4_col_vmd vrest 220000
ngc4_col_rp gc4_col_rt gc4_col_qb vdd vsrc pch W=2e-06 L=1e-06
rgc4_col_rrc gc4_col_rt gc4_col_rec 10000
cgc4_col_rc gc4_col_rec 0 1e-07
rgc4_col_rr gc4_col_rec 0 8.2e+06
ngc4_col_sh1 gc4_col_vm gc4_col_rec gc4_col_vms 0 nch W=2e-06 L=1e-06
ngc4_col_sh2 gc4_col_vms gc4_col_qb vrest 0 nch W=2e-06 L=1e-06
ngc4_col_porh gc4_col_h por_hold vthe 0 nch W=2e-06 L=1e-06
ngc4_col_porm gc4_col_vm por_hold vrest 0 nch W=2e-06 L=1e-06
ngc4_cin_sw gc4_cin_x gc4_gb vdd vsrc pch W=4e-06 L=1e-06
ngc4_cin_cp gc4_col_vm ilimp_n gc4_cin_x vsrc pch W=4e-06 L=4e-06
ngc4_op_tsw gc4_op_tt gc4_col_qb vdd vsrc pch W=2e-06 L=1e-06
rgc4_op_trc gc4_op_tt gc4_op_at 10000
cgc4_op_tc gc4_op_at 0 1e-07
rgc4_op_trl gc4_op_at 0 2.2e+07
ngc4_op_sh1p gc4_op_an gc4_op_at vdd vsrc pch W=2.4e-06 L=5e-07
ngc4_op_sh1n gc4_op_an gc4_op_at 0 0 nch W=1.2e-06 L=5e-07
ngc4_op_sh2p gc4_op_aq gc4_op_an vdd vsrc pch W=2.4e-06 L=5e-07
ngc4_op_sh2n gc4_op_aq gc4_op_an 0 0 nch W=1.2e-06 L=5e-07
ngc4_op_abp gc4_op_aqb gc4_op_aq vdd vsrc pch W=2.4e-06 L=5e-07
ngc4_op_abn gc4_op_aqb gc4_op_aq 0 0 nch W=1.2e-06 L=5e-07
rgc4_op_dr gc4_op_aq gc4_op_ad 1e+06
cgc4_op_dc gc4_op_ad 0 3.3e-07
ngc4_op_d2p gc4_op_adn gc4_op_ad vdd vsrc pch W=2.4e-06 L=5e-07
ngc4_op_d2n gc4_op_adn gc4_op_ad 0 0 nch W=1.2e-06 L=5e-07
ngc4_op_gpa gc4_op_pb gc4_op_aq vdd vsrc pch W=2.4e-06 L=5e-07
ngc4_op_gpb gc4_op_pb gc4_op_adn vdd vsrc pch W=2.4e-06 L=5e-07
ngc4_op_gna gc4_op_pb gc4_op_aq gc4_op_gx 0 nch W=2.4e-06 L=5e-07
ngc4_op_gnb gc4_op_gx gc4_op_adn 0 0 nch W=2.4e-06 L=5e-07
ngc4_op_op gc4_op_p gc4_op_pb vdd vsrc pch W=2.4e-06 L=5e-07
ngc4_op_on gc4_op_p gc4_op_pb 0 0 nch W=1.2e-06 L=5e-07
nhsc3_sw hsc3_sd gc3_col_qb vdd vsrc pch W=4e-06 L=5e-07
rhsc3_rr hsc3_sd hsc3_h1 100000
chsc3_c1 hsc3_h1 0 1e-06
rhsc3_r2 hsc3_h1 hc3 1e+06
chsc3_c2 hc3 0 4.7e-07
rhsc3_rl hc3 0 4.7e+06
nhsc4_sw hsc4_sd gc4_col_qb vdd vsrc pch W=4e-06 L=5e-07
rhsc4_rr hsc4_sd hsc4_h1 100000
chsc4_c1 hsc4_h1 0 1e-06
rhsc4_r2 hsc4_h1 hc4 1e+06
chsc4_c2 hc4 0 4.7e-07
rhsc4_rl hc4 0 4.7e+06
nthc34f_st_mh thc34f_mi hc3 thc34f_st_x 0 nch W=2e-06 L=4e-06
nthc34f_st_mp thc34f_st_x gc4_op_aq 0 0 nch W=4e-06 L=1e-06
va_cthc34f_cm_p thc34f_vm cthc34f_cm_p 0
cthc34f_cm cthc34f_cm_p 0 1.5e-06
va_rthc34f_rm_p thc34f_vm rthc34f_rm_p 0
rthc34f_rm rthc34f_rm_p vrest 1e+06
rthc34f_kb vdd thc34f_knb 1e+06
nthc34f_kmb thc34f_knb thc34f_knb 0 0 nch W=4e-06 L=4e-06
nthc34f_kmt thc34f_ktail thc34f_knb 0 0 nch W=4e-06 L=4e-06
va_nthc34f_km1_g thc34f_vm nthc34f_km1_g 0
nthc34f_km1 thc34f_kd1 nthc34f_km1_g thc34f_ktail 0 nch W=4e-06 L=4e-06
nthc34f_km2 thc34f_ko1 thc34f_h thc34f_ktail 0 nch W=4e-06 L=4e-06
nthc34f_km3 thc34f_kd1 thc34f_kd1 vdd vsrc pch W=4e-06 L=4e-06
nthc34f_km4 thc34f_ko1 thc34f_kd1 vdd vsrc pch W=4e-06 L=4e-06
nthc34f_ki1p thc34f_qb thc34f_ko1 vdd vsrc pch W=2.4e-06 L=5e-07
nthc34f_ki1n thc34f_qb thc34f_ko1 0 0 nch W=1.2e-06 L=5e-07
nthc34f_ki2p thc34f_q thc34f_qb vdd vsrc pch W=2.4e-06 L=5e-07
nthc34f_ki2n thc34f_q thc34f_qb 0 0 nch W=1.2e-06 L=5e-07
rthc34f_hra thc34f_h vthr 1e+06
rthc34f_hrf thc34f_h thc34f_qb 1.9e+07
cthc34f_hc thc34f_h 0 2.1e-09
va_nthc34f_dis_d thc34f_vm nthc34f_dis_d 0
va_nthc34f_dis_s thc34f_vmd nthc34f_dis_s 0
nthc34f_dis nthc34f_dis_d thc34f_q nthc34f_dis_s 0 nch W=4e-06 L=1e-06
va_rthc34f_rdis_p thc34f_vmd rthc34f_rdis_p 0
rthc34f_rdis rthc34f_rdis_p vrest 12000
nthc34f_rp thc34f_rt thc34f_qb vdd vsrc pch W=2e-06 L=1e-06
rthc34f_rrc thc34f_rt thc34f_rec 10000
cthc34f_rc thc34f_rec 0 1e-07
rthc34f_rr thc34f_rec 0 8.2e+06
va_nthc34f_sh1_d thc34f_vm nthc34f_sh1_d 0
va_nthc34f_sh1_s thc34f_vms nthc34f_sh1_s 0
nthc34f_sh1 nthc34f_sh1_d thc34f_rec nthc34f_sh1_s 0 nch W=2e-06 L=1e-06
va_nthc34f_sh2_d thc34f_vms nthc34f_sh2_d 0
nthc34f_sh2 nthc34f_sh2_d thc34f_qb vrest 0 nch W=2e-06 L=1e-06
nthc34f_porh thc34f_h por_hold vthr 0 nch W=2e-06 L=1e-06
va_nthc34f_porm_d thc34f_vm nthc34f_porm_d 0
nthc34f_porm nthc34f_porm_d por_hold vrest 0 nch W=2e-06 L=1e-06
nthc34f_op_tsw thc34f_op_tt thc34f_qb vdd vsrc pch W=2e-06 L=1e-06
rthc34f_op_trc thc34f_op_tt thc34f_op_at 10000
cthc34f_op_tc thc34f_op_at 0 1e-07
rthc34f_op_trl thc34f_op_at 0 2.2e+07
nthc34f_op_sh1p thc34f_op_an thc34f_op_at vdd vsrc pch W=2.4e-06 L=5e-07
nthc34f_op_sh1n thc34f_op_an thc34f_op_at 0 0 nch W=1.2e-06 L=5e-07
nthc34f_op_sh2p thc34f_op_aq thc34f_op_an vdd vsrc pch W=2.4e-06 L=5e-07
nthc34f_op_sh2n thc34f_op_aq thc34f_op_an 0 0 nch W=1.2e-06 L=5e-07
nthc34f_op_abp thc34f_op_aqb thc34f_op_aq vdd vsrc pch W=2.4e-06 L=5e-07
nthc34f_op_abn thc34f_op_aqb thc34f_op_aq 0 0 nch W=1.2e-06 L=5e-07
rthc34f_op_dr thc34f_op_aq thc34f_op_ad 1e+06
cthc34f_op_dc thc34f_op_ad 0 3.3e-07
nthc34f_op_d2p thc34f_op_adn thc34f_op_ad vdd vsrc pch W=2.4e-06 L=5e-07
nthc34f_op_d2n thc34f_op_adn thc34f_op_ad 0 0 nch W=1.2e-06 L=5e-07
nthc34f_op_gpa thc34f_op_pb thc34f_op_aq vdd vsrc pch W=2.4e-06 L=5e-07
nthc34f_op_gpb thc34f_op_pb thc34f_op_adn vdd vsrc pch W=2.4e-06 L=5e-07
nthc34f_op_gna thc34f_op_pb thc34f_op_aq thc34f_op_gx 0 nch W=2.4e-06 L=5e-07
nthc34f_op_gnb thc34f_op_gx thc34f_op_adn 0 0 nch W=2.4e-06 L=5e-07
nthc34f_op_op thc34f_op_p thc34f_op_pb vdd vsrc pch W=2.4e-06 L=5e-07
nthc34f_op_on thc34f_op_p thc34f_op_pb 0 0 nch W=1.2e-06 L=5e-07
nthc34f_rm_md thc34f_mi thc34f_mi vdd vsrc pch W=4e-06 L=2e-06
va_nthc34f_rm_mo_d thc34f_vm nthc34f_rm_mo_d 0
nthc34f_rm_mo nthc34f_rm_mo_d thc34f_mi vdd vsrc pch W=1e-06 L=8e-06
nthc34r_st_mh thc34r_mi hc4 thc34r_st_x 0 nch W=2e-06 L=4e-06
nthc34r_st_mp thc34r_st_x gc3_op_aq 0 0 nch W=4e-06 L=1e-06
va_cthc34r_cm_p thc34r_vm cthc34r_cm_p 0
cthc34r_cm cthc34r_cm_p 0 1.5e-06
va_rthc34r_rm_p thc34r_vm rthc34r_rm_p 0
rthc34r_rm rthc34r_rm_p vrest 1e+06
rthc34r_kb vdd thc34r_knb 1e+06
nthc34r_kmb thc34r_knb thc34r_knb 0 0 nch W=4e-06 L=4e-06
nthc34r_kmt thc34r_ktail thc34r_knb 0 0 nch W=4e-06 L=4e-06
va_nthc34r_km1_g thc34r_vm nthc34r_km1_g 0
nthc34r_km1 thc34r_kd1 nthc34r_km1_g thc34r_ktail 0 nch W=4e-06 L=4e-06
nthc34r_km2 thc34r_ko1 thc34r_h thc34r_ktail 0 nch W=4e-06 L=4e-06
nthc34r_km3 thc34r_kd1 thc34r_kd1 vdd vsrc pch W=4e-06 L=4e-06
nthc34r_km4 thc34r_ko1 thc34r_kd1 vdd vsrc pch W=4e-06 L=4e-06
nthc34r_ki1p thc34r_qb thc34r_ko1 vdd vsrc pch W=2.4e-06 L=5e-07
nthc34r_ki1n thc34r_qb thc34r_ko1 0 0 nch W=1.2e-06 L=5e-07
nthc34r_ki2p thc34r_q thc34r_qb vdd vsrc pch W=2.4e-06 L=5e-07
nthc34r_ki2n thc34r_q thc34r_qb 0 0 nch W=1.2e-06 L=5e-07
rthc34r_hra thc34r_h vthr 1e+06
rthc34r_hrf thc34r_h thc34r_qb 1.9e+07
cthc34r_hc thc34r_h 0 2.1e-09
va_nthc34r_dis_d thc34r_vm nthc34r_dis_d 0
va_nthc34r_dis_s thc34r_vmd nthc34r_dis_s 0
nthc34r_dis nthc34r_dis_d thc34r_q nthc34r_dis_s 0 nch W=4e-06 L=1e-06
va_rthc34r_rdis_p thc34r_vmd rthc34r_rdis_p 0
rthc34r_rdis rthc34r_rdis_p vrest 12000
nthc34r_rp thc34r_rt thc34r_qb vdd vsrc pch W=2e-06 L=1e-06
rthc34r_rrc thc34r_rt thc34r_rec 10000
cthc34r_rc thc34r_rec 0 1e-07
rthc34r_rr thc34r_rec 0 8.2e+06
va_nthc34r_sh1_d thc34r_vm nthc34r_sh1_d 0
va_nthc34r_sh1_s thc34r_vms nthc34r_sh1_s 0
nthc34r_sh1 nthc34r_sh1_d thc34r_rec nthc34r_sh1_s 0 nch W=2e-06 L=1e-06
va_nthc34r_sh2_d thc34r_vms nthc34r_sh2_d 0
nthc34r_sh2 nthc34r_sh2_d thc34r_qb vrest 0 nch W=2e-06 L=1e-06
nthc34r_porh thc34r_h por_hold vthr 0 nch W=2e-06 L=1e-06
va_nthc34r_porm_d thc34r_vm nthc34r_porm_d 0
nthc34r_porm nthc34r_porm_d por_hold vrest 0 nch W=2e-06 L=1e-06
nthc34r_op_tsw thc34r_op_tt thc34r_qb vdd vsrc pch W=2e-06 L=1e-06
rthc34r_op_trc thc34r_op_tt thc34r_op_at 10000
cthc34r_op_tc thc34r_op_at 0 1e-07
rthc34r_op_trl thc34r_op_at 0 2.2e+07
nthc34r_op_sh1p thc34r_op_an thc34r_op_at vdd vsrc pch W=2.4e-06 L=5e-07
nthc34r_op_sh1n thc34r_op_an thc34r_op_at 0 0 nch W=1.2e-06 L=5e-07
nthc34r_op_sh2p thc34r_op_aq thc34r_op_an vdd vsrc pch W=2.4e-06 L=5e-07
nthc34r_op_sh2n thc34r_op_aq thc34r_op_an 0 0 nch W=1.2e-06 L=5e-07
nthc34r_op_abp thc34r_op_aqb thc34r_op_aq vdd vsrc pch W=2.4e-06 L=5e-07
nthc34r_op_abn thc34r_op_aqb thc34r_op_aq 0 0 nch W=1.2e-06 L=5e-07
rthc34r_op_dr thc34r_op_aq thc34r_op_ad 1e+06
cthc34r_op_dc thc34r_op_ad 0 3.3e-07
nthc34r_op_d2p thc34r_op_adn thc34r_op_ad vdd vsrc pch W=2.4e-06 L=5e-07
nthc34r_op_d2n thc34r_op_adn thc34r_op_ad 0 0 nch W=1.2e-06 L=5e-07
nthc34r_op_gpa thc34r_op_pb thc34r_op_aq vdd vsrc pch W=2.4e-06 L=5e-07
nthc34r_op_gpb thc34r_op_pb thc34r_op_adn vdd vsrc pch W=2.4e-06 L=5e-07
nthc34r_op_gna thc34r_op_pb thc34r_op_aq thc34r_op_gx 0 nch W=2.4e-06 L=5e-07
nthc34r_op_gnb thc34r_op_gx thc34r_op_adn 0 0 nch W=2.4e-06 L=5e-07
nthc34r_op_op thc34r_op_p thc34r_op_pb vdd vsrc pch W=2.4e-06 L=5e-07
nthc34r_op_on thc34r_op_p thc34r_op_pb 0 0 nch W=1.2e-06 L=5e-07
nthc34r_rm_md thc34r_mi thc34r_mi vdd vsrc pch W=4e-06 L=2e-06
va_nthc34r_rm_mo_d thc34r_vm nthc34r_rm_mo_d 0
nthc34r_rm_mo nthc34r_rm_mo_d thc34r_mi vdd vsrc pch W=1e-06 L=8e-06
cspcc1 spc1 0 1e-07
rspcl1 spc1 vmid 1e+06
nspci1_sw spci1_x vdd vdd vsrc pch W=4e-06 L=1e-06
nspci1_cp spc1 irefp_n spci1_x vsrc pch W=2e-06 L=4e-06
cspcc2 spc2 0 1e-07
rspcl2 spc2 vmid 1e+06
nspci2_sw spci2_x vdd vdd vsrc pch W=4e-06 L=1e-06
nspci2_cp spc2 irefp_n spci2_x vsrc pch W=2e-06 L=4e-06
cspcc3 spc3 0 1e-07
rspcl3 spc3 vmid 1e+06
nspci3_sw spci3_x gc3_op_aqb vdd vsrc pch W=4e-06 L=1e-06
nspci3_cp spc3 irefp_n spci3_x vsrc pch W=2e-06 L=4e-06
cspcc4 spc4 0 1e-07
rspcl4 spc4 vmid 1e+06
nspci4_sw spci4_x gc4_op_aqb vdd vsrc pch W=4e-06 L=1e-06
nspci4_cp spc4 irefp_n spci4_x vsrc pch W=2e-06 L=4e-06
rspcrs12 spc1 spcs12 200000
cspccs12 spcs12 0 1e-12
rspcrt12 spcs12 spc2 800000
rspcrs23 spc2 spcs23 200000
cspccs23 spcs23 0 1e-12
rspcrt23 spcs23 spc3 800000
rspcrs34 spc3 spcs34 200000
cspccs34 spcs34 0 1e-12
rspcrt34 spcs34 spc4 800000
va_csgc34f_cm_p sgc34f_vm csgc34f_cm_p 0
csgc34f_cm csgc34f_cm_p 0 1e-07
va_rsgc34f_rm_p sgc34f_vm rsgc34f_rm_p 0
rsgc34f_rm rsgc34f_rm_p vrest 1e+06
rsgc34f_kb vdd sgc34f_knb 1e+06
nsgc34f_kmb sgc34f_knb sgc34f_knb 0 0 nch W=4e-06 L=4e-06
nsgc34f_kmt sgc34f_ktail sgc34f_knb 0 0 nch W=4e-06 L=4e-06
va_nsgc34f_km1_g sgc34f_vm nsgc34f_km1_g 0
nsgc34f_km1 sgc34f_kd1 nsgc34f_km1_g sgc34f_ktail 0 nch W=4e-06 L=4e-06
nsgc34f_km2 sgc34f_ko1 sgc34f_h sgc34f_ktail 0 nch W=4e-06 L=4e-06
nsgc34f_km3 sgc34f_kd1 sgc34f_kd1 vdd vsrc pch W=4e-06 L=4e-06
nsgc34f_km4 sgc34f_ko1 sgc34f_kd1 vdd vsrc pch W=4e-06 L=4e-06
nsgc34f_ki1p sgc34f_qb sgc34f_ko1 vdd vsrc pch W=2.4e-06 L=5e-07
nsgc34f_ki1n sgc34f_qb sgc34f_ko1 0 0 nch W=1.2e-06 L=5e-07
nsgc34f_ki2p sgc34f_q sgc34f_qb vdd vsrc pch W=2.4e-06 L=5e-07
nsgc34f_ki2n sgc34f_q sgc34f_qb 0 0 nch W=1.2e-06 L=5e-07
rsgc34f_hra sgc34f_h vthr 1e+06
rsgc34f_hrf sgc34f_h sgc34f_qb 1.9e+07
csgc34f_hc sgc34f_h 0 2.1e-09
va_nsgc34f_dis_d sgc34f_vm nsgc34f_dis_d 0
va_nsgc34f_dis_s sgc34f_vmd nsgc34f_dis_s 0
nsgc34f_dis nsgc34f_dis_d sgc34f_q nsgc34f_dis_s 0 nch W=4e-06 L=1e-06
va_rsgc34f_rdis_p sgc34f_vmd rsgc34f_rdis_p 0
rsgc34f_rdis rsgc34f_rdis_p vrest 75000
nsgc34f_rp sgc34f_rt sgc34f_qb vdd vsrc pch W=2e-06 L=1e-06
rsgc34f_rrc sgc34f_rt sgc34f_rec 10000
csgc34f_rc sgc34f_rec 0 1e-07
rsgc34f_rr sgc34f_rec 0 8.2e+06
va_nsgc34f_sh1_d sgc34f_vm nsgc34f_sh1_d 0
va_nsgc34f_sh1_s sgc34f_vms nsgc34f_sh1_s 0
nsgc34f_sh1 nsgc34f_sh1_d sgc34f_rec nsgc34f_sh1_s 0 nch W=2e-06 L=1e-06
va_nsgc34f_sh2_d sgc34f_vms nsgc34f_sh2_d 0
nsgc34f_sh2 nsgc34f_sh2_d sgc34f_qb vrest 0 nch W=2e-06 L=1e-06
nsgc34f_porh sgc34f_h por_hold vthr 0 nch W=2e-06 L=1e-06
va_nsgc34f_porm_d sgc34f_vm nsgc34f_porm_d 0
nsgc34f_porm nsgc34f_porm_d por_hold vrest 0 nch W=2e-06 L=1e-06
nsgc34f_op_tsw sgc34f_op_tt sgc34f_qb vdd vsrc pch W=2e-06 L=1e-06
rsgc34f_op_trc sgc34f_op_tt sgc34f_op_at 10000
csgc34f_op_tc sgc34f_op_at 0 1e-07
rsgc34f_op_trl sgc34f_op_at 0 2.2e+07
nsgc34f_op_sh1p sgc34f_op_an sgc34f_op_at vdd vsrc pch W=2.4e-06 L=5e-07
nsgc34f_op_sh1n sgc34f_op_an sgc34f_op_at 0 0 nch W=1.2e-06 L=5e-07
nsgc34f_op_sh2p sgc34f_op_aq sgc34f_op_an vdd vsrc pch W=2.4e-06 L=5e-07
nsgc34f_op_sh2n sgc34f_op_aq sgc34f_op_an 0 0 nch W=1.2e-06 L=5e-07
nsgc34f_op_abp sgc34f_op_aqb sgc34f_op_aq vdd vsrc pch W=2.4e-06 L=5e-07
nsgc34f_op_abn sgc34f_op_aqb sgc34f_op_aq 0 0 nch W=1.2e-06 L=5e-07
rsgc34f_op_dr sgc34f_op_aq sgc34f_op_ad 1e+06
csgc34f_op_dc sgc34f_op_ad 0 3.3e-07
nsgc34f_op_d2p sgc34f_op_adn sgc34f_op_ad vdd vsrc pch W=2.4e-06 L=5e-07
nsgc34f_op_d2n sgc34f_op_adn sgc34f_op_ad 0 0 nch W=1.2e-06 L=5e-07
nsgc34f_op_gpa sgc34f_op_pb sgc34f_op_aq vdd vsrc pch W=2.4e-06 L=5e-07
nsgc34f_op_gpb sgc34f_op_pb sgc34f_op_adn vdd vsrc pch W=2.4e-06 L=5e-07
nsgc34f_op_gna sgc34f_op_pb sgc34f_op_aq sgc34f_op_gx 0 nch W=2.4e-06 L=5e-07
nsgc34f_op_gnb sgc34f_op_gx sgc34f_op_adn 0 0 nch W=2.4e-06 L=5e-07
nsgc34f_op_op sgc34f_op_p sgc34f_op_pb vdd vsrc pch W=2.4e-06 L=5e-07
nsgc34f_op_on sgc34f_op_p sgc34f_op_pb 0 0 nch W=1.2e-06 L=5e-07
rsgc34f_ota_b vdd sgc34f_ota_nb 3.3e+06
nsgc34f_ota_mb sgc34f_ota_nb sgc34f_ota_nb 0 0 nch W=4e-06 L=4e-06
nsgc34f_ota_mt sgc34f_ota_tail sgc34f_ota_nb 0 0 nch W=4e-06 L=4e-06
nsgc34f_ota_m1 sgc34f_ota_d1 spc3 sgc34f_ota_tail 0 nch W=1e-05 L=2e-06
va_nsgc34f_ota_m2_d sgc34f_vm nsgc34f_ota_m2_d 0
nsgc34f_ota_m2 nsgc34f_ota_m2_d spcs34 sgc34f_ota_tail 0 nch W=1e-05 L=2e-06
nsgc34f_ota_m3 sgc34f_ota_d1 sgc34f_ota_d1 vdd vsrc pch W=1e-05 L=2e-06
va_nsgc34f_ota_m4_d sgc34f_vm nsgc34f_ota_m4_d 0
nsgc34f_ota_m4 nsgc34f_ota_m4_d sgc34f_ota_d1 vdd vsrc pch W=1e-05 L=2e-06
va_csgc34r_cm_p sgc34r_vm csgc34r_cm_p 0
csgc34r_cm csgc34r_cm_p 0 1e-07
va_rsgc34r_rm_p sgc34r_vm rsgc34r_rm_p 0
rsgc34r_rm rsgc34r_rm_p vrest 1e+06
rsgc34r_kb vdd sgc34r_knb 1e+06
nsgc34r_kmb sgc34r_knb sgc34r_knb 0 0 nch W=4e-06 L=4e-06
nsgc34r_kmt sgc34r_ktail sgc34r_knb 0 0 nch W=4e-06 L=4e-06
va_nsgc34r_km1_g sgc34r_vm nsgc34r_km1_g 0
nsgc34r_km1 sgc34r_kd1 nsgc34r_km1_g sgc34r_ktail 0 nch W=4e-06 L=4e-06
nsgc34r_km2 sgc34r_ko1 sgc34r_h sgc34r_ktail 0 nch W=4e-06 L=4e-06
nsgc34r_km3 sgc34r_kd1 sgc34r_kd1 vdd vsrc pch W=4e-06 L=4e-06
nsgc34r_km4 sgc34r_ko1 sgc34r_kd1 vdd vsrc pch W=4e-06 L=4e-06
nsgc34r_ki1p sgc34r_qb sgc34r_ko1 vdd vsrc pch W=2.4e-06 L=5e-07
nsgc34r_ki1n sgc34r_qb sgc34r_ko1 0 0 nch W=1.2e-06 L=5e-07
nsgc34r_ki2p sgc34r_q sgc34r_qb vdd vsrc pch W=2.4e-06 L=5e-07
nsgc34r_ki2n sgc34r_q sgc34r_qb 0 0 nch W=1.2e-06 L=5e-07
rsgc34r_hra sgc34r_h vthr 1e+06
rsgc34r_hrf sgc34r_h sgc34r_qb 1.9e+07
csgc34r_hc sgc34r_h 0 2.1e-09
va_nsgc34r_dis_d sgc34r_vm nsgc34r_dis_d 0
va_nsgc34r_dis_s sgc34r_vmd nsgc34r_dis_s 0
nsgc34r_dis nsgc34r_dis_d sgc34r_q nsgc34r_dis_s 0 nch W=4e-06 L=1e-06
va_rsgc34r_rdis_p sgc34r_vmd rsgc34r_rdis_p 0
rsgc34r_rdis rsgc34r_rdis_p vrest 75000
nsgc34r_rp sgc34r_rt sgc34r_qb vdd vsrc pch W=2e-06 L=1e-06
rsgc34r_rrc sgc34r_rt sgc34r_rec 10000
csgc34r_rc sgc34r_rec 0 1e-07
rsgc34r_rr sgc34r_rec 0 8.2e+06
va_nsgc34r_sh1_d sgc34r_vm nsgc34r_sh1_d 0
va_nsgc34r_sh1_s sgc34r_vms nsgc34r_sh1_s 0
nsgc34r_sh1 nsgc34r_sh1_d sgc34r_rec nsgc34r_sh1_s 0 nch W=2e-06 L=1e-06
va_nsgc34r_sh2_d sgc34r_vms nsgc34r_sh2_d 0
nsgc34r_sh2 nsgc34r_sh2_d sgc34r_qb vrest 0 nch W=2e-06 L=1e-06
nsgc34r_porh sgc34r_h por_hold vthr 0 nch W=2e-06 L=1e-06
va_nsgc34r_porm_d sgc34r_vm nsgc34r_porm_d 0
nsgc34r_porm nsgc34r_porm_d por_hold vrest 0 nch W=2e-06 L=1e-06
nsgc34r_op_tsw sgc34r_op_tt sgc34r_qb vdd vsrc pch W=2e-06 L=1e-06
rsgc34r_op_trc sgc34r_op_tt sgc34r_op_at 10000
csgc34r_op_tc sgc34r_op_at 0 1e-07
rsgc34r_op_trl sgc34r_op_at 0 2.2e+07
nsgc34r_op_sh1p sgc34r_op_an sgc34r_op_at vdd vsrc pch W=2.4e-06 L=5e-07
nsgc34r_op_sh1n sgc34r_op_an sgc34r_op_at 0 0 nch W=1.2e-06 L=5e-07
nsgc34r_op_sh2p sgc34r_op_aq sgc34r_op_an vdd vsrc pch W=2.4e-06 L=5e-07
nsgc34r_op_sh2n sgc34r_op_aq sgc34r_op_an 0 0 nch W=1.2e-06 L=5e-07
nsgc34r_op_abp sgc34r_op_aqb sgc34r_op_aq vdd vsrc pch W=2.4e-06 L=5e-07
nsgc34r_op_abn sgc34r_op_aqb sgc34r_op_aq 0 0 nch W=1.2e-06 L=5e-07
rsgc34r_op_dr sgc34r_op_aq sgc34r_op_ad 1e+06
csgc34r_op_dc sgc34r_op_ad 0 3.3e-07
nsgc34r_op_d2p sgc34r_op_adn sgc34r_op_ad vdd vsrc pch W=2.4e-06 L=5e-07
nsgc34r_op_d2n sgc34r_op_adn sgc34r_op_ad 0 0 nch W=1.2e-06 L=5e-07
nsgc34r_op_gpa sgc34r_op_pb sgc34r_op_aq vdd vsrc pch W=2.4e-06 L=5e-07
nsgc34r_op_gpb sgc34r_op_pb sgc34r_op_adn vdd vsrc pch W=2.4e-06 L=5e-07
nsgc34r_op_gna sgc34r_op_pb sgc34r_op_aq sgc34r_op_gx 0 nch W=2.4e-06 L=5e-07
nsgc34r_op_gnb sgc34r_op_gx sgc34r_op_adn 0 0 nch W=2.4e-06 L=5e-07
nsgc34r_op_op sgc34r_op_p sgc34r_op_pb vdd vsrc pch W=2.4e-06 L=5e-07
nsgc34r_op_on sgc34r_op_p sgc34r_op_pb 0 0 nch W=1.2e-06 L=5e-07
rsgc34r_ota_b vdd sgc34r_ota_nb 3.3e+06
nsgc34r_ota_mb sgc34r_ota_nb sgc34r_ota_nb 0 0 nch W=4e-06 L=4e-06
nsgc34r_ota_mt sgc34r_ota_tail sgc34r_ota_nb 0 0 nch W=4e-06 L=4e-06
nsgc34r_ota_m1 sgc34r_ota_d1 spcs34 sgc34r_ota_tail 0 nch W=1e-05 L=2e-06
va_nsgc34r_ota_m2_d sgc34r_vm nsgc34r_ota_m2_d 0
nsgc34r_ota_m2 nsgc34r_ota_m2_d spc3 sgc34r_ota_tail 0 nch W=1e-05 L=2e-06
nsgc34r_ota_m3 sgc34r_ota_d1 sgc34r_ota_d1 vdd vsrc pch W=1e-05 L=2e-06
va_nsgc34r_ota_m4_d sgc34r_vm nsgc34r_ota_m4_d 0
nsgc34r_ota_m4 nsgc34r_ota_m4_d sgc34r_ota_d1 vdd vsrc pch W=1e-05 L=2e-06
ncdc34f_hsf_sw cdc34f_hsf_sd sgc34f_op_aqb vdd vsrc pch W=4e-06 L=5e-07
rcdc34f_hsf_rr cdc34f_hsf_sd cdc34f_hsf_h1 100000
ccdc34f_hsf_c1 cdc34f_hsf_h1 0 1e-06
rcdc34f_hsf_r2 cdc34f_hsf_h1 cdc34f_hs 1e+06
ccdc34f_hsf_c2 cdc34f_hs 0 4.7e-07
rcdc34f_hsf_rl cdc34f_hs 0 4.7e+06
ncdc34f_hcf_sw cdc34f_hcf_sd sgc34r_op_aqb vdd vsrc pch W=4e-06 L=5e-07
rcdc34f_hcf_rr cdc34f_hcf_sd cdc34f_hcf_h1 100000
ccdc34f_hcf_c1 cdc34f_hcf_h1 0 1e-06
rcdc34f_hcf_r2 cdc34f_hcf_h1 cdc34f_hc 1e+06
ccdc34f_hcf_c2 cdc34f_hc 0 4.7e-07
rcdc34f_hcf_rl cdc34f_hc 0 4.7e+06
va_ccdc34f_cm_p cdc34f_vm ccdc34f_cm_p 0
ccdc34f_cm ccdc34f_cm_p 0 1.5e-06
va_rcdc34f_rm_p cdc34f_vm rcdc34f_rm_p 0
rcdc34f_rm rcdc34f_rm_p vrest 1e+06
rcdc34f_kb vdd cdc34f_knb 1e+06
ncdc34f_kmb cdc34f_knb cdc34f_knb 0 0 nch W=4e-06 L=4e-06
ncdc34f_kmt cdc34f_ktail cdc34f_knb 0 0 nch W=4e-06 L=4e-06
va_ncdc34f_km1_g cdc34f_vm ncdc34f_km1_g 0
ncdc34f_km1 cdc34f_kd1 ncdc34f_km1_g cdc34f_ktail 0 nch W=4e-06 L=4e-06
ncdc34f_km2 cdc34f_ko1 cdc34f_h cdc34f_ktail 0 nch W=4e-06 L=4e-06
ncdc34f_km3 cdc34f_kd1 cdc34f_kd1 vdd vsrc pch W=4e-06 L=4e-06
ncdc34f_km4 cdc34f_ko1 cdc34f_kd1 vdd vsrc pch W=4e-06 L=4e-06
ncdc34f_ki1p cdc34f_qb cdc34f_ko1 vdd vsrc pch W=2.4e-06 L=5e-07
ncdc34f_ki1n cdc34f_qb cdc34f_ko1 0 0 nch W=1.2e-06 L=5e-07
ncdc34f_ki2p cdc34f_q cdc34f_qb vdd vsrc pch W=2.4e-06 L=5e-07
ncdc34f_ki2n cdc34f_q cdc34f_qb 0 0 nch W=1.2e-06 L=5e-07
rcdc34f_hra cdc34f_h vthr 1e+06
rcdc34f_hrf cdc34f_h cdc34f_qb 1.9e+07
ccdc34f_hc cdc34f_h 0 2.1e-09
va_ncdc34f_dis_d cdc34f_vm ncdc34f_dis_d 0
va_ncdc34f_dis_s cdc34f_vmd ncdc34f_dis_s 0
ncdc34f_dis ncdc34f_dis_d cdc34f_q ncdc34f_dis_s 0 nch W=4e-06 L=1e-06
va_rcdc34f_rdis_p cdc34f_vmd rcdc34f_rdis_p 0
rcdc34f_rdis rcdc34f_rdis_p vrest 12000
ncdc34f_rp cdc34f_rt cdc34f_qb vdd vsrc pch W=2e-06 L=1e-06
rcdc34f_rrc cdc34f_rt cdc34f_rec 10000
ccdc34f_rc cdc34f_rec 0 1e-07
rcdc34f_rr cdc34f_rec 0 8.2e+06
va_ncdc34f_sh1_d cdc34f_vm ncdc34f_sh1_d 0
va_ncdc34f_sh1_s cdc34f_vms ncdc34f_sh1_s 0
ncdc34f_sh1 ncdc34f_sh1_d cdc34f_rec ncdc34f_sh1_s 0 nch W=2e-06 L=1e-06
va_ncdc34f_sh2_d cdc34f_vms ncdc34f_sh2_d 0
ncdc34f_sh2 ncdc34f_sh2_d cdc34f_qb vrest 0 nch W=2e-06 L=1e-06
ncdc34f_porh cdc34f_h por_hold vthr 0 nch W=2e-06 L=1e-06
va_ncdc34f_porm_d cdc34f_vm ncdc34f_porm_d 0
ncdc34f_porm ncdc34f_porm_d por_hold vrest 0 nch W=2e-06 L=1e-06
ncdc34f_op_tsw cdc34f_op_tt cdc34f_qb vdd vsrc pch W=2e-06 L=1e-06
rcdc34f_op_trc cdc34f_op_tt cdc34f_op_at 10000
ccdc34f_op_tc cdc34f_op_at 0 1e-07
rcdc34f_op_trl cdc34f_op_at 0 2.2e+07
ncdc34f_op_sh1p cdc34f_op_an cdc34f_op_at vdd vsrc pch W=2.4e-06 L=5e-07
ncdc34f_op_sh1n cdc34f_op_an cdc34f_op_at 0 0 nch W=1.2e-06 L=5e-07
ncdc34f_op_sh2p cdc34f_op_aq cdc34f_op_an vdd vsrc pch W=2.4e-06 L=5e-07
ncdc34f_op_sh2n cdc34f_op_aq cdc34f_op_an 0 0 nch W=1.2e-06 L=5e-07
ncdc34f_op_abp cdc34f_op_aqb cdc34f_op_aq vdd vsrc pch W=2.4e-06 L=5e-07
ncdc34f_op_abn cdc34f_op_aqb cdc34f_op_aq 0 0 nch W=1.2e-06 L=5e-07
rcdc34f_op_dr cdc34f_op_aq cdc34f_op_ad 1e+06
ccdc34f_op_dc cdc34f_op_ad 0 3.3e-07
ncdc34f_op_d2p cdc34f_op_adn cdc34f_op_ad vdd vsrc pch W=2.4e-06 L=5e-07
ncdc34f_op_d2n cdc34f_op_adn cdc34f_op_ad 0 0 nch W=1.2e-06 L=5e-07
ncdc34f_op_gpa cdc34f_op_pb cdc34f_op_aq vdd vsrc pch W=2.4e-06 L=5e-07
ncdc34f_op_gpb cdc34f_op_pb cdc34f_op_adn vdd vsrc pch W=2.4e-06 L=5e-07
ncdc34f_op_gna cdc34f_op_pb cdc34f_op_aq cdc34f_op_gx 0 nch W=2.4e-06 L=5e-07
ncdc34f_op_gnb cdc34f_op_gx cdc34f_op_adn 0 0 nch W=2.4e-06 L=5e-07
ncdc34f_op_op cdc34f_op_p cdc34f_op_pb vdd vsrc pch W=2.4e-06 L=5e-07
ncdc34f_op_on cdc34f_op_p cdc34f_op_pb 0 0 nch W=1.2e-06 L=5e-07
ncdc34f_st_mh cdc34f_mi cdc34f_hs cdc34f_st_x 0 nch W=2e-06 L=4e-06
ncdc34f_st_mp cdc34f_st_x thc34f_op_aq 0 0 nch W=4e-06 L=1e-06
ncdc34f_rm_md cdc34f_mi cdc34f_mi vdd vsrc pch W=4e-06 L=2e-06
va_ncdc34f_rm_mo_d cdc34f_vm ncdc34f_rm_mo_d 0
ncdc34f_rm_mo ncdc34f_rm_mo_d cdc34f_mi vdd vsrc pch W=1e-06 L=8e-06
va_ncdc34f_kh_d cdc34f_vm ncdc34f_kh_d 0
ncdc34f_kh ncdc34f_kh_d cdc34f_hc cdc34f_kx 0 nch W=2e-06 L=4e-06
ncdc34f_kp cdc34f_kx thc34f_op_aq vrest 0 nch W=4e-06 L=1e-06
ncdc34r_hsf_sw cdc34r_hsf_sd sgc34r_op_aqb vdd vsrc pch W=4e-06 L=5e-07
rcdc34r_hsf_rr cdc34r_hsf_sd cdc34r_hsf_h1 100000
ccdc34r_hsf_c1 cdc34r_hsf_h1 0 1e-06
rcdc34r_hsf_r2 cdc34r_hsf_h1 cdc34r_hs 1e+06
ccdc34r_hsf_c2 cdc34r_hs 0 4.7e-07
rcdc34r_hsf_rl cdc34r_hs 0 4.7e+06
ncdc34r_hcf_sw cdc34r_hcf_sd sgc34f_op_aqb vdd vsrc pch W=4e-06 L=5e-07
rcdc34r_hcf_rr cdc34r_hcf_sd cdc34r_hcf_h1 100000
ccdc34r_hcf_c1 cdc34r_hcf_h1 0 1e-06
rcdc34r_hcf_r2 cdc34r_hcf_h1 cdc34r_hc 1e+06
ccdc34r_hcf_c2 cdc34r_hc 0 4.7e-07
rcdc34r_hcf_rl cdc34r_hc 0 4.7e+06
va_ccdc34r_cm_p cdc34r_vm ccdc34r_cm_p 0
ccdc34r_cm ccdc34r_cm_p 0 1.5e-06
va_rcdc34r_rm_p cdc34r_vm rcdc34r_rm_p 0
rcdc34r_rm rcdc34r_rm_p vrest 1e+06
rcdc34r_kb vdd cdc34r_knb 1e+06
ncdc34r_kmb cdc34r_knb cdc34r_knb 0 0 nch W=4e-06 L=4e-06
ncdc34r_kmt cdc34r_ktail cdc34r_knb 0 0 nch W=4e-06 L=4e-06
va_ncdc34r_km1_g cdc34r_vm ncdc34r_km1_g 0
ncdc34r_km1 cdc34r_kd1 ncdc34r_km1_g cdc34r_ktail 0 nch W=4e-06 L=4e-06
ncdc34r_km2 cdc34r_ko1 cdc34r_h cdc34r_ktail 0 nch W=4e-06 L=4e-06
ncdc34r_km3 cdc34r_kd1 cdc34r_kd1 vdd vsrc pch W=4e-06 L=4e-06
ncdc34r_km4 cdc34r_ko1 cdc34r_kd1 vdd vsrc pch W=4e-06 L=4e-06
ncdc34r_ki1p cdc34r_qb cdc34r_ko1 vdd vsrc pch W=2.4e-06 L=5e-07
ncdc34r_ki1n cdc34r_qb cdc34r_ko1 0 0 nch W=1.2e-06 L=5e-07
ncdc34r_ki2p cdc34r_q cdc34r_qb vdd vsrc pch W=2.4e-06 L=5e-07
ncdc34r_ki2n cdc34r_q cdc34r_qb 0 0 nch W=1.2e-06 L=5e-07
rcdc34r_hra cdc34r_h vthr 1e+06
rcdc34r_hrf cdc34r_h cdc34r_qb 1.9e+07
ccdc34r_hc cdc34r_h 0 2.1e-09
va_ncdc34r_dis_d cdc34r_vm ncdc34r_dis_d 0
va_ncdc34r_dis_s cdc34r_vmd ncdc34r_dis_s 0
ncdc34r_dis ncdc34r_dis_d cdc34r_q ncdc34r_dis_s 0 nch W=4e-06 L=1e-06
va_rcdc34r_rdis_p cdc34r_vmd rcdc34r_rdis_p 0
rcdc34r_rdis rcdc34r_rdis_p vrest 12000
ncdc34r_rp cdc34r_rt cdc34r_qb vdd vsrc pch W=2e-06 L=1e-06
rcdc34r_rrc cdc34r_rt cdc34r_rec 10000
ccdc34r_rc cdc34r_rec 0 1e-07
rcdc34r_rr cdc34r_rec 0 8.2e+06
va_ncdc34r_sh1_d cdc34r_vm ncdc34r_sh1_d 0
va_ncdc34r_sh1_s cdc34r_vms ncdc34r_sh1_s 0
ncdc34r_sh1 ncdc34r_sh1_d cdc34r_rec ncdc34r_sh1_s 0 nch W=2e-06 L=1e-06
va_ncdc34r_sh2_d cdc34r_vms ncdc34r_sh2_d 0
ncdc34r_sh2 ncdc34r_sh2_d cdc34r_qb vrest 0 nch W=2e-06 L=1e-06
ncdc34r_porh cdc34r_h por_hold vthr 0 nch W=2e-06 L=1e-06
va_ncdc34r_porm_d cdc34r_vm ncdc34r_porm_d 0
ncdc34r_porm ncdc34r_porm_d por_hold vrest 0 nch W=2e-06 L=1e-06
ncdc34r_op_tsw cdc34r_op_tt cdc34r_qb vdd vsrc pch W=2e-06 L=1e-06
rcdc34r_op_trc cdc34r_op_tt cdc34r_op_at 10000
ccdc34r_op_tc cdc34r_op_at 0 1e-07
rcdc34r_op_trl cdc34r_op_at 0 2.2e+07
ncdc34r_op_sh1p cdc34r_op_an cdc34r_op_at vdd vsrc pch W=2.4e-06 L=5e-07
ncdc34r_op_sh1n cdc34r_op_an cdc34r_op_at 0 0 nch W=1.2e-06 L=5e-07
ncdc34r_op_sh2p cdc34r_op_aq cdc34r_op_an vdd vsrc pch W=2.4e-06 L=5e-07
ncdc34r_op_sh2n cdc34r_op_aq cdc34r_op_an 0 0 nch W=1.2e-06 L=5e-07
ncdc34r_op_abp cdc34r_op_aqb cdc34r_op_aq vdd vsrc pch W=2.4e-06 L=5e-07
ncdc34r_op_abn cdc34r_op_aqb cdc34r_op_aq 0 0 nch W=1.2e-06 L=5e-07
rcdc34r_op_dr cdc34r_op_aq cdc34r_op_ad 1e+06
ccdc34r_op_dc cdc34r_op_ad 0 3.3e-07
ncdc34r_op_d2p cdc34r_op_adn cdc34r_op_ad vdd vsrc pch W=2.4e-06 L=5e-07
ncdc34r_op_d2n cdc34r_op_adn cdc34r_op_ad 0 0 nch W=1.2e-06 L=5e-07
ncdc34r_op_gpa cdc34r_op_pb cdc34r_op_aq vdd vsrc pch W=2.4e-06 L=5e-07
ncdc34r_op_gpb cdc34r_op_pb cdc34r_op_adn vdd vsrc pch W=2.4e-06 L=5e-07
ncdc34r_op_gna cdc34r_op_pb cdc34r_op_aq cdc34r_op_gx 0 nch W=2.4e-06 L=5e-07
ncdc34r_op_gnb cdc34r_op_gx cdc34r_op_adn 0 0 nch W=2.4e-06 L=5e-07
ncdc34r_op_op cdc34r_op_p cdc34r_op_pb vdd vsrc pch W=2.4e-06 L=5e-07
ncdc34r_op_on cdc34r_op_p cdc34r_op_pb 0 0 nch W=1.2e-06 L=5e-07
ncdc34r_st_mh cdc34r_mi cdc34r_hs cdc34r_st_x 0 nch W=2e-06 L=4e-06
ncdc34r_st_mp cdc34r_st_x thc34r_op_aq 0 0 nch W=4e-06 L=1e-06
ncdc34r_rm_md cdc34r_mi cdc34r_mi vdd vsrc pch W=4e-06 L=2e-06
va_ncdc34r_rm_mo_d cdc34r_vm ncdc34r_rm_mo_d 0
ncdc34r_rm_mo ncdc34r_rm_mo_d cdc34r_mi vdd vsrc pch W=1e-06 L=8e-06
va_ncdc34r_kh_d cdc34r_vm ncdc34r_kh_d 0
ncdc34r_kh ncdc34r_kh_d cdc34r_hc cdc34r_kx 0 nch W=2e-06 L=4e-06
ncdc34r_kp cdc34r_kx thc34r_op_aq vrest 0 nch W=4e-06 L=1e-06
va_cldpos_p load_pos cldpos_p 0
cldpos cldpos_p vmid 1e-06
va_rldpos_p load_pos rldpos_p 0
rldpos rldpos_p vmid 100000
nagc34f_sw agc34f_x cdc34f_op_aqb vdd vsrc pch W=4e-06 L=1e-06
va_nagc34f_cp_d load_pos nagc34f_cp_d 0
nagc34f_cp nagc34f_cp_d irefp_n agc34f_x vsrc pch W=4e-06 L=4e-06
va_cldneg_p load_neg cldneg_p 0
cldneg cldneg_p vmid 1e-06
va_rldneg_p load_neg rldneg_p 0
rldneg rldneg_p vmid 100000
nagc34r_sw agc34r_x cdc34r_op_aqb vdd vsrc pch W=4e-06 L=1e-06
va_nagc34r_cp_d load_neg nagc34r_cp_d 0
nagc34r_cp nagc34r_cp_d irefp_n agc34r_x vsrc pch W=4e-06 L=4e-06
cpar_agc34f_x agc34f_x 0 5e-14
cpar_agc34r_x agc34r_x 0 5e-14
cpar_cdc34f_h cdc34f_h 0 5e-14
cpar_cdc34f_hc cdc34f_hc 0 5e-14
cpar_cdc34f_hcf_h1 cdc34f_hcf_h1 0 5e-14
cpar_cdc34f_hcf_sd cdc34f_hcf_sd 0 5e-14
cpar_cdc34f_hs cdc34f_hs 0 5e-14
cpar_cdc34f_hsf_h1 cdc34f_hsf_h1 0 5e-14
cpar_cdc34f_hsf_sd cdc34f_hsf_sd 0 5e-14
cpar_cdc34f_kd1 cdc34f_kd1 0 5e-14
cpar_cdc34f_knb cdc34f_knb 0 5e-14
cpar_cdc34f_ko1 cdc34f_ko1 0 5e-14
cpar_cdc34f_ktail cdc34f_ktail 0 5e-14
cpar_cdc34f_kx cdc34f_kx 0 5e-14
cpar_cdc34f_mi cdc34f_mi 0 5e-14
cpar_cdc34f_op_ad cdc34f_op_ad 0 5e-14
cpar_cdc34f_op_adn cdc34f_op_adn 0 5e-14
cpar_cdc34f_op_an cdc34f_op_an 0 5e-14
cpar_cdc34f_op_aq cdc34f_op_aq 0 5e-14
cpar_cdc34f_op_aqb cdc34f_op_aqb 0 5e-14
cpar_cdc34f_op_at cdc34f_op_at 0 5e-14
cpar_cdc34f_op_gx cdc34f_op_gx 0 5e-14
cpar_cdc34f_op_p cdc34f_op_p 0 5e-14
cpar_cdc34f_op_pb cdc34f_op_pb 0 5e-14
cpar_cdc34f_op_tt cdc34f_op_tt 0 5e-14
cpar_cdc34f_q cdc34f_q 0 5e-14
cpar_cdc34f_qb cdc34f_qb 0 5e-14
cpar_cdc34f_rec cdc34f_rec 0 5e-14
cpar_cdc34f_rt cdc34f_rt 0 5e-14
cpar_cdc34f_st_x cdc34f_st_x 0 5e-14
va_cpar_cdc34f_vm_p cdc34f_vm cpar_cdc34f_vm_p 0
cpar_cdc34f_vm cpar_cdc34f_vm_p 0 5e-14
va_cpar_cdc34f_vmd_p cdc34f_vmd cpar_cdc34f_vmd_p 0
cpar_cdc34f_vmd cpar_cdc34f_vmd_p 0 5e-14
va_cpar_cdc34f_vms_p cdc34f_vms cpar_cdc34f_vms_p 0
cpar_cdc34f_vms cpar_cdc34f_vms_p 0 5e-14
cpar_cdc34r_h cdc34r_h 0 5e-14
cpar_cdc34r_hc cdc34r_hc 0 5e-14
cpar_cdc34r_hcf_h1 cdc34r_hcf_h1 0 5e-14
cpar_cdc34r_hcf_sd cdc34r_hcf_sd 0 5e-14
cpar_cdc34r_hs cdc34r_hs 0 5e-14
cpar_cdc34r_hsf_h1 cdc34r_hsf_h1 0 5e-14
cpar_cdc34r_hsf_sd cdc34r_hsf_sd 0 5e-14
cpar_cdc34r_kd1 cdc34r_kd1 0 5e-14
cpar_cdc34r_knb cdc34r_knb 0 5e-14
cpar_cdc34r_ko1 cdc34r_ko1 0 5e-14
cpar_cdc34r_ktail cdc34r_ktail 0 5e-14
cpar_cdc34r_kx cdc34r_kx 0 5e-14
cpar_cdc34r_mi cdc34r_mi 0 5e-14
cpar_cdc34r_op_ad cdc34r_op_ad 0 5e-14
cpar_cdc34r_op_adn cdc34r_op_adn 0 5e-14
cpar_cdc34r_op_an cdc34r_op_an 0 5e-14
cpar_cdc34r_op_aq cdc34r_op_aq 0 5e-14
cpar_cdc34r_op_aqb cdc34r_op_aqb 0 5e-14
cpar_cdc34r_op_at cdc34r_op_at 0 5e-14
cpar_cdc34r_op_gx cdc34r_op_gx 0 5e-14
cpar_cdc34r_op_p cdc34r_op_p 0 5e-14
cpar_cdc34r_op_pb cdc34r_op_pb 0 5e-14
cpar_cdc34r_op_tt cdc34r_op_tt 0 5e-14
cpar_cdc34r_q cdc34r_q 0 5e-14
cpar_cdc34r_qb cdc34r_qb 0 5e-14
cpar_cdc34r_rec cdc34r_rec 0 5e-14
cpar_cdc34r_rt cdc34r_rt 0 5e-14
cpar_cdc34r_st_x cdc34r_st_x 0 5e-14
va_cpar_cdc34r_vm_p cdc34r_vm cpar_cdc34r_vm_p 0
cpar_cdc34r_vm cpar_cdc34r_vm_p 0 5e-14
va_cpar_cdc34r_vmd_p cdc34r_vmd cpar_cdc34r_vmd_p 0
cpar_cdc34r_vmd cpar_cdc34r_vmd_p 0 5e-14
va_cpar_cdc34r_vms_p cdc34r_vms cpar_cdc34r_vms_p 0
cpar_cdc34r_vms cpar_cdc34r_vms_p 0 5e-14
cpar_gc3_and_a0_nb gc3_and_a0_nb 0 5e-14
cpar_gc3_and_a0_nx gc3_and_a0_nx 0 5e-14
cpar_gc3_and_a1_nb gc3_and_a1_nb 0 5e-14
cpar_gc3_and_a1_nx gc3_and_a1_nx 0 5e-14
cpar_gc3_and_a2_nb gc3_and_a2_nb 0 5e-14
cpar_gc3_and_a2_nx gc3_and_a2_nx 0 5e-14
cpar_gc3_and_a3_nb gc3_and_a3_nb 0 5e-14
cpar_gc3_and_a3_nx gc3_and_a3_nx 0 5e-14
cpar_gc3_and_a4_nb gc3_and_a4_nb 0 5e-14
cpar_gc3_and_a4_nx gc3_and_a4_nx 0 5e-14
cpar_gc3_and_a5_nb gc3_and_a5_nb 0 5e-14
cpar_gc3_and_a5_nx gc3_and_a5_nx 0 5e-14
cpar_gc3_and_a6_nb gc3_and_a6_nb 0 5e-14
cpar_gc3_and_a6_nx gc3_and_a6_nx 0 5e-14
cpar_gc3_and_a7_nb gc3_and_a7_nb 0 5e-14
cpar_gc3_and_a7_nx gc3_and_a7_nx 0 5e-14
cpar_gc3_and_a8_nb gc3_and_a8_nb 0 5e-14
cpar_gc3_and_a8_nx gc3_and_a8_nx 0 5e-14
cpar_gc3_and_g0 gc3_and_g0 0 5e-14
cpar_gc3_and_g1 gc3_and_g1 0 5e-14
cpar_gc3_and_g2 gc3_and_g2 0 5e-14
cpar_gc3_and_g3 gc3_and_g3 0 5e-14
cpar_gc3_and_g4 gc3_and_g4 0 5e-14
cpar_gc3_and_g5 gc3_and_g5 0 5e-14
cpar_gc3_and_g6 gc3_and_g6 0 5e-14
cpar_gc3_and_g7 gc3_and_g7 0 5e-14
cpar_gc3_and_g8 gc3_and_g8 0 5e-14
cpar_gc3_b1 gc3_b1 0 5e-14
cpar_gc3_b10 gc3_b10 0 5e-14
cpar_gc3_b10_n gc3_b10_n 0 5e-14
cpar_gc3_b10_q gc3_b10_q 0 5e-14
cpar_gc3_b10_t gc3_b10_t 0 5e-14
cpar_gc3_b1_n gc3_b1_n 0 5e-14
cpar_gc3_b1_q gc3_b1_q 0 5e-14
cpar_gc3_b1_t gc3_b1_t 0 5e-14
cpar_gc3_b2 gc3_b2 0 5e-14
cpar_gc3_b2_n gc3_b2_n 0 5e-14
cpar_gc3_b2_q gc3_b2_q 0 5e-14
cpar_gc3_b2_t gc3_b2_t 0 5e-14
cpar_gc3_b3 gc3_b3 0 5e-14
cpar_gc3_b3_n gc3_b3_n 0 5e-14
cpar_gc3_b3_q gc3_b3_q 0 5e-14
cpar_gc3_b3_t gc3_b3_t 0 5e-14
cpar_gc3_b4 gc3_b4 0 5e-14
cpar_gc3_b4_n gc3_b4_n 0 5e-14
cpar_gc3_b4_q gc3_b4_q 0 5e-14
cpar_gc3_b4_t gc3_b4_t 0 5e-14
cpar_gc3_b5 gc3_b5 0 5e-14
cpar_gc3_b5_n gc3_b5_n 0 5e-14
cpar_gc3_b5_q gc3_b5_q 0 5e-14
cpar_gc3_b5_t gc3_b5_t 0 5e-14
cpar_gc3_b6 gc3_b6 0 5e-14
cpar_gc3_b6_n gc3_b6_n 0 5e-14
cpar_gc3_b6_q gc3_b6_q 0 5e-14
cpar_gc3_b6_t gc3_b6_t 0 5e-14
cpar_gc3_b7 gc3_b7 0 5e-14
cpar_gc3_b7_n gc3_b7_n 0 5e-14
cpar_gc3_b7_q gc3_b7_q 0 5e-14
cpar_gc3_b7_t gc3_b7_t 0 5e-14
cpar_gc3_b8 gc3_b8 0 5e-14
cpar_gc3_b8_n gc3_b8_n 0 5e-14
cpar_gc3_b8_q gc3_b8_q 0 5e-14
cpar_gc3_b8_t gc3_b8_t 0 5e-14
cpar_gc3_b9 gc3_b9 0 5e-14
cpar_gc3_b9_n gc3_b9_n 0 5e-14
cpar_gc3_b9_q gc3_b9_q 0 5e-14
cpar_gc3_b9_t gc3_b9_t 0 5e-14
cpar_gc3_cin_x gc3_cin_x 0 5e-14
cpar_gc3_col_h gc3_col_h 0 5e-14
cpar_gc3_col_kd1 gc3_col_kd1 0 5e-14
cpar_gc3_col_knb gc3_col_knb 0 5e-14
cpar_gc3_col_ko1 gc3_col_ko1 0 5e-14
cpar_gc3_col_ktail gc3_col_ktail 0 5e-14
cpar_gc3_col_q gc3_col_q 0 5e-14
cpar_gc3_col_qb gc3_col_qb 0 5e-14
cpar_gc3_col_rec gc3_col_rec 0 5e-14
cpar_gc3_col_rt gc3_col_rt 0 5e-14
cpar_gc3_col_vm gc3_col_vm 0 5e-14
cpar_gc3_col_vmd gc3_col_vmd 0 5e-14
cpar_gc3_col_vms gc3_col_vms 0 5e-14
cpar_gc3_e10_h gc3_e10_h 0 5e-14
cpar_gc3_e10_kd1 gc3_e10_kd1 0 5e-14
cpar_gc3_e10_knb gc3_e10_knb 0 5e-14
cpar_gc3_e10_ko1 gc3_e10_ko1 0 5e-14
cpar_gc3_e10_ktail gc3_e10_ktail 0 5e-14
cpar_gc3_e10_q gc3_e10_q 0 5e-14
cpar_gc3_e10_qb gc3_e10_qb 0 5e-14
cpar_gc3_e10_rec gc3_e10_rec 0 5e-14
cpar_gc3_e10_rt gc3_e10_rt 0 5e-14
cpar_gc3_e10_vm gc3_e10_vm 0 5e-14
cpar_gc3_e10_vmd gc3_e10_vmd 0 5e-14
cpar_gc3_e10_vms gc3_e10_vms 0 5e-14
cpar_gc3_e1_h gc3_e1_h 0 5e-14
cpar_gc3_e1_kd1 gc3_e1_kd1 0 5e-14
cpar_gc3_e1_knb gc3_e1_knb 0 5e-14
cpar_gc3_e1_ko1 gc3_e1_ko1 0 5e-14
cpar_gc3_e1_ktail gc3_e1_ktail 0 5e-14
cpar_gc3_e1_q gc3_e1_q 0 5e-14
cpar_gc3_e1_qb gc3_e1_qb 0 5e-14
cpar_gc3_e1_rec gc3_e1_rec 0 5e-14
cpar_gc3_e1_rt gc3_e1_rt 0 5e-14
cpar_gc3_e1_vm gc3_e1_vm 0 5e-14
cpar_gc3_e1_vmd gc3_e1_vmd 0 5e-14
cpar_gc3_e1_vms gc3_e1_vms 0 5e-14
cpar_gc3_e2_h gc3_e2_h 0 5e-14
cpar_gc3_e2_kd1 gc3_e2_kd1 0 5e-14
cpar_gc3_e2_knb gc3_e2_knb 0 5e-14
cpar_gc3_e2_ko1 gc3_e2_ko1 0 5e-14
cpar_gc3_e2_ktail gc3_e2_ktail 0 5e-14
cpar_gc3_e2_q gc3_e2_q 0 5e-14
cpar_gc3_e2_qb gc3_e2_qb 0 5e-14
cpar_gc3_e2_rec gc3_e2_rec 0 5e-14
cpar_gc3_e2_rt gc3_e2_rt 0 5e-14
cpar_gc3_e2_vm gc3_e2_vm 0 5e-14
cpar_gc3_e2_vmd gc3_e2_vmd 0 5e-14
cpar_gc3_e2_vms gc3_e2_vms 0 5e-14
cpar_gc3_e3_h gc3_e3_h 0 5e-14
cpar_gc3_e3_kd1 gc3_e3_kd1 0 5e-14
cpar_gc3_e3_knb gc3_e3_knb 0 5e-14
cpar_gc3_e3_ko1 gc3_e3_ko1 0 5e-14
cpar_gc3_e3_ktail gc3_e3_ktail 0 5e-14
cpar_gc3_e3_q gc3_e3_q 0 5e-14
cpar_gc3_e3_qb gc3_e3_qb 0 5e-14
cpar_gc3_e3_rec gc3_e3_rec 0 5e-14
cpar_gc3_e3_rt gc3_e3_rt 0 5e-14
cpar_gc3_e3_vm gc3_e3_vm 0 5e-14
cpar_gc3_e3_vmd gc3_e3_vmd 0 5e-14
cpar_gc3_e3_vms gc3_e3_vms 0 5e-14
cpar_gc3_e4_h gc3_e4_h 0 5e-14
cpar_gc3_e4_kd1 gc3_e4_kd1 0 5e-14
cpar_gc3_e4_knb gc3_e4_knb 0 5e-14
cpar_gc3_e4_ko1 gc3_e4_ko1 0 5e-14
cpar_gc3_e4_ktail gc3_e4_ktail 0 5e-14
cpar_gc3_e4_q gc3_e4_q 0 5e-14
cpar_gc3_e4_qb gc3_e4_qb 0 5e-14
cpar_gc3_e4_rec gc3_e4_rec 0 5e-14
cpar_gc3_e4_rt gc3_e4_rt 0 5e-14
cpar_gc3_e4_vm gc3_e4_vm 0 5e-14
cpar_gc3_e4_vmd gc3_e4_vmd 0 5e-14
cpar_gc3_e4_vms gc3_e4_vms 0 5e-14
cpar_gc3_e5_h gc3_e5_h 0 5e-14
cpar_gc3_e5_kd1 gc3_e5_kd1 0 5e-14
cpar_gc3_e5_knb gc3_e5_knb 0 5e-14
cpar_gc3_e5_ko1 gc3_e5_ko1 0 5e-14
cpar_gc3_e5_ktail gc3_e5_ktail 0 5e-14
cpar_gc3_e5_q gc3_e5_q 0 5e-14
cpar_gc3_e5_qb gc3_e5_qb 0 5e-14
cpar_gc3_e5_rec gc3_e5_rec 0 5e-14
cpar_gc3_e5_rt gc3_e5_rt 0 5e-14
cpar_gc3_e5_vm gc3_e5_vm 0 5e-14
cpar_gc3_e5_vmd gc3_e5_vmd 0 5e-14
cpar_gc3_e5_vms gc3_e5_vms 0 5e-14
cpar_gc3_e6_h gc3_e6_h 0 5e-14
cpar_gc3_e6_kd1 gc3_e6_kd1 0 5e-14
cpar_gc3_e6_knb gc3_e6_knb 0 5e-14
cpar_gc3_e6_ko1 gc3_e6_ko1 0 5e-14
cpar_gc3_e6_ktail gc3_e6_ktail 0 5e-14
cpar_gc3_e6_q gc3_e6_q 0 5e-14
cpar_gc3_e6_qb gc3_e6_qb 0 5e-14
cpar_gc3_e6_rec gc3_e6_rec 0 5e-14
cpar_gc3_e6_rt gc3_e6_rt 0 5e-14
cpar_gc3_e6_vm gc3_e6_vm 0 5e-14
cpar_gc3_e6_vmd gc3_e6_vmd 0 5e-14
cpar_gc3_e6_vms gc3_e6_vms 0 5e-14
cpar_gc3_e7_h gc3_e7_h 0 5e-14
cpar_gc3_e7_kd1 gc3_e7_kd1 0 5e-14
cpar_gc3_e7_knb gc3_e7_knb 0 5e-14
cpar_gc3_e7_ko1 gc3_e7_ko1 0 5e-14
cpar_gc3_e7_ktail gc3_e7_ktail 0 5e-14
cpar_gc3_e7_q gc3_e7_q 0 5e-14
cpar_gc3_e7_qb gc3_e7_qb 0 5e-14
cpar_gc3_e7_rec gc3_e7_rec 0 5e-14
cpar_gc3_e7_rt gc3_e7_rt 0 5e-14
cpar_gc3_e7_vm gc3_e7_vm 0 5e-14
cpar_gc3_e7_vmd gc3_e7_vmd 0 5e-14
cpar_gc3_e7_vms gc3_e7_vms 0 5e-14
cpar_gc3_e8_h gc3_e8_h 0 5e-14
cpar_gc3_e8_kd1 gc3_e8_kd1 0 5e-14
cpar_gc3_e8_knb gc3_e8_knb 0 5e-14
cpar_gc3_e8_ko1 gc3_e8_ko1 0 5e-14
cpar_gc3_e8_ktail gc3_e8_ktail 0 5e-14
cpar_gc3_e8_q gc3_e8_q 0 5e-14
cpar_gc3_e8_qb gc3_e8_qb 0 5e-14
cpar_gc3_e8_rec gc3_e8_rec 0 5e-14
cpar_gc3_e8_rt gc3_e8_rt 0 5e-14
cpar_gc3_e8_vm gc3_e8_vm 0 5e-14
cpar_gc3_e8_vmd gc3_e8_vmd 0 5e-14
cpar_gc3_e8_vms gc3_e8_vms 0 5e-14
cpar_gc3_e9_h gc3_e9_h 0 5e-14
cpar_gc3_e9_kd1 gc3_e9_kd1 0 5e-14
cpar_gc3_e9_knb gc3_e9_knb 0 5e-14
cpar_gc3_e9_ko1 gc3_e9_ko1 0 5e-14
cpar_gc3_e9_ktail gc3_e9_ktail 0 5e-14
cpar_gc3_e9_q gc3_e9_q 0 5e-14
cpar_gc3_e9_qb gc3_e9_qb 0 5e-14
cpar_gc3_e9_rec gc3_e9_rec 0 5e-14
cpar_gc3_e9_rt gc3_e9_rt 0 5e-14
cpar_gc3_e9_vm gc3_e9_vm 0 5e-14
cpar_gc3_e9_vmd gc3_e9_vmd 0 5e-14
cpar_gc3_e9_vms gc3_e9_vms 0 5e-14
cpar_gc3_gb gc3_gb 0 5e-14
cpar_gc3_op_ad gc3_op_ad 0 5e-14
cpar_gc3_op_adn gc3_op_adn 0 5e-14
cpar_gc3_op_an gc3_op_an 0 5e-14
cpar_gc3_op_aq gc3_op_aq 0 5e-14
cpar_gc3_op_aqb gc3_op_aqb 0 5e-14
cpar_gc3_op_at gc3_op_at 0 5e-14
cpar_gc3_op_gx gc3_op_gx 0 5e-14
cpar_gc3_op_p gc3_op_p 0 5e-14
cpar_gc3_op_pb gc3_op_pb 0 5e-14
cpar_gc3_op_tt gc3_op_tt 0 5e-14
cpar_gc4_and_a0_nb gc4_and_a0_nb 0 5e-14
cpar_gc4_and_a0_nx gc4_and_a0_nx 0 5e-14
cpar_gc4_and_a1_nb gc4_and_a1_nb 0 5e-14
cpar_gc4_and_a1_nx gc4_and_a1_nx 0 5e-14
cpar_gc4_and_a2_nb gc4_and_a2_nb 0 5e-14
cpar_gc4_and_a2_nx gc4_and_a2_nx 0 5e-14
cpar_gc4_and_a3_nb gc4_and_a3_nb 0 5e-14
cpar_gc4_and_a3_nx gc4_and_a3_nx 0 5e-14
cpar_gc4_and_a4_nb gc4_and_a4_nb 0 5e-14
cpar_gc4_and_a4_nx gc4_and_a4_nx 0 5e-14
cpar_gc4_and_a5_nb gc4_and_a5_nb 0 5e-14
cpar_gc4_and_a5_nx gc4_and_a5_nx 0 5e-14
cpar_gc4_and_a6_nb gc4_and_a6_nb 0 5e-14
cpar_gc4_and_a6_nx gc4_and_a6_nx 0 5e-14
cpar_gc4_and_a7_nb gc4_and_a7_nb 0 5e-14
cpar_gc4_and_a7_nx gc4_and_a7_nx 0 5e-14
cpar_gc4_and_a8_nb gc4_and_a8_nb 0 5e-14
cpar_gc4_and_a8_nx gc4_and_a8_nx 0 5e-14
cpar_gc4_and_g0 gc4_and_g0 0 5e-14
cpar_gc4_and_g1 gc4_and_g1 0 5e-14
cpar_gc4_and_g2 gc4_and_g2 0 5e-14
cpar_gc4_and_g3 gc4_and_g3 0 5e-14
cpar_gc4_and_g4 gc4_and_g4 0 5e-14
cpar_gc4_and_g5 gc4_and_g5 0 5e-14
cpar_gc4_and_g6 gc4_and_g6 0 5e-14
cpar_gc4_and_g7 gc4_and_g7 0 5e-14
cpar_gc4_and_g8 gc4_and_g8 0 5e-14
cpar_gc4_b1 gc4_b1 0 5e-14
cpar_gc4_b10 gc4_b10 0 5e-14
cpar_gc4_b10_n gc4_b10_n 0 5e-14
cpar_gc4_b10_q gc4_b10_q 0 5e-14
cpar_gc4_b10_t gc4_b10_t 0 5e-14
cpar_gc4_b1_n gc4_b1_n 0 5e-14
cpar_gc4_b1_q gc4_b1_q 0 5e-14
cpar_gc4_b1_t gc4_b1_t 0 5e-14
cpar_gc4_b2 gc4_b2 0 5e-14
cpar_gc4_b2_n gc4_b2_n 0 5e-14
cpar_gc4_b2_q gc4_b2_q 0 5e-14
cpar_gc4_b2_t gc4_b2_t 0 5e-14
cpar_gc4_b3 gc4_b3 0 5e-14
cpar_gc4_b3_n gc4_b3_n 0 5e-14
cpar_gc4_b3_q gc4_b3_q 0 5e-14
cpar_gc4_b3_t gc4_b3_t 0 5e-14
cpar_gc4_b4 gc4_b4 0 5e-14
cpar_gc4_b4_n gc4_b4_n 0 5e-14
cpar_gc4_b4_q gc4_b4_q 0 5e-14
cpar_gc4_b4_t gc4_b4_t 0 5e-14
cpar_gc4_b5 gc4_b5 0 5e-14
cpar_gc4_b5_n gc4_b5_n 0 5e-14
cpar_gc4_b5_q gc4_b5_q 0 5e-14
cpar_gc4_b5_t gc4_b5_t 0 5e-14
cpar_gc4_b6 gc4_b6 0 5e-14
cpar_gc4_b6_n gc4_b6_n 0 5e-14
cpar_gc4_b6_q gc4_b6_q 0 5e-14
cpar_gc4_b6_t gc4_b6_t 0 5e-14
cpar_gc4_b7 gc4_b7 0 5e-14
cpar_gc4_b7_n gc4_b7_n 0 5e-14
cpar_gc4_b7_q gc4_b7_q 0 5e-14
cpar_gc4_b7_t gc4_b7_t 0 5e-14
cpar_gc4_b8 gc4_b8 0 5e-14
cpar_gc4_b8_n gc4_b8_n 0 5e-14
cpar_gc4_b8_q gc4_b8_q 0 5e-14
cpar_gc4_b8_t gc4_b8_t 0 5e-14
cpar_gc4_b9 gc4_b9 0 5e-14
cpar_gc4_b9_n gc4_b9_n 0 5e-14
cpar_gc4_b9_q gc4_b9_q 0 5e-14
cpar_gc4_b9_t gc4_b9_t 0 5e-14
cpar_gc4_cin_x gc4_cin_x 0 5e-14
cpar_gc4_col_h gc4_col_h 0 5e-14
cpar_gc4_col_kd1 gc4_col_kd1 0 5e-14
cpar_gc4_col_knb gc4_col_knb 0 5e-14
cpar_gc4_col_ko1 gc4_col_ko1 0 5e-14
cpar_gc4_col_ktail gc4_col_ktail 0 5e-14
cpar_gc4_col_q gc4_col_q 0 5e-14
cpar_gc4_col_qb gc4_col_qb 0 5e-14
cpar_gc4_col_rec gc4_col_rec 0 5e-14
cpar_gc4_col_rt gc4_col_rt 0 5e-14
cpar_gc4_col_vm gc4_col_vm 0 5e-14
cpar_gc4_col_vmd gc4_col_vmd 0 5e-14
cpar_gc4_col_vms gc4_col_vms 0 5e-14
cpar_gc4_e10_h gc4_e10_h 0 5e-14
cpar_gc4_e10_kd1 gc4_e10_kd1 0 5e-14
cpar_gc4_e10_knb gc4_e10_knb 0 5e-14
cpar_gc4_e10_ko1 gc4_e10_ko1 0 5e-14
cpar_gc4_e10_ktail gc4_e10_ktail 0 5e-14
cpar_gc4_e10_q gc4_e10_q 0 5e-14
cpar_gc4_e10_qb gc4_e10_qb 0 5e-14
cpar_gc4_e10_rec gc4_e10_rec 0 5e-14
cpar_gc4_e10_rt gc4_e10_rt 0 5e-14
cpar_gc4_e10_vm gc4_e10_vm 0 5e-14
cpar_gc4_e10_vmd gc4_e10_vmd 0 5e-14
cpar_gc4_e10_vms gc4_e10_vms 0 5e-14
cpar_gc4_e1_h gc4_e1_h 0 5e-14
cpar_gc4_e1_kd1 gc4_e1_kd1 0 5e-14
cpar_gc4_e1_knb gc4_e1_knb 0 5e-14
cpar_gc4_e1_ko1 gc4_e1_ko1 0 5e-14
cpar_gc4_e1_ktail gc4_e1_ktail 0 5e-14
cpar_gc4_e1_q gc4_e1_q 0 5e-14
cpar_gc4_e1_qb gc4_e1_qb 0 5e-14
cpar_gc4_e1_rec gc4_e1_rec 0 5e-14
cpar_gc4_e1_rt gc4_e1_rt 0 5e-14
cpar_gc4_e1_vm gc4_e1_vm 0 5e-14
cpar_gc4_e1_vmd gc4_e1_vmd 0 5e-14
cpar_gc4_e1_vms gc4_e1_vms 0 5e-14
cpar_gc4_e2_h gc4_e2_h 0 5e-14
cpar_gc4_e2_kd1 gc4_e2_kd1 0 5e-14
cpar_gc4_e2_knb gc4_e2_knb 0 5e-14
cpar_gc4_e2_ko1 gc4_e2_ko1 0 5e-14
cpar_gc4_e2_ktail gc4_e2_ktail 0 5e-14
cpar_gc4_e2_q gc4_e2_q 0 5e-14
cpar_gc4_e2_qb gc4_e2_qb 0 5e-14
cpar_gc4_e2_rec gc4_e2_rec 0 5e-14
cpar_gc4_e2_rt gc4_e2_rt 0 5e-14
cpar_gc4_e2_vm gc4_e2_vm 0 5e-14
cpar_gc4_e2_vmd gc4_e2_vmd 0 5e-14
cpar_gc4_e2_vms gc4_e2_vms 0 5e-14
cpar_gc4_e3_h gc4_e3_h 0 5e-14
cpar_gc4_e3_kd1 gc4_e3_kd1 0 5e-14
cpar_gc4_e3_knb gc4_e3_knb 0 5e-14
cpar_gc4_e3_ko1 gc4_e3_ko1 0 5e-14
cpar_gc4_e3_ktail gc4_e3_ktail 0 5e-14
cpar_gc4_e3_q gc4_e3_q 0 5e-14
cpar_gc4_e3_qb gc4_e3_qb 0 5e-14
cpar_gc4_e3_rec gc4_e3_rec 0 5e-14
cpar_gc4_e3_rt gc4_e3_rt 0 5e-14
cpar_gc4_e3_vm gc4_e3_vm 0 5e-14
cpar_gc4_e3_vmd gc4_e3_vmd 0 5e-14
cpar_gc4_e3_vms gc4_e3_vms 0 5e-14
cpar_gc4_e4_h gc4_e4_h 0 5e-14
cpar_gc4_e4_kd1 gc4_e4_kd1 0 5e-14
cpar_gc4_e4_knb gc4_e4_knb 0 5e-14
cpar_gc4_e4_ko1 gc4_e4_ko1 0 5e-14
cpar_gc4_e4_ktail gc4_e4_ktail 0 5e-14
cpar_gc4_e4_q gc4_e4_q 0 5e-14
cpar_gc4_e4_qb gc4_e4_qb 0 5e-14
cpar_gc4_e4_rec gc4_e4_rec 0 5e-14
cpar_gc4_e4_rt gc4_e4_rt 0 5e-14
cpar_gc4_e4_vm gc4_e4_vm 0 5e-14
cpar_gc4_e4_vmd gc4_e4_vmd 0 5e-14
cpar_gc4_e4_vms gc4_e4_vms 0 5e-14
cpar_gc4_e5_h gc4_e5_h 0 5e-14
cpar_gc4_e5_kd1 gc4_e5_kd1 0 5e-14
cpar_gc4_e5_knb gc4_e5_knb 0 5e-14
cpar_gc4_e5_ko1 gc4_e5_ko1 0 5e-14
cpar_gc4_e5_ktail gc4_e5_ktail 0 5e-14
cpar_gc4_e5_q gc4_e5_q 0 5e-14
cpar_gc4_e5_qb gc4_e5_qb 0 5e-14
cpar_gc4_e5_rec gc4_e5_rec 0 5e-14
cpar_gc4_e5_rt gc4_e5_rt 0 5e-14
cpar_gc4_e5_vm gc4_e5_vm 0 5e-14
cpar_gc4_e5_vmd gc4_e5_vmd 0 5e-14
cpar_gc4_e5_vms gc4_e5_vms 0 5e-14
cpar_gc4_e6_h gc4_e6_h 0 5e-14
cpar_gc4_e6_kd1 gc4_e6_kd1 0 5e-14
cpar_gc4_e6_knb gc4_e6_knb 0 5e-14
cpar_gc4_e6_ko1 gc4_e6_ko1 0 5e-14
cpar_gc4_e6_ktail gc4_e6_ktail 0 5e-14
cpar_gc4_e6_q gc4_e6_q 0 5e-14
cpar_gc4_e6_qb gc4_e6_qb 0 5e-14
cpar_gc4_e6_rec gc4_e6_rec 0 5e-14
cpar_gc4_e6_rt gc4_e6_rt 0 5e-14
cpar_gc4_e6_vm gc4_e6_vm 0 5e-14
cpar_gc4_e6_vmd gc4_e6_vmd 0 5e-14
cpar_gc4_e6_vms gc4_e6_vms 0 5e-14
cpar_gc4_e7_h gc4_e7_h 0 5e-14
cpar_gc4_e7_kd1 gc4_e7_kd1 0 5e-14
cpar_gc4_e7_knb gc4_e7_knb 0 5e-14
cpar_gc4_e7_ko1 gc4_e7_ko1 0 5e-14
cpar_gc4_e7_ktail gc4_e7_ktail 0 5e-14
cpar_gc4_e7_q gc4_e7_q 0 5e-14
cpar_gc4_e7_qb gc4_e7_qb 0 5e-14
cpar_gc4_e7_rec gc4_e7_rec 0 5e-14
cpar_gc4_e7_rt gc4_e7_rt 0 5e-14
cpar_gc4_e7_vm gc4_e7_vm 0 5e-14
cpar_gc4_e7_vmd gc4_e7_vmd 0 5e-14
cpar_gc4_e7_vms gc4_e7_vms 0 5e-14
cpar_gc4_e8_h gc4_e8_h 0 5e-14
cpar_gc4_e8_kd1 gc4_e8_kd1 0 5e-14
cpar_gc4_e8_knb gc4_e8_knb 0 5e-14
cpar_gc4_e8_ko1 gc4_e8_ko1 0 5e-14
cpar_gc4_e8_ktail gc4_e8_ktail 0 5e-14
cpar_gc4_e8_q gc4_e8_q 0 5e-14
cpar_gc4_e8_qb gc4_e8_qb 0 5e-14
cpar_gc4_e8_rec gc4_e8_rec 0 5e-14
cpar_gc4_e8_rt gc4_e8_rt 0 5e-14
cpar_gc4_e8_vm gc4_e8_vm 0 5e-14
cpar_gc4_e8_vmd gc4_e8_vmd 0 5e-14
cpar_gc4_e8_vms gc4_e8_vms 0 5e-14
cpar_gc4_e9_h gc4_e9_h 0 5e-14
cpar_gc4_e9_kd1 gc4_e9_kd1 0 5e-14
cpar_gc4_e9_knb gc4_e9_knb 0 5e-14
cpar_gc4_e9_ko1 gc4_e9_ko1 0 5e-14
cpar_gc4_e9_ktail gc4_e9_ktail 0 5e-14
cpar_gc4_e9_q gc4_e9_q 0 5e-14
cpar_gc4_e9_qb gc4_e9_qb 0 5e-14
cpar_gc4_e9_rec gc4_e9_rec 0 5e-14
cpar_gc4_e9_rt gc4_e9_rt 0 5e-14
cpar_gc4_e9_vm gc4_e9_vm 0 5e-14
cpar_gc4_e9_vmd gc4_e9_vmd 0 5e-14
cpar_gc4_e9_vms gc4_e9_vms 0 5e-14
cpar_gc4_gb gc4_gb 0 5e-14
cpar_gc4_op_ad gc4_op_ad 0 5e-14
cpar_gc4_op_adn gc4_op_adn 0 5e-14
cpar_gc4_op_an gc4_op_an 0 5e-14
cpar_gc4_op_aq gc4_op_aq 0 5e-14
cpar_gc4_op_aqb gc4_op_aqb 0 5e-14
cpar_gc4_op_at gc4_op_at 0 5e-14
cpar_gc4_op_gx gc4_op_gx 0 5e-14
cpar_gc4_op_p gc4_op_p 0 5e-14
cpar_gc4_op_pb gc4_op_pb 0 5e-14
cpar_gc4_op_tt gc4_op_tt 0 5e-14
cpar_hc3 hc3 0 5e-14
cpar_hc4 hc4 0 5e-14
cpar_hsc3_h1 hsc3_h1 0 5e-14
cpar_hsc3_sd hsc3_sd 0 5e-14
cpar_hsc4_h1 hsc4_h1 0 5e-14
cpar_hsc4_sd hsc4_sd 0 5e-14
cpar_ilim_n ilim_n 0 5e-14
cpar_ilimp_n ilimp_n 0 5e-14
cpar_iref_n iref_n 0 5e-14
cpar_irefp_n irefp_n 0 5e-14
cpar_istep_n istep_n 0 5e-14
va_cpar_load_neg_p load_neg cpar_load_neg_p 0
cpar_load_neg cpar_load_neg_p 0 5e-14
va_cpar_load_pos_p load_pos cpar_load_pos_p 0
cpar_load_pos cpar_load_pos_p 0 5e-14
cpar_por_hold por_hold 0 5e-14
cpar_por_ok por_ok 0 5e-14
cpar_porc porc 0 5e-14
cpar_porx porx 0 5e-14
cpar_s1_anb s1_anb 0 5e-14
cpar_s1_atl s1_atl 0 5e-14
cpar_s1_da s1_da 0 5e-14
cpar_s1_db s1_db 0 5e-14
cpar_s1_m s1_m 0 5e-14
cpar_s1_s s1_s 0 5e-14
cpar_s1_tl s1_tl 0 5e-14
cpar_s1_ya s1_ya 0 5e-14
cpar_s1_yb s1_yb 0 5e-14
cpar_s1_za s1_za 0 5e-14
cpar_s1_zb s1_zb 0 5e-14
cpar_s2_anb s2_anb 0 5e-14
cpar_s2_atl s2_atl 0 5e-14
cpar_s2_da s2_da 0 5e-14
cpar_s2_db s2_db 0 5e-14
cpar_s2_m s2_m 0 5e-14
cpar_s2_s s2_s 0 5e-14
cpar_s2_tl s2_tl 0 5e-14
cpar_s2_ya s2_ya 0 5e-14
cpar_s2_yb s2_yb 0 5e-14
cpar_s2_za s2_za 0 5e-14
cpar_s2_zb s2_zb 0 5e-14
cpar_s3_anb s3_anb 0 5e-14
cpar_s3_atl s3_atl 0 5e-14
cpar_s3_da s3_da 0 5e-14
cpar_s3_db s3_db 0 5e-14
cpar_s3_m s3_m 0 5e-14
cpar_s3_s s3_s 0 5e-14
cpar_s3_tl s3_tl 0 5e-14
cpar_s3_ya s3_ya 0 5e-14
cpar_s3_yb s3_yb 0 5e-14
cpar_s3_za s3_za 0 5e-14
cpar_s3_zb s3_zb 0 5e-14
cpar_s4_anb s4_anb 0 5e-14
cpar_s4_atl s4_atl 0 5e-14
cpar_s4_da s4_da 0 5e-14
cpar_s4_db s4_db 0 5e-14
cpar_s4_m s4_m 0 5e-14
cpar_s4_s s4_s 0 5e-14
cpar_s4_tl s4_tl 0 5e-14
cpar_s4_ya s4_ya 0 5e-14
cpar_s4_yb s4_yb 0 5e-14
cpar_s4_za s4_za 0 5e-14
cpar_s4_zb s4_zb 0 5e-14
cpar_sgc34f_h sgc34f_h 0 5e-14
cpar_sgc34f_kd1 sgc34f_kd1 0 5e-14
cpar_sgc34f_knb sgc34f_knb 0 5e-14
cpar_sgc34f_ko1 sgc34f_ko1 0 5e-14
cpar_sgc34f_ktail sgc34f_ktail 0 5e-14
cpar_sgc34f_op_ad sgc34f_op_ad 0 5e-14
cpar_sgc34f_op_adn sgc34f_op_adn 0 5e-14
cpar_sgc34f_op_an sgc34f_op_an 0 5e-14
cpar_sgc34f_op_aq sgc34f_op_aq 0 5e-14
cpar_sgc34f_op_aqb sgc34f_op_aqb 0 5e-14
cpar_sgc34f_op_at sgc34f_op_at 0 5e-14
cpar_sgc34f_op_gx sgc34f_op_gx 0 5e-14
cpar_sgc34f_op_p sgc34f_op_p 0 5e-14
cpar_sgc34f_op_pb sgc34f_op_pb 0 5e-14
cpar_sgc34f_op_tt sgc34f_op_tt 0 5e-14
cpar_sgc34f_ota_d1 sgc34f_ota_d1 0 5e-14
cpar_sgc34f_ota_nb sgc34f_ota_nb 0 5e-14
cpar_sgc34f_ota_tail sgc34f_ota_tail 0 5e-14
cpar_sgc34f_q sgc34f_q 0 5e-14
cpar_sgc34f_qb sgc34f_qb 0 5e-14
cpar_sgc34f_rec sgc34f_rec 0 5e-14
cpar_sgc34f_rt sgc34f_rt 0 5e-14
va_cpar_sgc34f_vm_p sgc34f_vm cpar_sgc34f_vm_p 0
cpar_sgc34f_vm cpar_sgc34f_vm_p 0 5e-14
va_cpar_sgc34f_vmd_p sgc34f_vmd cpar_sgc34f_vmd_p 0
cpar_sgc34f_vmd cpar_sgc34f_vmd_p 0 5e-14
va_cpar_sgc34f_vms_p sgc34f_vms cpar_sgc34f_vms_p 0
cpar_sgc34f_vms cpar_sgc34f_vms_p 0 5e-14
cpar_sgc34r_h sgc34r_h 0 5e-14
cpar_sgc34r_kd1 sgc34r_kd1 0 5e-14
cpar_sgc34r_knb sgc34r_knb 0 5e-14
cpar_sgc34r_ko1 sgc34r_ko1 0 5e-14
cpar_sgc34r_ktail sgc34r_ktail 0 5e-14
cpar_sgc34r_op_ad sgc34r_op_ad 0 5e-14
cpar_sgc34r_op_adn sgc34r_op_adn 0 5e-14
cpar_sgc34r_op_an sgc34r_op_an 0 5e-14
cpar_sgc34r_op_aq sgc34r_op_aq 0 5e-14
cpar_sgc34r_op_aqb sgc34r_op_aqb 0 5e-14
cpar_sgc34r_op_at sgc34r_op_at 0 5e-14
cpar_sgc34r_op_gx sgc34r_op_gx 0 5e-14
cpar_sgc34r_op_p sgc34r_op_p 0 5e-14
cpar_sgc34r_op_pb sgc34r_op_pb 0 5e-14
cpar_sgc34r_op_tt sgc34r_op_tt 0 5e-14
cpar_sgc34r_ota_d1 sgc34r_ota_d1 0 5e-14
cpar_sgc34r_ota_nb sgc34r_ota_nb 0 5e-14
cpar_sgc34r_ota_tail sgc34r_ota_tail 0 5e-14
cpar_sgc34r_q sgc34r_q 0 5e-14
cpar_sgc34r_qb sgc34r_qb 0 5e-14
cpar_sgc34r_rec sgc34r_rec 0 5e-14
cpar_sgc34r_rt sgc34r_rt 0 5e-14
va_cpar_sgc34r_vm_p sgc34r_vm cpar_sgc34r_vm_p 0
cpar_sgc34r_vm cpar_sgc34r_vm_p 0 5e-14
va_cpar_sgc34r_vmd_p sgc34r_vmd cpar_sgc34r_vmd_p 0
cpar_sgc34r_vmd cpar_sgc34r_vmd_p 0 5e-14
va_cpar_sgc34r_vms_p sgc34r_vms cpar_sgc34r_vms_p 0
cpar_sgc34r_vms cpar_sgc34r_vms_p 0 5e-14
cpar_spc1 spc1 0 5e-14
cpar_spc2 spc2 0 5e-14
cpar_spc3 spc3 0 5e-14
cpar_spc4 spc4 0 5e-14
cpar_spci1_x spci1_x 0 5e-14
cpar_spci2_x spci2_x 0 5e-14
cpar_spci3_x spci3_x 0 5e-14
cpar_spci4_x spci4_x 0 5e-14
cpar_spcs12 spcs12 0 5e-14
cpar_spcs23 spcs23 0 5e-14
cpar_spcs34 spcs34 0 5e-14
cpar_thc34f_h thc34f_h 0 5e-14
cpar_thc34f_kd1 thc34f_kd1 0 5e-14
cpar_thc34f_knb thc34f_knb 0 5e-14
cpar_thc34f_ko1 thc34f_ko1 0 5e-14
cpar_thc34f_ktail thc34f_ktail 0 5e-14
cpar_thc34f_mi thc34f_mi 0 5e-14
cpar_thc34f_op_ad thc34f_op_ad 0 5e-14
cpar_thc34f_op_adn thc34f_op_adn 0 5e-14
cpar_thc34f_op_an thc34f_op_an 0 5e-14
cpar_thc34f_op_aq thc34f_op_aq 0 5e-14
cpar_thc34f_op_aqb thc34f_op_aqb 0 5e-14
cpar_thc34f_op_at thc34f_op_at 0 5e-14
cpar_thc34f_op_gx thc34f_op_gx 0 5e-14
cpar_thc34f_op_p thc34f_op_p 0 5e-14
cpar_thc34f_op_pb thc34f_op_pb 0 5e-14
cpar_thc34f_op_tt thc34f_op_tt 0 5e-14
cpar_thc34f_q thc34f_q 0 5e-14
cpar_thc34f_qb thc34f_qb 0 5e-14
cpar_thc34f_rec thc34f_rec 0 5e-14
cpar_thc34f_rt thc34f_rt 0 5e-14
cpar_thc34f_st_x thc34f_st_x 0 5e-14
va_cpar_thc34f_vm_p thc34f_vm cpar_thc34f_vm_p 0
cpar_thc34f_vm cpar_thc34f_vm_p 0 5e-14
va_cpar_thc34f_vmd_p thc34f_vmd cpar_thc34f_vmd_p 0
cpar_thc34f_vmd cpar_thc34f_vmd_p 0 5e-14
va_cpar_thc34f_vms_p thc34f_vms cpar_thc34f_vms_p 0
cpar_thc34f_vms cpar_thc34f_vms_p 0 5e-14
cpar_thc34r_h thc34r_h 0 5e-14
cpar_thc34r_kd1 thc34r_kd1 0 5e-14
cpar_thc34r_knb thc34r_knb 0 5e-14
cpar_thc34r_ko1 thc34r_ko1 0 5e-14
cpar_thc34r_ktail thc34r_ktail 0 5e-14
cpar_thc34r_mi thc34r_mi 0 5e-14
cpar_thc34r_op_ad thc34r_op_ad 0 5e-14
cpar_thc34r_op_adn thc34r_op_adn 0 5e-14
cpar_thc34r_op_an thc34r_op_an 0 5e-14
cpar_thc34r_op_aq thc34r_op_aq 0 5e-14
cpar_thc34r_op_aqb thc34r_op_aqb 0 5e-14
cpar_thc34r_op_at thc34r_op_at 0 5e-14
cpar_thc34r_op_gx thc34r_op_gx 0 5e-14
cpar_thc34r_op_p thc34r_op_p 0 5e-14
cpar_thc34r_op_pb thc34r_op_pb 0 5e-14
cpar_thc34r_op_tt thc34r_op_tt 0 5e-14
cpar_thc34r_q thc34r_q 0 5e-14
cpar_thc34r_qb thc34r_qb 0 5e-14
cpar_thc34r_rec thc34r_rec 0 5e-14
cpar_thc34r_rt thc34r_rt 0 5e-14
cpar_thc34r_st_x thc34r_st_x 0 5e-14
va_cpar_thc34r_vm_p thc34r_vm cpar_thc34r_vm_p 0
cpar_thc34r_vm cpar_thc34r_vm_p 0 5e-14
va_cpar_thc34r_vmd_p thc34r_vmd cpar_thc34r_vmd_p 0
cpar_thc34r_vmd cpar_thc34r_vmd_p 0 5e-14
va_cpar_thc34r_vms_p thc34r_vms cpar_thc34r_vms_p 0
cpar_thc34r_vms cpar_thc34r_vms_p 0 5e-14
cpar_vdd vdd 0 5e-14
cpar_vmid vmid 0 5e-14
cpar_vrest vrest 0 5e-14
cpar_vthe vthe 0 5e-14
cpar_vthr vthr 0 5e-14
.options sparse method=gear reltol=1e-5 abstol=1e-16
.save v(vdd) v(vrest) v(vmid) v(load_pos) v(load_neg) v(gc3_col_q) v(gc3_op_aq) v(gc3_op_p) v(hc3) v(gc4_col_q) v(gc4_op_aq) v(gc4_op_p) v(hc4) v(thc34f_vm) v(thc34f_q) v(thc34f_qb) v(thc34f_h) v(thc34f_rec) v(thc34f_vmd) v(thc34f_op_at) v(thc34f_op_aq) v(thc34f_op_p) v(sgc34f_vm) v(sgc34f_q) v(sgc34f_qb) v(sgc34f_h) v(sgc34f_rec) v(sgc34f_vmd) v(sgc34f_op_at) v(sgc34f_op_aq) v(sgc34f_op_p) v(cdc34f_vm) v(cdc34f_q) v(cdc34f_qb) v(cdc34f_h) v(cdc34f_rec) v(cdc34f_vmd) v(cdc34f_op_at) v(cdc34f_op_aq) v(cdc34f_op_p) v(cdc34f_hs) v(cdc34f_hc) v(thc34r_vm) v(thc34r_q) v(thc34r_qb) v(thc34r_h) v(thc34r_rec) v(thc34r_vmd) v(thc34r_op_at) v(thc34r_op_aq) v(thc34r_op_p) v(sgc34r_vm) v(sgc34r_q) v(sgc34r_qb) v(sgc34r_h) v(sgc34r_rec) v(sgc34r_vmd) v(sgc34r_op_at) v(sgc34r_op_aq) v(sgc34r_op_p) v(cdc34r_vm) v(cdc34r_q) v(cdc34r_qb) v(cdc34r_h) v(cdc34r_rec) v(cdc34r_vmd) v(cdc34r_op_at) v(cdc34r_op_aq) v(cdc34r_op_p) v(cdc34r_hs) v(cdc34r_hc) v(spc3) v(spc4) v(spcs34) v(thc34f_vms) v(thc34r_vms) v(sgc34f_vms) v(sgc34r_vms) v(cdc34f_vms) v(cdc34r_vms) i(va_cthc34f_cm_p) i(va_rthc34f_rm_p) i(va_nthc34f_km1_g) i(va_nthc34f_dis_d) i(va_nthc34f_sh1_d) i(va_nthc34f_porm_d) i(va_nthc34f_rm_mo_d) i(va_cpar_thc34f_vm_p) i(va_nthc34f_dis_s) i(va_rthc34f_rdis_p) i(va_cpar_thc34f_vmd_p) i(va_nthc34f_sh1_s) i(va_nthc34f_sh2_d) i(va_cpar_thc34f_vms_p) i(va_cthc34r_cm_p) i(va_rthc34r_rm_p) i(va_nthc34r_km1_g) i(va_nthc34r_dis_d) i(va_nthc34r_sh1_d) i(va_nthc34r_porm_d) i(va_nthc34r_rm_mo_d) i(va_cpar_thc34r_vm_p) i(va_nthc34r_dis_s) i(va_rthc34r_rdis_p) i(va_cpar_thc34r_vmd_p) i(va_nthc34r_sh1_s) i(va_nthc34r_sh2_d) i(va_cpar_thc34r_vms_p) i(va_csgc34f_cm_p) i(va_rsgc34f_rm_p) i(va_nsgc34f_km1_g) i(va_nsgc34f_dis_d) i(va_nsgc34f_sh1_d) i(va_nsgc34f_porm_d) i(va_nsgc34f_ota_m2_d) i(va_nsgc34f_ota_m4_d) i(va_cpar_sgc34f_vm_p) i(va_nsgc34f_dis_s) i(va_rsgc34f_rdis_p) i(va_cpar_sgc34f_vmd_p) i(va_nsgc34f_sh1_s) i(va_nsgc34f_sh2_d) i(va_cpar_sgc34f_vms_p) i(va_csgc34r_cm_p) i(va_rsgc34r_rm_p) i(va_nsgc34r_km1_g) i(va_nsgc34r_dis_d) i(va_nsgc34r_sh1_d) i(va_nsgc34r_porm_d) i(va_nsgc34r_ota_m2_d) i(va_nsgc34r_ota_m4_d) i(va_cpar_sgc34r_vm_p) i(va_nsgc34r_dis_s) i(va_rsgc34r_rdis_p) i(va_cpar_sgc34r_vmd_p) i(va_nsgc34r_sh1_s) i(va_nsgc34r_sh2_d) i(va_cpar_sgc34r_vms_p) i(va_ccdc34f_cm_p) i(va_rcdc34f_rm_p) i(va_ncdc34f_km1_g) i(va_ncdc34f_dis_d) i(va_ncdc34f_sh1_d) i(va_ncdc34f_porm_d) i(va_ncdc34f_rm_mo_d) i(va_ncdc34f_kh_d) i(va_cpar_cdc34f_vm_p) i(va_ncdc34f_dis_s) i(va_rcdc34f_rdis_p) i(va_cpar_cdc34f_vmd_p) i(va_ncdc34f_sh1_s) i(va_ncdc34f_sh2_d) i(va_cpar_cdc34f_vms_p) i(va_ccdc34r_cm_p) i(va_rcdc34r_rm_p) i(va_ncdc34r_km1_g) i(va_ncdc34r_dis_d) i(va_ncdc34r_sh1_d) i(va_ncdc34r_porm_d) i(va_ncdc34r_rm_mo_d) i(va_ncdc34r_kh_d) i(va_cpar_cdc34r_vm_p) i(va_ncdc34r_dis_s) i(va_rcdc34r_rdis_p) i(va_cpar_cdc34r_vmd_p) i(va_ncdc34r_sh1_s) i(va_ncdc34r_sh2_d) i(va_cpar_cdc34r_vms_p) i(va_cldpos_p) i(va_rldpos_p) i(va_nagc34f_cp_d) i(va_cpar_load_pos_p) i(va_cldneg_p) i(va_rldneg_p) i(va_nagc34r_cp_d) i(va_cpar_load_neg_p) v(vsrc) i(vsrc)
.control
pre_osdi /workspace/thermal-g3-env/host/native/models/ekv26_linux.osdi
set filetype=binary
tran 0.001 39.2 0 0.000125
write /workspace/thermal-g3-formal/formal-sparse125us-2026-10-22-40458034/runs/CHAIN_34_C_F/CHAIN_34_C_F.raw
quit
.endc
.end
